** sch_path: /foss/designs/CHIP-PLL/PFD/PFD_tb.sch
**.subckt PFD_tb
x1 0 net1 CRef UP DOWN CVco PFD_cell
*connector(1,1) ?1 DOWN
*connector(1,1) ?1 UP
Vref CRef 0 dc 0 ac 0 pulse(0 1.2 0 10n 10n {T/2} {T})
Vco CVco 0 dc 0 ac 0 pulse(0 1.2 {dly} 10n 10n {T/2} {T})
Vp net1 0 dc 1.2
**** begin user architecture code
 .lib cornerMOSlv.lib mos_tt

.param temp=27
.param T = 31.25u
.param dly=1u
.control
save all
tran 25n 400u
meas tran pw_up trig v(UP) val=0.6 rise=2 targ v(UP) val=0.6 fall=2 from=100u to=400u
meas tran pw_down trig v(DOWN) val=0.6 rise=2 targ v(DOWN) val=0.6 fall=2 from=100u to=400u
write PFD_tb.raw
.endc

**** end user architecture code
**.ends

* expanding   symbol:  PFD_cell.sym # of pins=6
** sym_path: /foss/designs/CHIP-PLL/PFD/PFD_cell.sym
** sch_path: /foss/designs/CHIP-PLL/PFD/PFD_cell.sch
.subckt PFD_cell gnd vp cRef UP DOWN cVco
*.iopin gnd
*.iopin vp
*.iopin DOWN
*.iopin UP
*.ipin cRef
*.ipin cVco
XM1 1 cVco 2 gnd sg13_lv_nmos w=0.5u l=0.13u ng=1
XM2 1 DOWN 2 gnd sg13_lv_nmos w=0.5u l=0.13u ng=1
XM3 2 cRef gnd gnd sg13_lv_nmos w=0.5u l=0.13u ng=1
XM4 1 cRef vp vp sg13_lv_pmos w=0.5u l=0.13u ng=1
XM6 3 cRef 4 gnd sg13_lv_nmos w=0.5u l=0.13u ng=1
XM7 3 UP 4 gnd sg13_lv_nmos w=0.5u l=0.13u ng=1
XM8 4 cVco gnd gnd sg13_lv_nmos w=0.5u l=0.13u ng=1
XM9 3 cVco vp vp sg13_lv_pmos w=0.5u l=0.13u ng=1
x1 gnd vp UP pre_up PFD_buffor
x2 gnd vp DOWN pre_down PFD_buffor
XM5 1 cRef pre_up vp sg13_lv_nmos w=0.5u l=0.13u ng=1
XM10 3 cVco pre_down vp sg13_lv_nmos w=0.5u l=0.13u ng=1
.ends

* expanding   symbol:  PFD_buffor.sym # of pins=4
** sym_path: /foss/designs/CHIP-PLL/PFD/PFD_buffor.sym
** sch_path: /foss/designs/CHIP-PLL/PFD/PFD_buffor.sch
.subckt PFD_buffor gnd vp out in
*.iopin gnd
*.iopin vp
*.ipin in
*.iopin out
XM1 out_stage1 in gnd gnd sg13_lv_nmos w=0.8u l=0.13u ng=1
XM4 out_stage1 in vp vp sg13_lv_pmos w=0.7u l=0.13u ng=1
XM2 out out_stage1 gnd gnd sg13_lv_nmos w=0.8u l=0.13u ng=1
XM3 out out_stage1 vp vp sg13_lv_pmos w=0.9u l=0.13u ng=1
.ends

.end
