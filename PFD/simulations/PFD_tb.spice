** sch_path: /foss/designs/CHIP-PLL/PFD/PFD_tb.sch
**.subckt PFD_tb
Vref CRef 0 dc 0 ac 0 pulse(0 {Vp} {T/2} 10n 10n {T/2} {T})
Vco CVco 0 dc 0 ac 0 pulse(1u {Vp} {dly} 10n 10n {T/2} {T})
Vp net1 0 dc {Vp}
C1 UP 0 5p
C2 DOWN 0 5p
x1 0 net1 CRef UP DOWN CVco PFD_cell
**** begin user architecture code
 .lib cornerMOSlv.lib mos_ff

.temp=125
.param T = 31.25u
.param dly=1u
.param Vp=1.2
.control
save all
tran 25n 400u

meas tran pw_up avg v(UP) from=100u to=400u
meas tran pw_down avg v(DOWN) from=100u to=400u
plot v(pw_up) v(pw_down)
write PFD_tb.raw
.endc

**** end user architecture code
**.ends

* expanding   symbol:  PFD_cell.sym # of pins=6
** sym_path: /foss/designs/CHIP-PLL/PFD/PFD_cell.sym
** sch_path: /foss/designs/CHIP-PLL/PFD/PFD_cell.sch
.subckt PFD_cell gnd vp cRef UP DOWN cVco
*.iopin gnd
*.iopin vp
*.iopin DOWN
*.iopin UP
*.ipin cRef
*.ipin cVco
XM1 1 cVco 2 gnd sg13_lv_nmos w=0.3u l=0.15u ng=1
XM2 1 DOWN 2 gnd sg13_lv_nmos w=0.3u l=0.15u ng=1
XM3 2 cRef gnd gnd sg13_lv_nmos w=0.3u l=0.15u ng=1
XM6 3 cRef 4 gnd sg13_lv_nmos w=0.3u l=0.15u ng=1
XM7 3 UP 4 gnd sg13_lv_nmos w=0.3u l=0.15u ng=1
XM8 4 cVco gnd gnd sg13_lv_nmos w=0.3u l=0.15u ng=1
x1 gnd vp UP pre_up PFD_buffor
x2 gnd vp DOWN pre_down PFD_buffor
x5 Cref_n vp vp 1 gnd cRef PFD_passgate
x6 cRef vp 1 pre_up gnd Cref_n PFD_passgate
x7 cVco_n vp vp 3 gnd cVco PFD_passgate
x8 cVco vp 3 pre_down gnd cVco_n PFD_passgate
x9 cRef Cref_n vp gnd inverter_x4
x3 cVco cVco_n vp gnd inverter_x4
.ends

* expanding   symbol:  PFD_buffor.sym # of pins=4
** sym_path: /foss/designs/CHIP-PLL/PFD/PFD_buffor.sym
** sch_path: /foss/designs/CHIP-PLL/PFD/PFD_buffor.sch
.subckt PFD_buffor gnd vp out in
*.iopin gnd
*.iopin vp
*.ipin in
*.iopin out
XM1 out_stage1 in gnd gnd sg13_lv_nmos w=0.3u l=0.15u ng=1
XM4 out_stage1 in vp vp sg13_lv_pmos w=0.3u l=0.15u ng=1
XM2 out_stage2 out_stage1 gnd gnd sg13_lv_nmos w=0.6u l=0.15u ng=1
XM3 out_stage2 out_stage1 vp vp sg13_lv_pmos w=0.6u l=0.15u ng=1
XM5 out_stage3 out_stage2 gnd gnd sg13_lv_nmos w=0.9u l=0.15u ng=1
XM6 out_stage3 out_stage2 vp vp sg13_lv_pmos w=0.9u l=0.15u ng=1
XM7 out out_stage3 gnd gnd sg13_lv_nmos w=1.2u l=0.15u ng=1
XM8 out out_stage3 vp vp sg13_lv_pmos w=1.2u l=0.15u ng=1
.ends

* expanding   symbol:  PFD_passgate.sym # of pins=6
** sym_path: /foss/designs/CHIP-PLL/PFD/PFD_passgate.sym
** sch_path: /foss/designs/CHIP-PLL/PFD/PFD_passgate.sch
.subckt PFD_passgate in_n vp A B gnd in_p
*.ipin in_n
*.ipin in_p
*.iopin vp
*.iopin gnd
*.iopin B
*.iopin A
XM4 B in_p A vp sg13_lv_pmos w=0.3u l=0.15u ng=1
XM5 B in_n A gnd sg13_lv_nmos w=0.15u l=0.15u ng=1
.ends

* expanding   symbol:  /foss/designs/CHIP-PLL/divider/inverter_x4.sym # of pins=4
** sym_path: /foss/designs/CHIP-PLL/divider/inverter_x4.sym
** sch_path: /foss/designs/CHIP-PLL/divider/inverter_x4.sch
.subckt inverter_x4 IN OUT VP GND
*.ipin IN
*.iopin VP
*.opin OUT
*.iopin GND
XM1 OUT IN GND GND sg13_lv_nmos w=0.60u l=0.13u ng=1
XM2 OUT IN VP VP sg13_lv_pmos w=0.60u l=0.13u ng=1
.ends

.end
