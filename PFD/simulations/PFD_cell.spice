** sch_path: /foss/designs/CHIP-PLL/PFD/PFD_cell.sch
**.subckt PFD_cell gnd vp cRef UP DOWN cVco
*.iopin gnd
*.iopin vp
*.iopin DOWN
*.iopin UP
*.ipin cRef
*.ipin cVco
XM1 1 cVco 2 gnd sg13_lv_nmos w=0.6u l=0.15u ng=1
XM2 1 DOWN 2 gnd sg13_lv_nmos w=0.6u l=0.15u ng=1
XM3 2 cRef gnd gnd sg13_lv_nmos w=0.3u l=0.15u ng=1
XM4 1 cRef vp vp sg13_lv_pmos w=0.3u l=0.15u ng=1
XM6 3 cRef 4 gnd sg13_lv_nmos w=0.6u l=0.15u ng=1
XM7 3 UP 4 gnd sg13_lv_nmos w=0.6u l=0.15u ng=1
XM8 4 cVco gnd gnd sg13_lv_nmos w=0.3u l=0.15u ng=1
XM9 3 cVco vp vp sg13_lv_pmos w=0.3u l=0.15u ng=1
x1 gnd vp UP pre_up PFD_buffor
x2 gnd vp DOWN pre_down PFD_buffor
XM5 1 cRef pre_up gnd sg13_lv_nmos w=0.3u l=0.15u ng=1
XM10 3 cVco pre_down gnd sg13_lv_nmos w=0.3u l=0.15u ng=1
**.ends

* expanding   symbol:  PFD_buffor.sym # of pins=4
** sym_path: /foss/designs/CHIP-PLL/PFD/PFD_buffor.sym
** sch_path: /foss/designs/CHIP-PLL/PFD/PFD_buffor.sch
.subckt PFD_buffor gnd vp out in
*.iopin gnd
*.iopin vp
*.ipin in
*.iopin out
XM1 out_stage1 in gnd gnd sg13_lv_nmos w=0.6u l=0.15u ng=1
XM4 out_stage1 in vp vp sg13_lv_pmos w=0.6u l=0.15u ng=1
XM2 out out_stage1 gnd gnd sg13_lv_nmos w=1u l=0.15u ng=1
XM3 out out_stage1 vp vp sg13_lv_pmos w=1u l=0.15u ng=1
.ends

.end
