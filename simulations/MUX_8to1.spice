** sch_path: /foss/designs/CHIP-PLL/schematics/divider/schematics/MUX_8to1.sch
**.subckt MUX_8to1 gd vp A0 out in1 in2 in3 in4 in5 in6 in7 A1 in8 A2
*.iopin gd
*.iopin vp
*.opin out
*.ipin in1
*.ipin in2
*.ipin in3
*.ipin in4
*.ipin in5
*.ipin in6
*.ipin in7
*.ipin in8
*.ipin A0
*.ipin A1
*.ipin A2
x9 A0 net1 vp gd inverter
x10 A1 net2 vp gd inverter
x11 A2 net3 vp gd inverter
x28 out_unb out vp gd inverter
x29 in4 net8 vp gd inverter
x30 in8 net4 vp gd inverter
x31 in7 net5 vp gd inverter
x32 in6 net6 vp gd inverter
x33 in5 net7 vp gd inverter
x34 in1 net11 vp gd inverter
x35 in2 net10 vp gd inverter
x36 in3 net9 vp gd inverter
x1 en8_ vp gd en8 net4 out_unb passgate
x2 en7_ vp gd en7 net5 out_unb passgate
x3 en6_ vp gd en6 net6 out_unb passgate
x4 en5_ vp gd en5 net7 out_unb passgate
x5 en4_ vp gd en4 net8 out_unb passgate
x6 en3_ vp gd en3 net9 out_unb passgate
x7 en2_ vp gd en2 net10 out_unb passgate
x8 en1_ vp gd en1 net11 out_unb passgate
x13 en8_ en8 vp gd inverter
x15 en7_ en7 vp gd inverter
x17 en6_ en6 vp gd inverter
x19 en5_ en5 vp gd inverter
x21 en4_ en4 vp gd inverter
x23 en3_ en3 vp gd inverter
x25 en2_ en2 vp gd inverter
x27 en1_ en1 vp gd inverter
x12 vp gd net3 en8_ net2 net1 NAND_3in
x14 vp gd net2 en7_ net3 A0 NAND_3in
x16 vp gd net1 en6_ net3 A1 NAND_3in
x18 vp gd net3 en5_ A1 A0 NAND_3in
x20 vp gd net1 en4_ net2 A2 NAND_3in
x22 vp gd net2 en3_ A2 A0 NAND_3in
x24 vp gd net1 en2_ A2 A1 NAND_3in
x26 vp gd A2 en1_ A1 A0 NAND_3in
**.ends

* expanding   symbol:  CHIP-PLL/schematics/divider/schematics/inverter.sym # of pins=4
** sym_path: /foss/designs/CHIP-PLL/schematics/divider/schematics/inverter.sym
** sch_path: /foss/designs/CHIP-PLL/schematics/divider/schematics/inverter.sch
.subckt inverter IN OUT VP GND
*.ipin IN
*.iopin VP
*.opin OUT
*.iopin GND
XM1 OUT IN GND GND sg13_lv_nmos w=0.15u l=0.13u ng=1 m=1 mm_ok=1
XM2 OUT IN VP VP sg13_lv_pmos w=0.15u l=0.13u ng=1 m=1 mm_ok=1
.ends

* expanding   symbol:  CHIP-PLL/schematics/divider/schematics/passgate.sym # of pins=6
** sym_path: /foss/designs/CHIP-PLL/schematics/divider/schematics/passgate.sym
** sch_path: /foss/designs/CHIP-PLL/schematics/divider/schematics/passgate.sch
.subckt passgate en_ VP GND en IO OI
*.iopin OI
*.iopin IO
*.iopin VP
*.iopin GND
*.ipin en_
*.ipin en
XM1 IO en OI GND sg13_lv_nmos w=0.15u l=0.13u ng=1 m=1 mm_ok=1
XM2 IO en_ OI VP sg13_lv_pmos w=0.15u l=0.13u ng=1 m=1 mm_ok=1
.ends

* expanding   symbol:  CHIP-PLL/schematics/divider/schematics/NAND_3in.sym # of pins=6
** sym_path: /foss/designs/CHIP-PLL/schematics/divider/schematics/NAND_3in.sym
** sch_path: /foss/designs/CHIP-PLL/schematics/divider/schematics/NAND_3in.sch
.subckt NAND_3in VP GND a y b c
*.opin y
*.iopin GND
*.ipin a
*.iopin VP
*.ipin b
*.ipin c
XM1 y a net2 GND sg13_lv_nmos w=0.15u l=0.13u ng=1 m=1 mm_ok=1
XM3 net2 b net1 GND sg13_lv_nmos w=0.15u l=0.13u ng=1 m=1 mm_ok=1
XM4 net1 c GND GND sg13_lv_nmos w=0.15u l=0.13u ng=1 m=1 mm_ok=1
XM7 y c VP VP sg13_lv_pmos w=0.15u l=0.13u ng=1 m=1 mm_ok=1
XM2 y a VP VP sg13_lv_pmos w=0.15u l=0.13u ng=1 m=1 mm_ok=1
XM5 y b VP VP sg13_lv_pmos w=0.15u l=0.13u ng=1 m=1 mm_ok=1
.ends

.end
