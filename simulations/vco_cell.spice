** sch_path: /foss/designs/CHIP-PLL/schematics/vco/vco_cell/vco_cell.sch
**.subckt vco_cell vp out in gnd
*.ipin in
*.iopin gnd
*.iopin vp
*.opin out
XM1 chwcto in gnd gnd sg13_lv_nmos w=0.405u l=0.420u ng=1 m=1 mm_ok=1
XM2 chwcto chwcto vp vp sg13_lv_pmos w=1.21u l=0.18u ng=1 m=1 mm_ok=1
XM3 1up chwcto vp vp sg13_lv_pmos w=1.21u l=0.18u ng=1 m=1 mm_ok=1
XM4 2up chwcto vp vp sg13_lv_pmos w=1.21u l=0.18u ng=1 m=1 mm_ok=1
XM5 3up chwcto vp vp sg13_lv_pmos w=1.21u l=0.18u ng=1 m=1 mm_ok=1
XM6 4up chwcto vp vp sg13_lv_pmos w=1.21u l=0.18u ng=1 m=1 mm_ok=1
XM7 5up chwcto vp vp sg13_lv_pmos w=1.21u l=0.18u ng=1 m=1 mm_ok=1
XM8 1-2 out 1up 1up sg13_lv_pmos w=1.2u l=0.18u ng=1 m=1 mm_ok=1
XM9 2-3 1-2 2up 2up sg13_lv_pmos w=1.2u l=0.18u ng=1 m=1 mm_ok=1
XM10 3-4 2-3 3up 3up sg13_lv_pmos w=1.2u l=0.18u ng=1 m=1 mm_ok=1
XM11 4-5 3-4 4up 4up sg13_lv_pmos w=1.2u l=0.18u ng=1 m=1 mm_ok=1
XM12 out 4-5 5up 5up sg13_lv_pmos w=1.2u l=0.18u ng=1 m=1 mm_ok=1
XM13 1-2 out 1dn 1dn sg13_lv_nmos w=0.4u l=0.18u ng=1 m=1 mm_ok=1
XM14 2-3 1-2 2dn 2dn sg13_lv_nmos w=0.4u l=0.18u ng=1 m=1 mm_ok=1
XM15 3-4 2-3 3dn 3dn sg13_lv_nmos w=0.4u l=0.18u ng=1 m=1 mm_ok=1
XM16 4-5 3-4 4dn 4dn sg13_lv_nmos w=0.4u l=0.18u ng=1 m=1 mm_ok=1
XM17 out 4-5 5dn 5dn sg13_lv_nmos w=0.4u l=0.18u ng=1 m=1 mm_ok=1
XM18 1dn in gnd gnd sg13_lv_nmos w=0.405u l=0.420u ng=1 m=1 mm_ok=1
XM19 2dn in gnd gnd sg13_lv_nmos w=0.405u l=0.420u ng=1 m=1 mm_ok=1
XM20 3dn in gnd gnd sg13_lv_nmos w=0.405u l=0.420u ng=1 m=1 mm_ok=1
XM21 4dn in gnd gnd sg13_lv_nmos w=0.405u l=0.420u ng=1 m=1 mm_ok=1
XM22 5dn in gnd gnd sg13_lv_nmos w=0.405u l=0.420u ng=1 m=1 mm_ok=1
**.ends
.end
