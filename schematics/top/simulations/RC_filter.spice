** sch_path: /foss/designs/CHIP-PLL/schematics/misc/RC_filter.sch
**.subckt RC_filter out in gd
*.ipin in
*.opin out
*.ipin gd
XM1 gd out gd gd sg13_lv_nmos w=10u l=10u ng=1 m=1 mm_ok=1
XM3 gd out gd gd sg13_lv_nmos w=10u l=10u ng=1 m=1 mm_ok=1
XM4 gd out gd gd sg13_lv_nmos w=10u l=10u ng=1 m=1 mm_ok=1
XR2 out in gd rppd w=0.5e-6 l=0.5e-6 m=1 b=0 mm_ok=1
**.ends
.end
