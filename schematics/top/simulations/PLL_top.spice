** sch_path: /foss/designs/CHIP-PLL/schematics/top/PLL_top.sch
.subckt PLL_top vp vph gd clk_ref out d5 d3 a1 d2 d1 d0 d4 a2 a0 rst vout
*.PININFO clk_ref:I out:O gd:I vph:I vp:I a0:I a1:I a2:I d0:I d1:I d2:I d3:I d4:I d5:I rst:I vout:O
x2 vp clk_ref cref gd buffer_hv
xPFD gd vp cref UP DOWN cvco rst_lv PFD_cell_2
xBUF vph aft_LS out gd buf
xDiv gd vp vco_out_buffered d0 d1 d2 d3 d4 d5 a0 a1 a2 cvco rst_lv Divider_top
xOutFlipFlop out_PLL_divided vp gd net1 vco_out_buffered net1 d_flip_flop
xLS vph aft_LS vp pre_LS gd level_shifter
x1 out_PLL_divided net2 vp gd inverter_x2
x3 net2 pre_LS vp gd inverter_x4_top
xCP vp UP vout DOWN rst_n gd charge_pump_cell
x9 rst_lv rst_n vp gd inverter_x4
xVCO vco_out_buffered gd vp a0 a1 a2 d0 d1 d2 d3 d4 d5 vout vco_top
x4 vp rst rst_lv gd buffer_hv
MM1 gd vp gd gd sg13_lv_nmos w=240u l=5u ng=1
.ends

* expanding   symbol:  /foss/designs/CHIP-PLL/schematics/misc/buffer_hv.sym # of pins=4
** sym_path: /foss/designs/CHIP-PLL/schematics/misc/buffer_hv.sym
** sch_path: /foss/designs/CHIP-PLL/schematics/misc/buffer_hv.sch
.subckt buffer_hv vph in out gd
*.PININFO in:I out:O vph:I gd:I
MM1 buf_stage_1 in vph vph sg13_hv_pmos w=1u l=0.45u ng=1
MM2 buf_stage_1 in gd gd sg13_hv_nmos w=1u l=0.45u ng=1
MM3 out buf_stage_1 vph vph sg13_hv_pmos w=1u l=0.45u ng=1
MM4 out buf_stage_1 gd gd sg13_hv_nmos w=1u l=0.45u ng=1
.ends

* expanding   symbol:  /foss/designs/CHIP-PLL/schematics/PFD/PFD_cell_2.sym # of pins=7
** sym_path: /foss/designs/CHIP-PLL/schematics/PFD/PFD_cell_2.sym
** sch_path: /foss/designs/CHIP-PLL/schematics/PFD/PFD_cell_2.sch
.subckt PFD_cell_2 gnd vp cRef UP DOWN cVco rst
*.PININFO gnd:B vp:B cRef:I cVco:I rst:I UP:O DOWN:O
MM4 UP rst gnd gnd sg13_lv_nmos w=0.45u l=0.15u ng=1
MM5 DOWN rst gnd gnd sg13_lv_nmos w=0.45u l=0.15u ng=1
x1 rst vp flip_flop_reset vp gnd reset_n PFD_passgate
x3 reset_n vp flip_flop_reset net3 gnd rst PFD_passgate
x7 vp gnd pre_up post_nand pre_down NAND_2in
* noconn #net5
x8 gnd vp net3 net4 PFD_buffor
x11 cRef flip_flop_reset vp pre_up net5 vp gnd PFD_flip_flop
x12 cVco flip_flop_reset vp pre_down net6 vp gnd PFD_flip_flop
* noconn #net6
x2 pre_down net1 vp gnd PFD_inverter_x4
x4 net1 DOWN vp gnd PFD_inverter_x4
x5 net2 UP vp gnd PFD_inverter_x4
x6 pre_up net2 vp gnd PFD_inverter_x4
x9 rst reset_n vp gnd PFD_inverter_x4
x10 post_nand net4 vp gnd PFD_inverter_x4
.ends

* expanding   symbol:  /foss/designs/CHIP-PLL/schematics/buf/buf.sym # of pins=4
** sym_path: /foss/designs/CHIP-PLL/schematics/buf/buf.sym
** sch_path: /foss/designs/CHIP-PLL/schematics/buf/buf.sch
.subckt buf VDD INPUT OUT GND
*.PININFO INPUT:I VDD:B GND:B OUT:O
MM9 OUT net3 VDD VDD sg13_hv_pmos w=10u l=0.4u ng=1 m=12
MM6 net3 net2 VDD VDD sg13_hv_pmos w=10u l=0.4u ng=1 m=4
MM4 net2 net1 VDD VDD sg13_hv_pmos w=10u l=0.4u ng=1 m=2
MM2 net1 INPUT VDD VDD sg13_hv_pmos w=10u l=0.4u ng=1
MM1 OUT net3 GND GND sg13_hv_nmos w=10u l=0.45u ng=1 m=12
MM3 net3 net2 GND GND sg13_hv_nmos w=10u l=0.45u ng=1 m=4
MM5 net2 net1 GND GND sg13_hv_nmos w=10u l=0.45u ng=1 m=2
MM7 net1 INPUT GND GND sg13_hv_nmos w=10u l=0.45u ng=1
.ends

* expanding   symbol:  /foss/designs/CHIP-PLL/schematics/divider/schematics/Divider_top.sym # of pins=14
** sym_path: /foss/designs/CHIP-PLL/schematics/divider/schematics/Divider_top.sym
** sch_path: /foss/designs/CHIP-PLL/schematics/divider/schematics/Divider_top.sch
.subckt Divider_top gd VP clk d0 d1 d2 d3 d4 d5 a0 a1 a2 out_div rst
*.PININFO gd:B clk:I VP:B out_div:O d0:I d1:I d2:I d3:I d4:I d5:I a0:I a1:I a2:I rst:I
x1 gd VP clk div2 div4 div8 div16 div32 div64 div128 2Div
x2 gd VP a0 MUX_out clk div2 div4 div8 div16 div32 div64 a1 div128 a2 MUX_8to1
x3 gd VP MUX_out rst d0 d1 d2 d3 d4 d5 out_div pdiv
.ends

* expanding   symbol:  /foss/designs/CHIP-PLL/schematics/divider/schematics/d_flip_flop.sym # of pins=6
** sym_path: /foss/designs/CHIP-PLL/schematics/divider/schematics/d_flip_flop.sym
** sch_path: /foss/designs/CHIP-PLL/schematics/divider/schematics/d_flip_flop.sch
.subckt d_flip_flop q VP GND q_ clk d
*.PININFO GND:B clk:I VP:B d:I q:O q_:O
x1 VP GND net1 net3 clk net4 NAND_3in
x2 VP GND net4 net2 net1 NAND_2in_x2
x3 VP GND net2 net1 clk NAND_2in_x2
x4 VP GND net1 q q_ NAND_2in_x2
x5 VP GND q q_ net3 NAND_2in_x2
x6 VP GND net3 net4 d NAND_2in_x2
.ends

* expanding   symbol:  /foss/designs/CHIP-PLL/schematics/misc/level_shifter.sym # of pins=5
** sym_path: /foss/designs/CHIP-PLL/schematics/misc/level_shifter.sym
** sch_path: /foss/designs/CHIP-PLL/schematics/misc/level_shifter.sch
.subckt level_shifter vph out vpl in gd
*.PININFO in:I out:O gd:I vph:I vpl:I
MM1 1_stage_out in vpl vpl sg13_lv_pmos w=2u l=0.45u ng=1
MM3 1_stage_out in net1 gd sg13_lv_nmos w=1u l=0.45u ng=1
MM4 net1 in gd gd sg13_lv_nmos w=1u l=0.45u ng=1
MM2 2_stage_out 1_stage_out vpl vpl sg13_lv_pmos w=2u l=0.45u ng=1
MM5 2_stage_out 1_stage_out net4 gd sg13_lv_nmos w=1u l=0.45u ng=1
MM6 net4 1_stage_out gd gd sg13_lv_nmos w=1u l=0.45u ng=1
MM7 net2 3_stage_out vph vph sg13_hv_pmos w=1u l=0.45u ng=1
MM8 3_stage_out 2_stage_out gd gd sg13_hv_nmos w=4u l=0.45u ng=1
MM9 4 1_stage_out net2 vph sg13_hv_pmos w=1u l=0.45u ng=1
MM10 3_stage_out 2_stage_out net3 vph sg13_hv_pmos w=2u l=0.45u ng=1
MM11 net3 4 vph vph sg13_hv_pmos w=2u l=0.45u ng=1
MM12 4 1_stage_out gd gd sg13_hv_nmos w=2u l=0.45u ng=1
MM15 out 3_stage_out vph vph sg13_hv_pmos w=2u l=0.45u ng=1
MM14 out 3_stage_out net5 gd sg13_hv_nmos w=1u l=0.45u ng=1
MM13 net5 3_stage_out gd gd sg13_hv_nmos w=1u l=0.45u ng=1
.ends

* expanding   symbol:  /foss/designs/CHIP-PLL/schematics/divider/schematics/inverter_x2.sym # of pins=4
** sym_path: /foss/designs/CHIP-PLL/schematics/divider/schematics/inverter_x2.sym
** sch_path: /foss/designs/CHIP-PLL/schematics/divider/schematics/inverter_x2.sch
.subckt inverter_x2 IN OUT VP GND
*.PININFO IN:I VP:B OUT:O GND:B
MM1 OUT IN GND GND sg13_lv_nmos w=0.30u l=0.13u ng=1
MM2 OUT IN VP VP sg13_lv_pmos w=0.30u l=0.13u ng=1
.ends

* expanding   symbol:  /foss/designs/CHIP-PLL/schematics/divider/schematics/inverter_x4_top.sym # of pins=4
** sym_path: /foss/designs/CHIP-PLL/schematics/divider/schematics/inverter_x4_top.sym
** sch_path: /foss/designs/CHIP-PLL/schematics/divider/schematics/inverter_x4_top.sch
.subckt inverter_x4_top IN OUT VP GND
*.PININFO IN:I VP:B OUT:O GND:B
MM1 OUT IN GND GND sg13_lv_nmos w=0.60u l=0.13u ng=1
MM2 OUT IN VP VP sg13_lv_pmos w=0.60u l=0.13u ng=1
.ends

* expanding   symbol:  /foss/designs/CHIP-PLL/schematics/charge_pump/charge_pump_cell.sym # of pins=6
** sym_path: /foss/designs/CHIP-PLL/schematics/charge_pump/charge_pump_cell.sym
** sch_path: /foss/designs/CHIP-PLL/schematics/charge_pump/charge_pump_cell.sch
.subckt charge_pump_cell vp UP vout DN rst gd
*.PININFO UP:B DN:B gd:B vp:B vout:O rst:B
x1 vp gd bias vbias
x2 vp net6 gd curr_source
MM20 net8 net15 vp vp sg13_lv_pmos w=1.6u l=0.6u ng=1
MM3 net15 bias net8 vp sg13_lv_pmos w=1.6u l=0.6u ng=1
MM12 net1 net6 vp vp sg13_lv_pmos w=1u l=0.6u ng=1
MM14 net1 bias net2 gd sg13_lv_nmos w=4.8u l=0.6u ng=1
MM9 net2 net1 gd gd sg13_lv_nmos w=4.8u l=0.6u ng=1
MM17 net7 net1 gd gd sg13_lv_nmos w=1.6u l=0.6u ng=1
MM6 net10 bias net7 gd sg13_lv_nmos w=1.6u l=0.6u ng=1
MM10 net5 net15 vp vp sg13_lv_pmos w=1.65u l=0.6u ng=1
MM2 net3 bias net5 vp sg13_lv_pmos w=1.6u l=0.6u ng=1
MM5 vout net9 net3 vp sg13_lv_pmos w=1u l=0.6u ng=1
MM7 net9 UP vp vp sg13_lv_pmos w=1u l=0.6u ng=1
MM4 net9 UP gd gd sg13_lv_nmos w=1u l=0.6u ng=1
MM11 vout DN net13 gd sg13_lv_nmos w=1u l=0.6u ng=1
MM13 net13 bias net4 gd sg13_lv_nmos w=1.6u l=0.6u ng=1
MM8 net4 net1 gd gd sg13_lv_nmos w=1.6u l=0.6u ng=1
MM15 vtest vtest vp vp sg13_lv_pmos w=1.8u l=1.8u ng=1
MM16 vtest vtest gd gd sg13_lv_nmos w=0.6u l=1.8u ng=1
MM18 vout rst vtest vp sg13_lv_pmos w=1.8u l=0.6u ng=1
MM1 net15 bias net10 gd sg13_lv_nmos w=1.6u l=0.6u ng=1
MM19 gd gd gd gd sg13_lv_nmos w=1.6u l=0.6u ng=1
.ends

* expanding   symbol:  /foss/designs/CHIP-PLL/schematics/divider/schematics/inverter_x4.sym # of pins=4
** sym_path: /foss/designs/CHIP-PLL/schematics/divider/schematics/inverter_x4.sym
** sch_path: /foss/designs/CHIP-PLL/schematics/divider/schematics/inverter_x4.sch
.subckt inverter_x4 IN OUT VP GND
*.PININFO IN:I VP:B OUT:O GND:B
MM1 OUT IN GND GND sg13_lv_nmos w=0.60u l=0.13u ng=1
MM2 OUT IN VP VP sg13_lv_pmos w=0.60u l=0.13u ng=1
.ends

* expanding   symbol:  /foss/designs/CHIP-PLL/schematics/vco/vco_cell/vco_top.sym # of pins=13
** sym_path: /foss/designs/CHIP-PLL/schematics/vco/vco_cell/vco_top.sym
** sch_path: /foss/designs/CHIP-PLL/schematics/vco/vco_cell/vco_top.sch
.subckt vco_top out gd VP c0 c1 c2 f0 f1 f2 f3 f4 f5 vco_in
*.PININFO gd:B VP:B c1:I c2:I f0:I f1:I c0:I f2:I f3:I f4:I f5:I out:O vco_in:I
x1 VP_vco0 gd net1 net10 vco_core_0
x2 VP_vco1 gd net2 VCO2_5_sel net6 nVCO2_11_sel nVCO2_5_sel VCO2_11_sel vco_core_1
x3 VP_vco2 gd net3 net7 VCO3_5_sel nVCO3_5_sel nVCO3_11_sel VCO3_11_sel vco_core_2
x4 VP_vco3 gd net4 net8 VCO4_5_sel nVCO4_5_sel nVCO4_11_sel VCO4_11_sel vco_core_3
x5 VP_vco4 gd net5 net9 vco_core_4
x6 VP gd vco_0_out net1 0_buf
x7 VP gd vco_1_out net2 0_buf
x8 VP gd vco_2_out net3 0_buf
x9 VP gd vco_3_out net4 0_buf
x10 VP gd vco_4_out net5 0_buf
x11 gd VP c0 c1 c2 f0 f1 f2 f3 f4 f5 vco_0_out vco_1_out vco_2_out vco_3_out vco_4_out VCO2_11_sel VCO2_5_sel VCO3_11_sel
+ VCO3_5_sel VCO4_11_sel VCO4_5_sel out VCO4_SEL VCO3_SEL VCO2_SEL VCO_SEL VCO5_SEL VCO_MUX_and_decoder
x12 VCO2_5_sel nVCO2_5_sel VP gd inverter
x13 VCO2_11_sel nVCO2_11_sel VP gd inverter
x14 VCO3_5_sel nVCO3_5_sel VP gd inverter
x15 VCO3_11_sel nVCO3_11_sel VP gd inverter
x16 VCO4_5_sel nVCO4_5_sel VP gd inverter
x17 VCO4_11_sel nVCO4_11_sel VP gd inverter
x19 VCO_SEL VCO_SEL_n VP gd inverter
x21 VCO2_SEL VCO2_SEL_n VP gd inverter
x23 VCO3_SEL VCO3_SEL_n VP gd inverter
x25 VCO4_SEL VCO4_SEL_n VP gd inverter
x27 VCO5_SEL VCO5_SEL_n VP gd inverter
MM1 net6 VCO2_SEL_n gd gd sg13_lv_nmos w=0.3u l=0.13u ng=1
MM6 VP_vco4 VCO5_SEL_n gd gd sg13_lv_nmos w=0.3u l=0.13u ng=1
MM7 VP_vco3 VCO4_SEL_n gd gd sg13_lv_nmos w=0.3u l=0.13u ng=1
MM8 VP_vco2 VCO3_SEL_n gd gd sg13_lv_nmos w=0.3u l=0.13u ng=1
MM9 VP_vco1 VCO2_SEL_n gd gd sg13_lv_nmos w=0.3u l=0.13u ng=1
MM10 VP_vco0 VCO_SEL_n gd gd sg13_lv_nmos w=0.3u l=0.13u ng=1
x28 VCO2_SEL VP vco_in net6 gd VCO2_SEL_n PFD_passgate
MM2 net7 VCO3_SEL_n gd gd sg13_lv_nmos w=0.3u l=0.13u ng=1
x26 VCO3_SEL VP vco_in net7 gd VCO3_SEL_n PFD_passgate
MM3 net8 VCO4_SEL_n gd gd sg13_lv_nmos w=0.3u l=0.13u ng=1
x29 VCO4_SEL VP vco_in net8 gd VCO4_SEL_n PFD_passgate
MM4 net9 VCO5_SEL_n gd gd sg13_lv_nmos w=0.3u l=0.13u ng=1
x30 VCO5_SEL VP vco_in net9 gd VCO5_SEL_n PFD_passgate
MM5 net10 VCO_SEL_n gd gd sg13_lv_nmos w=0.3u l=0.13u ng=1
x31 VCO_SEL VP vco_in net10 gd VCO_SEL_n PFD_passgate
x18 VCO_SEL_n VP gd VCO_SEL VP VP_vco0 vco_passgate
x20 VCO2_SEL_n VP gd VCO2_SEL VP VP_vco1 vco_passgate
x22 VCO3_SEL_n VP gd VCO3_SEL VP VP_vco2 vco_passgate
x24 VCO4_SEL_n VP gd VCO4_SEL VP VP_vco3 vco_passgate
x32 VCO5_SEL_n VP gd VCO5_SEL VP VP_vco4 vco_passgate
.ends

* expanding   symbol:  /foss/designs/CHIP-PLL/schematics/PFD/PFD_passgate.sym # of pins=6
** sym_path: /foss/designs/CHIP-PLL/schematics/PFD/PFD_passgate.sym
** sch_path: /foss/designs/CHIP-PLL/schematics/PFD/PFD_passgate.sch
.subckt PFD_passgate in_n vp A B gnd in_p
*.PININFO in_n:I in_p:I vp:B gnd:B B:B A:B
MM4 B in_p A vp sg13_lv_pmos w=0.3u l=0.15u ng=1
MM5 B in_n A gnd sg13_lv_nmos w=0.3u l=0.15u ng=1
.ends

* expanding   symbol:  /foss/designs/CHIP-PLL/schematics/divider/schematics/NAND_2in.sym # of pins=5
** sym_path: /foss/designs/CHIP-PLL/schematics/divider/schematics/NAND_2in.sym
** sch_path: /foss/designs/CHIP-PLL/schematics/divider/schematics/NAND_2in.sch
.subckt NAND_2in VP GND a y b
*.PININFO y:O GND:B a:I VP:B b:I
MM1 y a net1 GND sg13_lv_nmos w=0.15u l=0.13u ng=1
MM3 net1 b GND GND sg13_lv_nmos w=0.15u l=0.13u ng=1
MM2 y b VP VP sg13_lv_pmos w=0.15u l=0.13u ng=1
MM4 y a VP VP sg13_lv_pmos w=0.15u l=0.13u ng=1
.ends

* expanding   symbol:  /foss/designs/CHIP-PLL/schematics/PFD/PFD_buffor.sym # of pins=4
** sym_path: /foss/designs/CHIP-PLL/schematics/PFD/PFD_buffor.sym
** sch_path: /foss/designs/CHIP-PLL/schematics/PFD/PFD_buffor.sch
.subckt PFD_buffor gnd vp out in
*.PININFO gnd:B vp:B in:I out:B
MM1 out_stage1 in gnd gnd sg13_lv_nmos w=0.4u l=0.75u ng=1
MM4 out_stage1 in vp vp sg13_lv_pmos w=0.4u l=0.75u ng=1
MM2 out out_stage1 gnd gnd sg13_lv_nmos w=0.4u l=0.75u ng=1
MM3 out out_stage1 vp vp sg13_lv_pmos w=0.4u l=0.75u ng=1
.ends

* expanding   symbol:  /foss/designs/CHIP-PLL/schematics/PFD/PFD_flip_flop.sym # of pins=7
** sym_path: /foss/designs/CHIP-PLL/schematics/PFD/PFD_flip_flop.sym
** sch_path: /foss/designs/CHIP-PLL/schematics/PFD/PFD_flip_flop.sch
.subckt PFD_flip_flop clk rst D Q NQ vp gd
*.PININFO D:I Q:O NQ:O clk:I rst:I gd:I vp:I
x8 clk vp post_NOR 1 gd clk_n PFD_passgate
x4 clk vp 2 3 gd clk_n PFD_passgate
x7 clk_n vp NQ 3 gd clk PFD_passgate
x3 vp rst 3 Q gd PFD_NOR
x5 vp rst 2 post_NOR gd PFD_NOR
x1 clk_n vp D 1 gd clk PFD_passgate
MM1 gd 1 gd gd sg13_lv_nmos w=10u l=5u ng=1
MM2 gd 3 gd gd sg13_lv_nmos w=10u l=5u ng=1
MM3 gd 2 gd gd sg13_lv_nmos w=10u l=5u ng=1
x9 1 2 vp gd PFD_inverter_x8
x6 Q NQ vp gd PFD_inverter_x8
x2 clk clk_n vp gd PFD_inverter_x4
.ends

* expanding   symbol:  /foss/designs/CHIP-PLL/schematics/PFD/PFD_inverter_x4.sym # of pins=4
** sym_path: /foss/designs/CHIP-PLL/schematics/PFD/PFD_inverter_x4.sym
** sch_path: /foss/designs/CHIP-PLL/schematics/PFD/PFD_inverter_x4.sch
.subckt PFD_inverter_x4 IN OUT VP GND
*.PININFO IN:I VP:B OUT:O GND:B
MM1 OUT IN GND GND sg13_lv_nmos w=0.60u l=0.13u ng=1
MM2 OUT IN VP VP sg13_lv_pmos w=0.60u l=0.13u ng=1
.ends

* expanding   symbol:  /foss/designs/CHIP-PLL/schematics/divider/schematics/2Div.sym # of pins=10
** sym_path: /foss/designs/CHIP-PLL/schematics/divider/schematics/2Div.sym
** sch_path: /foss/designs/CHIP-PLL/schematics/divider/schematics/2Div.sch
.subckt 2Div gd vp in div2 div4 div8 div16 div32 div64 div128
*.PININFO gd:B in:I vp:B div2:O div4:O div8:O div16:O div32:O div64:O div128:O
x1 div2 vp gd net1 in net1 d_flip_flop
x2 div4 vp gd net2 div2 net2 d_flip_flop
x3 div32 vp gd net5 div16 net5 d_flip_flop
x4 div64 vp gd net6 div32 net6 d_flip_flop
x5 div8 vp gd net3 div4 net3 d_flip_flop
x6 div16 vp gd net4 div8 net4 d_flip_flop
x7 div128 vp gd net7 div64 net7 d_flip_flop
.ends

* expanding   symbol:  /foss/designs/CHIP-PLL/schematics/divider/schematics/MUX_8to1.sym # of pins=14
** sym_path: /foss/designs/CHIP-PLL/schematics/divider/schematics/MUX_8to1.sym
** sch_path: /foss/designs/CHIP-PLL/schematics/divider/schematics/MUX_8to1.sch
.subckt MUX_8to1 gd vp A0 out in1 in2 in3 in4 in5 in6 in7 A1 in8 A2
*.PININFO gd:B vp:B out:O in1:I in2:I in3:I in4:I in5:I in6:I in7:I in8:I A0:I A1:I A2:I
x9 A0 net1 vp gd inverter_x4
x10 A1 net2 vp gd inverter_x4
x11 A2 net3 vp gd inverter_x4
x28 out_unb out vp gd inverter_x4
x29 in4 net8 vp gd inverter_x4
x30 in8 net4 vp gd inverter_x4
x31 in7 net5 vp gd inverter_x4
x32 in6 net6 vp gd inverter_x4
x33 in5 net7 vp gd inverter_x4
x34 in1 net11 vp gd inverter_x4
x35 in2 net10 vp gd inverter_x4
x36 in3 net9 vp gd inverter_x4
x13 en1_ en1 vp gd inverter_x4
x15 en2_ en2 vp gd inverter_x4
x17 en3_ en3 vp gd inverter_x4
x19 en4_ en4 vp gd inverter_x4
x21 en5_ en5 vp gd inverter_x4
x23 en6_ en6 vp gd inverter_x4
x25 en7_ en7 vp gd inverter_x4
x27 en8_ en8 vp gd inverter_x4
x12 vp gd net3 en1_ net2 net1 NAND_3in
x14 vp gd net2 en2_ net3 A0 NAND_3in
x16 vp gd net1 en3_ net3 A1 NAND_3in
x18 vp gd net3 en4_ A1 A0 NAND_3in
x20 vp gd net1 en5_ net2 A2 NAND_3in
x22 vp gd net2 en6_ A2 A0 NAND_3in
x24 vp gd net1 en7_ A2 A1 NAND_3in
x26 vp gd A2 en8_ A1 A0 NAND_3in
x1 en8_ vp gd en8 net4 out_unb passgate
x2 en4_ vp gd en4 net8 out_unb passgate
x3 en7_ vp gd en7 net5 out_unb passgate
x4 en3_ vp gd en3 net9 out_unb passgate
x5 en6_ vp gd en6 net6 out_unb passgate
x6 en2_ vp gd en2 net10 out_unb passgate
x7 en5_ vp gd en5 net7 out_unb passgate
x8 en1_ vp gd en1 net11 out_unb passgate
.ends

* expanding   symbol:  /foss/designs/CHIP-PLL/schematics/divider/schematics/pdiv.sym # of pins=11
** sym_path: /foss/designs/CHIP-PLL/schematics/divider/schematics/pdiv.sym
** sch_path: /foss/designs/CHIP-PLL/schematics/divider/schematics/pdiv.sch
.subckt pdiv gd VP clk reset d0 d1 d2 d3 d4 d5 out_div
*.PININFO gd:B clk:I VP:B d0:I d1:I d2:I d3:I d4:I d5:I out_div:O reset:I
x4 VP gd d0 d012 d1 d2 NAND_3in
x7 VP gd d3 d345 d4 d5 NAND_3in
x5 VP gd d012 bypass d345 NOR_2in
x1 gd VP clk out r_div2 r_div4 r_div8 r_div16 r_div32 r_div64 div_with_reset
x2 out_pre_buff VP gd r_div2 r_div4 r_div8 r_div16 r_div32 r_div64 d0 d1 d2 d3 d4 d5 count_data_check
x11 out_div VP gd net2 net1 net2 net4 d_flip_flop_reset
x13 out_pre_buff out VP gd inverter_x8
x3 net3 VP gd bypass clk net1 passgate
x8 bypass VP gd net3 out net1 passgate
x6 bypass net3 VP gd inverter_x4
x9 reset net4 VP gd inverter_x4
.ends

* expanding   symbol:  /foss/designs/CHIP-PLL/schematics/divider/schematics/NAND_3in.sym # of pins=6
** sym_path: /foss/designs/CHIP-PLL/schematics/divider/schematics/NAND_3in.sym
** sch_path: /foss/designs/CHIP-PLL/schematics/divider/schematics/NAND_3in.sch
.subckt NAND_3in VP GND a y b c
*.PININFO y:O GND:B a:I VP:B b:I c:I
MM1 y a net2 GND sg13_lv_nmos w=0.3u l=0.13u ng=1
MM3 net2 b net1 GND sg13_lv_nmos w=0.3u l=0.13u ng=1
MM4 net1 c GND GND sg13_lv_nmos w=0.3u l=0.13u ng=1
MM7 y c VP VP sg13_lv_pmos w=0.15u l=0.13u ng=1
MM2 y a VP VP sg13_lv_pmos w=0.15u l=0.13u ng=1
MM5 y b VP VP sg13_lv_pmos w=0.15u l=0.13u ng=1
.ends

* expanding   symbol:  /foss/designs/CHIP-PLL/schematics/divider/schematics/NAND_2in_x2.sym # of pins=5
** sym_path: /foss/designs/CHIP-PLL/schematics/divider/schematics/NAND_2in_x2.sym
** sch_path: /foss/designs/CHIP-PLL/schematics/divider/schematics/NAND_2in_x2.sch
.subckt NAND_2in_x2 VP GND a y b
*.PININFO y:O GND:B a:I VP:B b:I
MM1 y a net1 GND sg13_lv_nmos w=0.6u l=0.13u ng=1
MM2 y b VP VP sg13_lv_pmos w=0.3u l=0.13u ng=1
MM3 net1 b GND GND sg13_lv_nmos w=0.6u l=0.13u ng=1
MM4 y a VP VP sg13_lv_pmos w=0.3u l=0.13u ng=1
.ends

* expanding   symbol:  /foss/designs/CHIP-PLL/schematics/charge_pump/vbias.sym # of pins=3
** sym_path: /foss/designs/CHIP-PLL/schematics/charge_pump/vbias.sym
** sch_path: /foss/designs/CHIP-PLL/schematics/charge_pump/vbias.sch
.subckt vbias vp gd vbias
*.PININFO vbias:O gd:B vp:B
MM5 net1 iref vp vp sg13_lv_pmos w=1.2u l=0.6u ng=1
MM6 vbias net1 net2 gd sg13_lv_nmos w=3.6u l=0.6u ng=1
MM2 net2 net2 gd gd sg13_lv_nmos w=1.2u l=0.6u ng=1
MM3 gd gd gd gd sg13_lv_nmos w=1.86u l=0.6u ng=1
MM7 vp vp vp vp sg13_lv_pmos w=1.375u l=0.6u ng=1
RR1 net1 vbias 509.4 $SUB=gd $[rppd] w=1e-6 l=1.7e-6 b=0
x1 vp iref gd curr_source
.ends

* expanding   symbol:  /foss/designs/CHIP-PLL/schematics/charge_pump/curr_source.sym # of pins=3
** sym_path: /foss/designs/CHIP-PLL/schematics/charge_pump/curr_source.sym
** sch_path: /foss/designs/CHIP-PLL/schematics/charge_pump/curr_source.sch
.subckt curr_source vp iref gd
*.PININFO vp:B gd:B iref:O
MM9 net3 net3 gd gd sg13_lv_nmos w=1u l=0.6u ng=1
MM4 iref iref vp vp sg13_lv_pmos w=1.4u l=0.6u ng=1
MM5 net2 iref vp vp sg13_lv_pmos w=1.2u l=0.6u ng=1
MM10 iref net2 net1 gd sg13_lv_nmos w=1.2u l=0.6u ng=1
MM1 net2 net2 gd gd sg13_lv_nmos w=1.4u l=0.6u ng=1
MM3 vp vp net3 gd sg13_lv_nmos w=1u l=0.6u ng=1
MM6 vp net3 iref gd sg13_lv_nmos w=1u l=0.6u ng=1
MM2 gd gd gd gd sg13_lv_nmos w=0.4u l=0.6u ng=1
RR2 net1 gd 509.4 $SUB=gd $[rppd] w=1e-6 l=1.7e-6 b=0
.ends

* expanding   symbol:  /foss/designs/CHIP-PLL/schematics/vco/vco_cell/vco_core_0.sym # of pins=4
** sym_path: /foss/designs/CHIP-PLL/schematics/vco/vco_cell/vco_core_0.sym
** sch_path: /foss/designs/CHIP-PLL/schematics/vco/vco_cell/vco_core_0.sch
.subckt vco_core_0 vp gnd out in
*.PININFO in:I vp:B out:O gnd:B
MM1 pgt in gnd gnd sg13_lv_nmos w=0.8u l=0.14*4u ng=1
MM2 pgt pgt vp vp sg13_lv_pmos w=1.2u l=0.14*4u ng=1
x1 vp pgt out net1 in gnd vco_delay_cell_0
x2 vp pgt net1 2th in gnd vco_delay_cell_0
x3 vp pgt 2th 3th in gnd vco_delay_cell_0
x4 vp pgt 3th 4th in gnd vco_delay_cell_0
x7 vp pgt 4th out in gnd vco_delay_cell_0
.ends

* expanding   symbol:  /foss/designs/CHIP-PLL/schematics/vco/vco_cell/vco_core_1.sym # of pins=8
** sym_path: /foss/designs/CHIP-PLL/schematics/vco/vco_cell/vco_core_1.sym
** sch_path: /foss/designs/CHIP-PLL/schematics/vco/vco_cell/vco_core_1.sch
.subckt vco_core_1 vp gnd out en5 in nen11 nen5 en11
*.PININFO in:I vp:B out:O gnd:B en5:I en11:I nen11:I nen5:I
MM1 pgt in gnd gnd sg13_lv_nmos w=0.8u l=0.35*4u ng=1
MM2 pgt pgt vp vp sg13_lv_pmos w=1.2u l=0.35*4u ng=1
x1 vp pgt out 1th in gnd vco_delay_cell_1
x2 vp pgt 1th 2th in gnd vco_delay_cell_1
x3 vp pgt 2th 3th in gnd vco_delay_cell_1
x4 vp pgt 3th 4th in gnd vco_delay_cell_1
x7 vp pgt 5th out in gnd vco_delay_cell_1
x8 vp pgt 11_1st 6th in gnd vco_delay_cell_1
x9 vp pgt 6th 7th in gnd vco_delay_cell_1
x10 vp pgt 7th 8th in gnd vco_delay_cell_1
x11 vp pgt 8th 9th in gnd vco_delay_cell_1
x12 vp pgt 9th 10th in gnd vco_delay_cell_1
x13 vp pgt 10th 11_lst in gnd vco_delay_cell_1
MM4 11_1st nen11 4th vp sg13_lv_pmos w=0.3u l=0.15u ng=1
MM5 11_1st en11 4th gnd sg13_lv_nmos w=0.3u l=0.15u ng=1
MM3 5th nen11 11_lst vp sg13_lv_pmos w=0.3u l=0.15u ng=1
MM6 5th en11 11_lst gnd sg13_lv_nmos w=0.3u l=0.15u ng=1
MM7 5th nen5 4th vp sg13_lv_pmos w=0.3u l=0.15u ng=1
MM8 5th en5 4th gnd sg13_lv_nmos w=0.3u l=0.15u ng=1
.ends

* expanding   symbol:  /foss/designs/CHIP-PLL/schematics/vco/vco_cell/vco_core_2.sym # of pins=8
** sym_path: /foss/designs/CHIP-PLL/schematics/vco/vco_cell/vco_core_2.sym
** sch_path: /foss/designs/CHIP-PLL/schematics/vco/vco_cell/vco_core_2.sch
.subckt vco_core_2 vp gnd out in en5 nen5 nen11 en11
*.PININFO in:I vp:B out:O gnd:B en5:I en11:I nen11:I nen5:I
MM1 pgt in gnd gnd sg13_lv_nmos w=0.8u l=1.4*4u ng=1
MM2 pgt pgt vp vp sg13_lv_pmos w=1.2u l=1.4*4u ng=1
x1 vp pgt out 1th in gnd vco_delay_cell_2
x2 vp pgt 1th 2th in gnd vco_delay_cell_2
x3 vp pgt 2th 3th in gnd vco_delay_cell_2
x4 vp pgt 3th 4th in gnd vco_delay_cell_2
x7 vp pgt 5th out in gnd vco_delay_cell_2
x8 vp pgt 11_1st 6th in gnd vco_delay_cell_2
x9 vp pgt 6th 7th in gnd vco_delay_cell_2
x10 vp pgt 7th 8th in gnd vco_delay_cell_2
x11 vp pgt 8th 9th in gnd vco_delay_cell_2
x12 vp pgt 9th 10th in gnd vco_delay_cell_2
x13 vp pgt 10th 11_lst in gnd vco_delay_cell_2
MM4 11_1st nen11 4th vp sg13_lv_pmos w=0.3u l=0.15u ng=1
MM5 11_1st en11 4th gnd sg13_lv_nmos w=0.3u l=0.15u ng=1
MM3 5th nen11 11_lst vp sg13_lv_pmos w=0.3u l=0.15u ng=1
MM6 5th en11 11_lst gnd sg13_lv_nmos w=0.3u l=0.15u ng=1
MM7 5th nen5 4th vp sg13_lv_pmos w=0.3u l=0.15u ng=1
MM8 5th en5 4th gnd sg13_lv_nmos w=0.3u l=0.15u ng=1
.ends

* expanding   symbol:  /foss/designs/CHIP-PLL/schematics/vco/vco_cell/vco_core_3.sym # of pins=8
** sym_path: /foss/designs/CHIP-PLL/schematics/vco/vco_cell/vco_core_3.sym
** sch_path: /foss/designs/CHIP-PLL/schematics/vco/vco_cell/vco_core_3.sch
.subckt vco_core_3 vp gnd out in en5 nen5 nen11 en11
*.PININFO in:I vp:B out:O gnd:B en5:I en11:I nen11:I nen5:I
MM1 pgt in gnd gnd sg13_lv_nmos w=0.8u l=4.25*4u ng=1
MM2 pgt pgt vp vp sg13_lv_pmos w=1.2u l=4.25*4u ng=1
x1 vp pgt out 1th in gnd vco_delay_cell_3
x2 vp pgt 1th 2th in gnd vco_delay_cell_3
x3 vp pgt 2th 3th in gnd vco_delay_cell_3
x4 vp pgt 3th 4th in gnd vco_delay_cell_3
x7 vp pgt 5th out in gnd vco_delay_cell_3
x8 vp pgt 11_1st 6th in gnd vco_delay_cell_3
x9 vp pgt 6th 7th in gnd vco_delay_cell_3
x10 vp pgt 7th 8th in gnd vco_delay_cell_3
x11 vp pgt 8th 9th in gnd vco_delay_cell_3
x12 vp pgt 9th 10th in gnd vco_delay_cell_3
x13 vp pgt 10th 11_lst in gnd vco_delay_cell_3
MM4 11_1st nen11 4th vp sg13_lv_pmos w=0.3u l=0.15u ng=1
MM5 11_1st en11 4th gnd sg13_lv_nmos w=0.3u l=0.15u ng=1
MM3 5th nen11 11_lst vp sg13_lv_pmos w=0.3u l=0.15u ng=1
MM6 5th en11 11_lst gnd sg13_lv_nmos w=0.3u l=0.15u ng=1
MM7 5th nen5 4th vp sg13_lv_pmos w=0.3u l=0.15u ng=1
MM8 5th en5 4th gnd sg13_lv_nmos w=0.3u l=0.15u ng=1
.ends

* expanding   symbol:  /foss/designs/CHIP-PLL/schematics/vco/vco_cell/vco_core_4.sym # of pins=4
** sym_path: /foss/designs/CHIP-PLL/schematics/vco/vco_cell/vco_core_4.sym
** sch_path: /foss/designs/CHIP-PLL/schematics/vco/vco_cell/vco_core_4.sch
.subckt vco_core_4 vp gnd out in
*.PININFO in:I vp:B out:O gnd:B
MM1 pgt in gnd gnd sg13_lv_nmos w=0.8u l=7.5*4u ng=1
MM2 pgt pgt vp vp sg13_lv_pmos w=1.2u l=7.5*4u ng=1
x1 vp pgt out 1th in gnd vco_delay_cell_4
x2 vp pgt 1th 2th in gnd vco_delay_cell_4
x3 vp pgt 2th 3th in gnd vco_delay_cell_4
x4 vp pgt 3th 4th in gnd vco_delay_cell_4
x7 vp pgt 10th out in gnd vco_delay_cell_4
x8 vp pgt 4th 5th in gnd vco_delay_cell_4
x9 vp pgt 5th 6th in gnd vco_delay_cell_4
x10 vp pgt 6th 7th in gnd vco_delay_cell_4
x11 vp pgt 7th 8th in gnd vco_delay_cell_4
x12 vp pgt 8th 9th in gnd vco_delay_cell_4
x13 vp pgt 9th 10th in gnd vco_delay_cell_4
.ends

* expanding   symbol:  /foss/designs/CHIP-PLL/schematics/vco/vco_cell/0_buf.sym # of pins=4
** sym_path: /foss/designs/CHIP-PLL/schematics/vco/vco_cell/0_buf.sym
** sch_path: /foss/designs/CHIP-PLL/schematics/vco/vco_cell/0_buf.sch
.subckt 0_buf vp gnd out in
*.PININFO in:I out:O vp:B gnd:B
MM9 3th 2th vp vp sg13_lv_pmos w=2.5u l=0.13u ng=1
MM10 3th 2th gnd gnd sg13_lv_nmos w=2.5u l=0.13u ng=1
MM11 2th 1th vp vp sg13_lv_pmos w=2.4u l=0.13u ng=1
MM12 2th 1th gnd gnd sg13_lv_nmos w=1.2u l=0.13u ng=1
MM1 4th 3th vp vp sg13_lv_pmos w=5u l=0.13u ng=1
MM2 4th 3th gnd gnd sg13_lv_nmos w=5u l=0.13u ng=1
MM3 5th 4th vp vp sg13_lv_pmos w=10u l=0.13u ng=1
MM4 5th 4th gnd gnd sg13_lv_nmos w=10u l=0.13u ng=1
MM5 out 5th vp vp sg13_lv_pmos w=10u l=0.13u ng=1 m=2
MM6 out 5th gnd gnd sg13_lv_nmos w=10u l=0.13u ng=1 m=2
MM7 1th in gnd gnd sg13_lv_nmos w=0.8u l=0.13u ng=1
MM8 1th in vp vp sg13_lv_pmos w=1.5u l=0.13u ng=1
.ends

* expanding   symbol:  /foss/designs/CHIP-PLL/schematics/divider/schematics/VCO_MUX_and_decoder.sym # of pins=28
** sym_path: /foss/designs/CHIP-PLL/schematics/divider/schematics/VCO_MUX_and_decoder.sym
** sch_path: /foss/designs/CHIP-PLL/schematics/divider/schematics/VCO_MUX_and_decoder.sch
.subckt VCO_MUX_and_decoder gd VP c0 c1 c2 f0 f1 f2 f3 f4 f5 VCO_in VCO2_in VCO3_in VCO4_in VCO5_in VCO2_11_sel VCO2_5_sel
+ VCO3_11_sel VCO3_5_sel VCO4_11_sel VCO4_5_sel out VCO4_sel VCO3_sel VCO2_sel VCO_sel VCO5_sel
*.PININFO gd:B VP:B c1:I c2:I f0:I f1:I c0:I VCO2_11_sel:O VCO2_5_sel:O VCO3_11_sel:O VCO3_5_sel:O VCO4_11_sel:O VCO4_5_sel:O f2:I
*+ f3:I f4:I f5:I VCO_in:I VCO2_in:I VCO3_in:I VCO4_in:I VCO5_in:I out:O VCO_sel:O VCO2_sel:O VCO3_sel:O VCO4_sel:O VCO5_sel:O
x2 gd VP VCO_in VCO2_in VCO3_in VCO4_in VCO5_in VCO_sel VCO2_sel VCO3_sel VCO4_sel VCO5_sel out VCO_MUX
x4 VP gd VCO2_11_sel net1 VCO2_5_sel NOR_2in
x5 net1 VCO2_sel VP gd inverter
x3 VP gd VCO3_11_sel net2 VCO3_5_sel NOR_2in
x6 VP gd VCO4_11_sel net3 VCO4_5_sel NOR_2in
x7 net2 VCO3_sel VP gd inverter
x8 net3 VCO4_sel VP gd inverter
x9 gd VP c0 c1 c2 f0 f1 f2 f3 f4 f5 VCO_sel VCO2_11_sel VCO2_5_sel VCO3_11_sel VCO3_5_sel VCO4_11_sel VCO4_5_sel VCO5_sel
+ VCO_decoder_cells
.ends

* expanding   symbol:  /foss/designs/CHIP-PLL/schematics/divider/schematics/inverter.sym # of pins=4
** sym_path: /foss/designs/CHIP-PLL/schematics/divider/schematics/inverter.sym
** sch_path: /foss/designs/CHIP-PLL/schematics/divider/schematics/inverter.sch
.subckt inverter IN OUT VP GND
*.PININFO IN:I VP:B OUT:O GND:B
MM1 OUT IN GND GND sg13_lv_nmos w=0.15u l=0.13u ng=1
MM2 OUT IN VP VP sg13_lv_pmos w=0.15u l=0.13u ng=1
.ends

* expanding   symbol:  /foss/designs/CHIP-PLL/schematics/vco/vco_cell/vco_passgate.sym # of pins=6
** sym_path: /foss/designs/CHIP-PLL/schematics/vco/vco_cell/vco_passgate.sym
** sch_path: /foss/designs/CHIP-PLL/schematics/vco/vco_cell/vco_passgate.sch
.subckt vco_passgate en_ VP GND en IO OI
*.PININFO OI:B IO:B VP:B GND:B en_:I en:I
MM1 IO en OI GND sg13_lv_nmos w=2.5u l=0.13u ng=1
MM2 IO en_ OI VP sg13_lv_pmos w=2.5u l=0.13u ng=1
.ends

* expanding   symbol:  /foss/designs/CHIP-PLL/schematics/PFD/PFD_NOR.sym # of pins=5
** sym_path: /foss/designs/CHIP-PLL/schematics/PFD/PFD_NOR.sym
** sch_path: /foss/designs/CHIP-PLL/schematics/PFD/PFD_NOR.sch
.subckt PFD_NOR vp A B Out gd
*.PININFO vp:I gd:I B:I A:I Out:O
MM1 Out A net1 vp sg13_lv_pmos w=0.3u l=0.15u ng=1
MM4 net1 B vp vp sg13_lv_pmos w=0.3u l=0.15u ng=1
MM2 Out A gd gd sg13_lv_nmos w=0.3u l=0.15u ng=1
MM3 Out B gd gd sg13_lv_nmos w=0.3u l=0.15u ng=1
.ends

* expanding   symbol:  /foss/designs/CHIP-PLL/schematics/PFD/PFD_inverter_x8.sym # of pins=4
** sym_path: /foss/designs/CHIP-PLL/schematics/PFD/PFD_inverter_x8.sym
** sch_path: /foss/designs/CHIP-PLL/schematics/PFD/PFD_inverter_x8.sch
.subckt PFD_inverter_x8 IN OUT VP GND
*.PININFO IN:I VP:B OUT:O GND:B
MM1 OUT IN GND GND sg13_lv_nmos w=1.20u l=0.13u ng=1
MM2 OUT IN VP VP sg13_lv_pmos w=1.20u l=0.13u ng=1
.ends

* expanding   symbol:  /foss/designs/CHIP-PLL/schematics/divider/schematics/passgate.sym # of pins=6
** sym_path: /foss/designs/CHIP-PLL/schematics/divider/schematics/passgate.sym
** sch_path: /foss/designs/CHIP-PLL/schematics/divider/schematics/passgate.sch
.subckt passgate in_p vp gnd in_n A B
*.PININFO in_n:I in_p:I vp:B gnd:B B:B A:B
MM4 B in_p A vp sg13_lv_pmos w=0.3u l=0.15u ng=1
MM5 B in_n A gnd sg13_lv_nmos w=0.3u l=0.15u ng=1
.ends

* expanding   symbol:  /foss/designs/CHIP-PLL/schematics/divider/schematics/NOR_2in.sym # of pins=5
** sym_path: /foss/designs/CHIP-PLL/schematics/divider/schematics/NOR_2in.sym
** sch_path: /foss/designs/CHIP-PLL/schematics/divider/schematics/NOR_2in.sch
.subckt NOR_2in vp gd A Out B
*.PININFO Out:O gd:B A:I vp:B B:I
MM3 Out A gd gd sg13_lv_nmos w=0.15u l=0.13u ng=1
MM2 Out B net1 vp sg13_lv_pmos w=0.15u l=0.13u ng=1
MM4 net1 A vp vp sg13_lv_pmos w=0.15u l=0.13u ng=1
MM5 Out B gd gd sg13_lv_nmos w=0.15u l=0.13u ng=1
.ends

* expanding   symbol:  /foss/designs/CHIP-PLL/schematics/divider/schematics/div_with_reset.sym # of pins=10
** sym_path: /foss/designs/CHIP-PLL/schematics/divider/schematics/div_with_reset.sym
** sch_path: /foss/designs/CHIP-PLL/schematics/divider/schematics/div_with_reset.sch
.subckt div_with_reset gd vp in reset r_div2 r_div4 r_div8 r_div16 r_div32 r_div64
*.PININFO gd:B in:I vp:B r_div2:O r_div4:O r_div8:O r_div16:O r_div32:O r_div64:O reset:I
x1 net1 vp gd r_div4 net2 r_div4 reset d_flip_flop_reset
x2 net2 vp gd r_div2 in r_div2 reset d_flip_flop_reset
x3 net6 vp gd r_div64 net5 r_div64 reset d_flip_flop_reset
x4 net5 vp gd r_div32 net4 r_div32 reset d_flip_flop_reset
x5 net4 vp gd r_div16 net3 r_div16 reset d_flip_flop_reset
x6 net3 vp gd r_div8 net1 r_div8 reset d_flip_flop_reset
* noconn #net6
.ends

* expanding   symbol:  /foss/designs/CHIP-PLL/schematics/divider/schematics/count_data_check.sym # of pins=15
** sym_path: /foss/designs/CHIP-PLL/schematics/divider/schematics/count_data_check.sym
** sch_path: /foss/designs/CHIP-PLL/schematics/divider/schematics/count_data_check.sch
.subckt count_data_check out VP GND c0 c1 c2 c3 c4 c5 d0 d1 d2 d3 d4 d5
*.PININFO GND:B c0:I VP:B c1:I out:O c2:I c3:I c4:I c5:I d0:I d1:I d3:I d4:I d5:I d2:I
x7 VP GND y0 and012 y1 y2 NAND_3in
x8 VP GND y3 and345 y4 y5 NAND_3in
x9 VP GND and012 out and345 NOR_2in
x1 VP GND d0 y0 c0 XNOR
x2 VP GND d1 y1 c1 XNOR
x3 VP GND d2 y2 c2 XNOR
x4 VP GND d3 y3 c3 XNOR
x5 VP GND d4 y4 c4 XNOR
x6 VP GND d5 y5 c5 XNOR
.ends

* expanding   symbol:  /foss/designs/CHIP-PLL/schematics/divider/schematics/d_flip_flop_reset.sym # of pins=7
** sym_path: /foss/designs/CHIP-PLL/schematics/divider/schematics/d_flip_flop_reset.sym
** sch_path: /foss/designs/CHIP-PLL/schematics/divider/schematics/d_flip_flop_reset.sch
.subckt d_flip_flop_reset q VP GND q_ clk d reset
*.PININFO GND:B clk:I VP:B d:I q:O q_:O reset:I
x2 VP GND q q_ net3 reset NAND_3in_x3
x5 VP GND net3 net4 d reset NAND_3in_x3
x6 VP GND net2 net1 clk reset NAND_3in_x3
x4 VP GND net1 q q_ NAND_2in_x2
x3 VP GND net4 net2 net1 NAND_2in_x2
x1 VP GND net1 net3 clk net4 NAND_3in_x3
.ends

* expanding   symbol:  /foss/designs/CHIP-PLL/schematics/divider/schematics/inverter_x8.sym # of pins=4
** sym_path: /foss/designs/CHIP-PLL/schematics/divider/schematics/inverter_x8.sym
** sch_path: /foss/designs/CHIP-PLL/schematics/divider/schematics/inverter_x8.sch
.subckt inverter_x8 IN OUT VP GND
*.PININFO IN:I VP:B OUT:O GND:B
MM1 OUT IN GND GND sg13_lv_nmos w=0.60u l=0.13u ng=1
MM2 OUT IN VP VP sg13_lv_pmos w=1.20u l=0.13u ng=1
.ends

* expanding   symbol:  /foss/designs/CHIP-PLL/schematics/vco/vco_cell/vco_delay_cell_0.sym # of pins=6
** sym_path: /foss/designs/CHIP-PLL/schematics/vco/vco_cell/vco_delay_cell_0.sym
** sch_path: /foss/designs/CHIP-PLL/schematics/vco/vco_cell/vco_delay_cell_0.sch
.subckt vco_delay_cell_0 vp pgt in out ngt gnd
*.PININFO in:I out:O gnd:B vp:B pgt:B ngt:B
MM23 up pgt vp vp sg13_lv_pmos w=1.2u l=0.14*4u ng=1
MM1 out in up vp sg13_lv_pmos w=1.2u l=0.14*2u ng=1
MM2 out in dn gnd sg13_lv_nmos w=0.8u l=0.14*2u ng=1
MM26 dn ngt gnd gnd sg13_lv_nmos w=0.8u l=0.14*4u ng=1
.ends

* expanding   symbol:  /foss/designs/CHIP-PLL/schematics/vco/vco_cell/vco_delay_cell_1.sym # of pins=6
** sym_path: /foss/designs/CHIP-PLL/schematics/vco/vco_cell/vco_delay_cell_1.sym
** sch_path: /foss/designs/CHIP-PLL/schematics/vco/vco_cell/vco_delay_cell_1.sch
.subckt vco_delay_cell_1 vp pgt in out ngt gnd
*.PININFO in:I out:O gnd:B vp:B pgt:B ngt:B
MM23 up pgt vp vp sg13_lv_pmos w=1.2u l=0.35*4u ng=1
MM24 out in up vp sg13_lv_pmos w=1.2u l=0.35*2u ng=1
MM25 out in dn gnd sg13_lv_nmos w=0.8u l=0.35*2u ng=1
MM26 dn ngt gnd gnd sg13_lv_nmos w=0.8u l=0.35*4u ng=1
.ends

* expanding   symbol:  /foss/designs/CHIP-PLL/schematics/vco/vco_cell/vco_delay_cell_2.sym # of pins=6
** sym_path: /foss/designs/CHIP-PLL/schematics/vco/vco_cell/vco_delay_cell_2.sym
** sch_path: /foss/designs/CHIP-PLL/schematics/vco/vco_cell/vco_delay_cell_2.sch
.subckt vco_delay_cell_2 vp pgt in out ngt gnd
*.PININFO in:I out:O gnd:B vp:B pgt:B ngt:B
MM23 up pgt vp vp sg13_lv_pmos w=1.2u l=1.4*4u ng=1
MM24 out in up vp sg13_lv_pmos w=1.2u l=1.4*2u ng=1
MM25 out in dn gnd sg13_lv_nmos w=0.8u l=1.4*2u ng=1
MM26 dn ngt gnd gnd sg13_lv_nmos w=0.8u l=1.4*4u ng=1
.ends

* expanding   symbol:  /foss/designs/CHIP-PLL/schematics/vco/vco_cell/vco_delay_cell_3.sym # of pins=6
** sym_path: /foss/designs/CHIP-PLL/schematics/vco/vco_cell/vco_delay_cell_3.sym
** sch_path: /foss/designs/CHIP-PLL/schematics/vco/vco_cell/vco_delay_cell_3.sch
.subckt vco_delay_cell_3 vp pgt in out ngt gnd
*.PININFO in:I out:O gnd:B vp:B pgt:B ngt:B
MM23 up pgt vp vp sg13_lv_pmos w=1.2u l=4.25*4u ng=1
MM24 out in up vp sg13_lv_pmos w=1.2u l=4.25*2u ng=1
MM25 out in dn gnd sg13_lv_nmos w=0.8u l=4.25*2u ng=1
MM26 dn ngt gnd gnd sg13_lv_nmos w=0.8u l=4.25*4u ng=1
.ends

* expanding   symbol:  /foss/designs/CHIP-PLL/schematics/vco/vco_cell/vco_delay_cell_4.sym # of pins=6
** sym_path: /foss/designs/CHIP-PLL/schematics/vco/vco_cell/vco_delay_cell_4.sym
** sch_path: /foss/designs/CHIP-PLL/schematics/vco/vco_cell/vco_delay_cell_4.sch
.subckt vco_delay_cell_4 vp pgt in out ngt gnd
*.PININFO in:I out:O gnd:B vp:B pgt:B ngt:B
MM23 up pgt vp vp sg13_lv_pmos w=1.2u l=7.5*4u ng=1
MM24 out in up vp sg13_lv_pmos w=1.2u l=7.5*2u ng=1
MM25 out in dn gnd sg13_lv_nmos w=0.8u l=7.5*2u ng=1
MM26 dn ngt gnd gnd sg13_lv_nmos w=0.8u l=7.5*4u ng=1
.ends

* expanding   symbol:  /foss/designs/CHIP-PLL/schematics/divider/schematics/VCO_MUX.sym # of pins=13
** sym_path: /foss/designs/CHIP-PLL/schematics/divider/schematics/VCO_MUX.sym
** sch_path: /foss/designs/CHIP-PLL/schematics/divider/schematics/VCO_MUX.sch
.subckt VCO_MUX gd VP VCO_in VCO2_in VCO3_in VCO4_in VCO5_in VCO_sel VCO2_sel VCO3_sel VCO4_sel VCO5_sel out
*.PININFO gd:B VP:B VCO2_in:I VCO3_in:I VCO4_in:I VCO5_in:I out:O VCO_in:I VCO2_sel:I VCO3_sel:I VCO_sel:I VCO4_sel:I VCO5_sel:I
x2 VCO_sel net1 VP gd inverter_dek
x3 net2 VP gd VCO2_sel VCO2_in out passgate_scaled
x4 VCO2_sel net2 VP gd inverter_dek
x5 net3 VP gd VCO3_sel VCO3_in out passgate_scaled
x6 VCO3_sel net3 VP gd inverter_dek
x7 net4 VP gd VCO4_sel VCO4_in out passgate_scaled
x8 VCO4_sel net4 VP gd inverter_dek
x9 net5 VP gd VCO5_sel VCO5_in out passgate_scaled
x10 VCO5_sel net5 VP gd inverter_dek
x1 net1 VP gd VCO_sel VCO_in out vco_passgate_mux
.ends

* expanding   symbol:  /foss/designs/CHIP-PLL/schematics/divider/schematics/VCO_decoder_cells.sym # of pins=19
** sym_path: /foss/designs/CHIP-PLL/schematics/divider/schematics/VCO_decoder_cells.sym
** sch_path: /foss/designs/CHIP-PLL/schematics/divider/schematics/VCO_decoder_cells.sch
.subckt VCO_decoder_cells gd VP c0 c1 c2 f0 f1 f2 f3 f4 f5 VCO_sel VCO2_11_sel VCO2_5_sel VCO3_11_sel VCO3_5_sel VCO4_11_sel
+ VCO4_5_sel VCO5_11_sel
*.PININFO gd:B VP:B c1:I c2:I f0:I f1:I c0:I VCO2_11_sel:O VCO2_5_sel:O VCO_sel:O VCO3_11_sel:O VCO3_5_sel:O VCO4_11_sel:O
*+ VCO4_5_sel:O VCO5_11_sel:O f2:I f3:I f4:I f5:I
x6 gd VP c0 c1 c2 000 001 010 011 100 101 110 111 3bit_to_8_outs
x7 after_000011 after_000011_n 000000 f5_n gd after_000111 VP after_000111_n after_001111 after_001111_n f1 f2 f3 f4 f5 000000_n
+ f0 row_section_decoding
x4 gd VP 110 after_001111_n after_000111 111 000000_n 101 after_000011 after_001111 f5_n after_000111_n 010 100 after_000011_n 011
+ f5 VCO2_5_sel VCO2_11_sel VCO2_selection
x2 gd VP 000000 000 000000_n after_001111_n 010 after_000011_n 011 001 after_000011 after_000111_n VCO4_11_sel VCO4_5_sel
+ VCO4_selection
x1 VCO_sel after_000111 111 gd VP after_001111 110 101 f5 VCO_selection
x5 gd VP f5_n 000000 after_000111_n 001 000000_n 110 011 101 000 after_000011_n after_000111 after_001111 100 after_001111_n
+ after_000011 010 VCO3_11_sel VCO3_5_sel f5 VCO3_selection
x3 gd VP VCO5_11_sel 000 after_000011_n 010 000000 VCO5_selection
.ends

* expanding   symbol:  /foss/designs/CHIP-PLL/schematics/divider/schematics/XNOR.sym # of pins=5
** sym_path: /foss/designs/CHIP-PLL/schematics/divider/schematics/XNOR.sym
** sch_path: /foss/designs/CHIP-PLL/schematics/divider/schematics/XNOR.sch
.subckt XNOR VP GND a y b
*.PININFO y:O GND:B a:I VP:B b:I
MM1 y a net1 GND sg13_lv_nmos w=0.15u l=0.13u ng=1
MM3 net1 _b GND GND sg13_lv_nmos w=0.15u l=0.13u ng=1
MM2 net2 a VP VP sg13_lv_pmos w=0.15u l=0.13u ng=1 m=4
MM4 net3 _a VP VP sg13_lv_pmos w=0.15u l=0.13u ng=1 m=4
MM5 y _a net4 GND sg13_lv_nmos w=0.15u l=0.13u ng=1
MM6 net4 b GND GND sg13_lv_nmos w=0.15u l=0.13u ng=1
MM7 y b net2 VP sg13_lv_pmos w=0.15u l=0.13u ng=1 m=4
MM8 y _b net3 VP sg13_lv_pmos w=0.15u l=0.13u ng=1 m=4
x1 a _a VP GND inverter
x2 b _b VP GND inverter
.ends

* expanding   symbol:  /foss/designs/CHIP-PLL/schematics/divider/schematics/NAND_3in_x3.sym # of pins=6
** sym_path: /foss/designs/CHIP-PLL/schematics/divider/schematics/NAND_3in_x3.sym
** sch_path: /foss/designs/CHIP-PLL/schematics/divider/schematics/NAND_3in_x3.sch
.subckt NAND_3in_x3 VP GND a y b c
*.PININFO y:O GND:B a:I VP:B b:I c:I
MM1 y a net2 GND sg13_lv_nmos w=1.20u l=0.13u ng=1
MM5 y b VP VP sg13_lv_pmos w=0.3u l=0.13u ng=1
MM3 net2 b net1 GND sg13_lv_nmos w=1.20u l=0.13u ng=1
MM4 net1 c GND GND sg13_lv_nmos w=1.20u l=0.13u ng=1
MM2 y a VP VP sg13_lv_pmos w=0.3u l=0.13u ng=1
MM6 y c VP VP sg13_lv_pmos w=0.3u l=0.13u ng=1
.ends

* expanding   symbol:  /foss/designs/CHIP-PLL/schematics/divider/schematics/inverter_dek.sym # of pins=4
** sym_path: /foss/designs/CHIP-PLL/schematics/divider/schematics/inverter_dek.sym
** sch_path: /foss/designs/CHIP-PLL/schematics/divider/schematics/inverter_dek.sch
.subckt inverter_dek IN OUT VP GND
*.PININFO IN:I VP:B OUT:O GND:B
MM1 OUT IN GND GND sg13_lv_nmos w=0.15u l=0.13u ng=1
MM2 OUT IN VP VP sg13_lv_pmos w=0.15u l=0.13u ng=1
.ends

* expanding   symbol:  /foss/designs/CHIP-PLL/schematics/divider/schematics/passgate_scaled.sym # of pins=6
** sym_path: /foss/designs/CHIP-PLL/schematics/divider/schematics/passgate_scaled.sym
** sch_path: /foss/designs/CHIP-PLL/schematics/divider/schematics/passgate_scaled.sch
.subckt passgate_scaled en_ VP GND en IO OI
*.PININFO OI:B IO:B VP:B GND:B en_:I en:I
MM1 IO en OI GND sg13_lv_nmos w=0.15u l=0.13u ng=1
MM2 IO en_ OI VP sg13_lv_pmos w=0.15u l=0.13u ng=1
.ends

* expanding   symbol:  /foss/designs/CHIP-PLL/schematics/divider/schematics/vco_passgate_mux.sym # of pins=6
** sym_path: /foss/designs/CHIP-PLL/schematics/divider/schematics/vco_passgate_mux.sym
** sch_path: /foss/designs/CHIP-PLL/schematics/divider/schematics/vco_passgate_mux.sch
.subckt vco_passgate_mux en_ VP GND en IO OI
*.PININFO OI:B IO:B VP:B GND:B en_:I en:I
MM1 IO en OI GND sg13_lv_nmos w=2.5u l=0.13u ng=1
MM2 IO en_ OI VP sg13_lv_pmos w=2.5u l=0.13u ng=1
.ends

* expanding   symbol:  /foss/designs/CHIP-PLL/schematics/divider/schematics/3bit_to_8_outs.sym # of pins=13
** sym_path: /foss/designs/CHIP-PLL/schematics/divider/schematics/3bit_to_8_outs.sym
** sch_path: /foss/designs/CHIP-PLL/schematics/divider/schematics/3bit_to_8_outs.sch
.subckt 3bit_to_8_outs gd VP c0 c1 c2 coarse_0 coarse_1 coarse_2 coarse_3 coarse_4 coarse_5 coarse_6 coarse_7
*.PININFO gd:B VP:B c1:I c2:I c0:I coarse_1:O coarse_2:O coarse_0:O coarse_3:O coarse_4:O coarse_5:O coarse_6:O coarse_7:O
x1 c0 c0_n VP gd inverter_dek
x4 VP gd c0_n net1 c1_n c2_n NAND_3in_dek
x2 c1 c1_n VP gd inverter_dek
x3 c2 c2_n VP gd inverter_dek
x8 net4 coarse_3 VP gd inverter_dek
x9 net3 coarse_2 VP gd inverter_dek
x10 net2 coarse_1 VP gd inverter_dek
x11 net1 coarse_0 VP gd inverter_dek
x12 net8 coarse_7 VP gd inverter_dek
x13 net7 coarse_6 VP gd inverter_dek
x15 net6 coarse_5 VP gd inverter_dek
x16 net5 coarse_4 VP gd inverter_dek
x5 VP gd c0 net2 c1_n c2_n NAND_3in_dek
x6 VP gd c0_n net3 c1 c2_n NAND_3in_dek
x7 VP gd c0 net4 c1 c2_n NAND_3in_dek
x14 VP gd c0 net8 c1 c2 NAND_3in_dek
x17 VP gd c0_n net7 c1 c2 NAND_3in_dek
x18 VP gd c0 net6 c1_n c2 NAND_3in_dek
x19 VP gd c0_n net5 c1_n c2 NAND_3in_dek
.ends

* expanding   symbol:  /foss/designs/CHIP-PLL/schematics/divider/schematics/row_section_decoding.sym # of pins=17
** sym_path: /foss/designs/CHIP-PLL/schematics/divider/schematics/row_section_decoding.sym
** sch_path: /foss/designs/CHIP-PLL/schematics/divider/schematics/row_section_decoding.sch
.subckt row_section_decoding after_000011 after_000011_n 000000 f5_n gd after_000111 VP after_000111_n after_001111 after_001111_n
+ f1 f2 f3 f4 f5 000000_n f0
*.PININFO f1:I f2:I f3:I f4:I f5:I gd:B VP:B after_000011_n:O 000000:O after_000011:O f5_n:O after_000111:O after_000111_n:O
*+ after_001111:O after_001111_n:O 000000_n:O f0:I
x2 VP gd f2 net1 f3 NOR_2in_dek
x3 VP gd f4 net2 f5 NOR_2in_dek
x4 VP gd f3 after_000111_n f4 f5 NOR_3in_dek
x5 VP gd f4 after_001111_n f5 NOR_2in_dek
x6 VP gd net1 after_000011 net2 NAND_2in_dek
x7 after_000111_n after_000111 VP gd inverter_dek
x8 after_001111_n after_001111 VP gd inverter_dek
x9 after_000011 after_000011_n VP gd inverter_dek
x10 f5 f5_n VP gd inverter_dek
x11 VP gd f2 net3 f3 NOR_2in_dek
x27 VP gd f4 net4 f5 NOR_2in_dek
x29 VP gd f1 net5 f0 NOR_2in_dek
x31 VP gd net3 000000_n net4 net5 NAND_3in_dek
x33 000000_n 000000 VP gd inverter_dek
.ends

* expanding   symbol:  /foss/designs/CHIP-PLL/schematics/divider/schematics/VCO2_selection.sym # of pins=19
** sym_path: /foss/designs/CHIP-PLL/schematics/divider/schematics/VCO2_selection.sym
** sch_path: /foss/designs/CHIP-PLL/schematics/divider/schematics/VCO2_selection.sch
.subckt VCO2_selection gd VP 110 after_001111_n after_000111 111 000000_n 101 after_000011 after_001111 f5_n after_000111_n 010
+ 100 after_000011_n 011 f5 VCO2_5_sel VCO2_11_sel
*.PININFO gd:B VP:B after_001111_n:I after_000111:I 000000_n:I 110:I VCO2_11_sel:O VCO2_5_sel:O 101:I f5_n:I 100:I f5:I 011:I
*+ after_000111_n:I after_000011:I 111:I after_000011_n:I 010:I after_001111:I
x15 VP gd 110 net1 after_001111_n after_000111 NAND_3in_dek
x16 VP gd 100 net3 f5 NAND_2in_dek
x19 VP gd net1 VCO2_5_sel net2 net3 net4 NAND_4in_dek
x22 net9 net10 VP gd inverter_dek
x1 VP gd 101 net2 after_000111 f5_n NAND_3in_dek
x2 VP gd 111 net4 after_000011 after_000111_n NAND_3in_dek
x3 VP gd 010 net11 f5 NAND_2in_dek
x4 VP gd 011 net6 after_001111 NAND_2in_dek
x5 VP gd 111 net7 after_000011_n NAND_2in_dek
x6 VP gd 100 net5 after_000111 f5_n NAND_3in_dek
x7 VP gd 101 net8 after_000011 after_000111_n NAND_3in_dek
x8 VP gd 110 net12 after_000111_n 000000_n NAND_3in_dek
x9 VP gd net10 VCO2_11_sel net8 net12 net7 NAND_4in_dek
x10 VP gd net11 net9 net6 net5 NAND_3in_dek
.ends

* expanding   symbol:  /foss/designs/CHIP-PLL/schematics/divider/schematics/VCO4_selection.sym # of pins=14
** sym_path: /foss/designs/CHIP-PLL/schematics/divider/schematics/VCO4_selection.sym
** sch_path: /foss/designs/CHIP-PLL/schematics/divider/schematics/VCO4_selection.sch
.subckt VCO4_selection gd VP 000000 000 000000_n after_001111_n 010 after_000011_n 011 001 after_000011 after_000111_n VCO4_11_sel
+ VCO4_5_sel
*.PININFO gd:B VP:B 000000_n:I VCO4_5_sel:O VCO4_11_sel:O 000:I 000000:I after_001111_n:I 010:I after_000011_n:I 011:I 001:I
*+ after_000011:I after_000111_n:I
x80 VP gd 000 net1 after_000011 after_001111_n NAND_3in_dek
x86 VP gd 001 net4 after_000111_n after_000011 NAND_3in_dek
x91 net5 VCO4_11_sel VP gd inverter_dek
x42 VP gd net1 VCO4_5_sel net4 net2 net3 NAND_4in_dek
x46 VP gd 011 net3 000000 NAND_2in_dek
x1 VP gd 010 net2 after_000011_n 000000_n NAND_3in_dek
x2 VP gd 001 net5 after_000011_n NAND_2in_dek
.ends

* expanding   symbol:  /foss/designs/CHIP-PLL/schematics/divider/schematics/VCO_selection.sym # of pins=9
** sym_path: /foss/designs/CHIP-PLL/schematics/divider/schematics/VCO_selection.sym
** sch_path: /foss/designs/CHIP-PLL/schematics/divider/schematics/VCO_selection.sch
.subckt VCO_selection VCO_sel after_000111 111 gd VP after_001111 110 101 f5
*.PININFO gd:B VP:B after_000111:I 111:I after_001111:I 110:I 101:I f5:I VCO_sel:O
x11 VP gd after_000111 net1 111 NAND_2in_dek
x14 VP gd net1 VCO_sel net2 net3 NAND_3in_dek
x1 VP gd after_001111 net2 110 NAND_2in_dek
x2 VP gd 101 net3 f5 NAND_2in_dek
.ends

* expanding   symbol:  /foss/designs/CHIP-PLL/schematics/divider/schematics/VCO3_selection.sym # of pins=21
** sym_path: /foss/designs/CHIP-PLL/schematics/divider/schematics/VCO3_selection.sym
** sch_path: /foss/designs/CHIP-PLL/schematics/divider/schematics/VCO3_selection.sch
.subckt VCO3_selection gd VP f5_n 000000 after_000111_n 001 000000_n 110 011 101 000 after_000011_n after_000111 after_001111 100
+ after_001111_n after_000011 010 VCO3_11_sel VCO3_5_sel f5
*.PININFO gd:B VP:B 000000_n:I 000000:I VCO3_11_sel:O VCO3_5_sel:O 011:I after_000111:I after_001111_n:I 010:I 001:I 101:I f5_n:I
*+ 100:I after_000011:I after_000011_n:I 110:I 000:I after_000111_n:I after_001111:I f5:I
x47 VP gd 010 net2 after_000111 f5_n NAND_3in_dek
x50 VP gd 001 net3 f5 NAND_2in_dek
x34 VP gd net12 VCO3_5_sel net4 net13 net5 NAND_4in_dek
x35 net11 net12 VP gd inverter_dek
x39 net14 net15 VP gd inverter_dek
x1 VP gd net3 net11 net2 net1 NAND_3in_dek
x2 VP gd 011 net1 after_000111 after_001111_n NAND_3in_dek
x3 VP gd 100 net4 000000_n after_000111_n NAND_3in_dek
x4 VP gd 101 net13 after_000011_n NAND_2in_dek
x5 VP gd 110 net5 000000 NAND_2in_dek
x6 VP gd 000 net8 after_001111 NAND_2in_dek
x7 VP gd 100 net9 000000 NAND_2in_dek
x8 VP gd net8 net14 net7 NAND_2in_dek
x9 VP gd 001 net7 after_000111 f5_n NAND_3in_dek
x10 VP gd 010 net10 after_000011 after_000111_n NAND_3in_dek
x11 VP gd 011 net6 after_000111_n 000000_n NAND_3in_dek
x12 VP gd net15 VCO3_11_sel net10 net6 net9 NAND_4in_dek
.ends

* expanding   symbol:  /foss/designs/CHIP-PLL/schematics/divider/schematics/VCO5_selection.sym # of pins=7
** sym_path: /foss/designs/CHIP-PLL/schematics/divider/schematics/VCO5_selection.sym
** sch_path: /foss/designs/CHIP-PLL/schematics/divider/schematics/VCO5_selection.sch
.subckt VCO5_selection gd VP VCO5_11_sel 000 after_000011_n 010 000000
*.PININFO gd:B VP:B VCO5_11_sel:O 000:I after_000011_n:I 010:I 000000:I
x1 VP gd 010 net2 000000 NAND_2in_dek
x2 VP gd net1 VCO5_11_sel net2 NAND_2in_dek
x3 VP gd 000 net1 after_000011_n NAND_2in_dek
.ends

* expanding   symbol:  /foss/designs/CHIP-PLL/schematics/divider/schematics/NAND_3in_dek.sym # of pins=6
** sym_path: /foss/designs/CHIP-PLL/schematics/divider/schematics/NAND_3in_dek.sym
** sch_path: /foss/designs/CHIP-PLL/schematics/divider/schematics/NAND_3in_dek.sch
.subckt NAND_3in_dek VP GND a y b c
*.PININFO y:O GND:B a:I VP:B b:I c:I
MM1 y a net2 GND sg13_lv_nmos w=0.15u l=0.13u ng=1
MM3 net2 b net1 GND sg13_lv_nmos w=0.15u l=0.13u ng=1
MM4 net1 c GND GND sg13_lv_nmos w=0.15u l=0.13u ng=1
MM7 y c VP VP sg13_lv_pmos w=0.15u l=0.13u ng=1
MM2 y a VP VP sg13_lv_pmos w=0.15u l=0.13u ng=1
MM5 y b VP VP sg13_lv_pmos w=0.15u l=0.13u ng=1
.ends

* expanding   symbol:  /foss/designs/CHIP-PLL/schematics/divider/schematics/NOR_2in_dek.sym # of pins=5
** sym_path: /foss/designs/CHIP-PLL/schematics/divider/schematics/NOR_2in_dek.sym
** sch_path: /foss/designs/CHIP-PLL/schematics/divider/schematics/NOR_2in_dek.sch
.subckt NOR_2in_dek vp gd A Out B
*.PININFO Out:O gd:B A:I vp:B B:I
MM3 Out A gd gd sg13_lv_nmos w=0.15u l=0.13u ng=1
MM2 Out B net1 vp sg13_lv_pmos w=0.15u l=0.13u ng=1
MM4 net1 A vp vp sg13_lv_pmos w=0.15u l=0.13u ng=1
MM5 Out B gd gd sg13_lv_nmos w=0.15u l=0.13u ng=1
.ends

* expanding   symbol:  /foss/designs/CHIP-PLL/schematics/divider/schematics/NOR_3in_dek.sym # of pins=6
** sym_path: /foss/designs/CHIP-PLL/schematics/divider/schematics/NOR_3in_dek.sym
** sch_path: /foss/designs/CHIP-PLL/schematics/divider/schematics/NOR_3in_dek.sch
.subckt NOR_3in_dek VP GND a y b c
*.PININFO y:O GND:B a:I VP:B b:I c:I
MM3 y a GND GND sg13_lv_nmos w=0.15u l=0.13u ng=1
MM2 y b net2 VP sg13_lv_pmos w=0.15u l=0.13u ng=1
MM4 net1 a VP VP sg13_lv_pmos w=0.15u l=0.13u ng=1
MM5 y b GND GND sg13_lv_nmos w=0.15u l=0.13u ng=1
MM1 y c GND GND sg13_lv_nmos w=0.15u l=0.13u ng=1
MM6 net2 c net1 VP sg13_lv_pmos w=0.15u l=0.13u ng=1
.ends

* expanding   symbol:  /foss/designs/CHIP-PLL/schematics/divider/schematics/NAND_2in_dek.sym # of pins=5
** sym_path: /foss/designs/CHIP-PLL/schematics/divider/schematics/NAND_2in_dek.sym
** sch_path: /foss/designs/CHIP-PLL/schematics/divider/schematics/NAND_2in_dek.sch
.subckt NAND_2in_dek VP GND a y b
*.PININFO y:O GND:B a:I VP:B b:I
MM1 y a net1 GND sg13_lv_nmos w=0.15u l=0.13u ng=1
MM3 net1 b GND GND sg13_lv_nmos w=0.15u l=0.13u ng=1
MM2 y b VP VP sg13_lv_pmos w=0.15u l=0.13u ng=1
MM4 y a VP VP sg13_lv_pmos w=0.15u l=0.13u ng=1
.ends

* expanding   symbol:  /foss/designs/CHIP-PLL/schematics/divider/schematics/NAND_4in_dek.sym # of pins=7
** sym_path: /foss/designs/CHIP-PLL/schematics/divider/schematics/NAND_4in_dek.sym
** sch_path: /foss/designs/CHIP-PLL/schematics/divider/schematics/NAND_4in_dek.sch
.subckt NAND_4in_dek VP GND a y b c d
*.PININFO y:O GND:B a:I VP:B b:I c:I d:I
MM1 y a net2 GND sg13_lv_nmos w=0.15u l=0.13u ng=1
MM3 net3 c net1 GND sg13_lv_nmos w=0.15u l=0.13u ng=1
MM4 net1 d GND GND sg13_lv_nmos w=0.15u l=0.13u ng=1
MM7 y c VP VP sg13_lv_pmos w=0.15u l=0.13u ng=1
MM2 y a VP VP sg13_lv_pmos w=0.15u l=0.13u ng=1
MM5 y b VP VP sg13_lv_pmos w=0.15u l=0.13u ng=1
MM6 y d VP VP sg13_lv_pmos w=0.15u l=0.13u ng=1
MM8 net2 b net3 GND sg13_lv_nmos w=0.15u l=0.13u ng=1
.ends
