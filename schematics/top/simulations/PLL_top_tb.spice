** sch_path: /foss/designs/CHIP-PLL/schematics/top/PLL_top_tb.sch
**.subckt PLL_top_tb
Vref clk_ref GND dc 0 ac 0 pulse(0 {Vph} {T/2} 10n 10n {T/2} {T})
Vp Vp GND dc {Vp}
Vph Vph GND dc {Vph}
C1 out GND 1p
V8 d4 GND 0
V9 d5 GND 0
V11 d0 GND 1.2
V10 d1 GND 1.2
V12 d2 GND 0
V7 d3 GND 0
V5 a1 GND 1.2
V6 a0 GND 1.2
V13 a2 GND 1.2
xPLL Vp Vph GND clk_ref out d5 d3 a1 d2 d1 d0 d4 a2 a0 rst PLL_top
Vp1 rst GND dc 0 ac 0 PULSE({Vp} 0 63u 1p 1p 1 2
**** begin user architecture code
 .lib cornerMOSlv.lib mos_tt
.lib cornerMOShv.lib mos_tt
.lib cornerRES.lib res_typ

.temp=25
.param T = 31.25u

.param Vp=1.2
.param Vph=3.3
.control
save v(rst) v(out) v(xPLL.cvco) v(xPLL.cref) v(xPLL.UP) v(xPLL.DOWN) v(xPLL.vout_preRC) v(xPLL.vco_out_prebuff) v(xPLL.vout_aftRC) v(xPLL.vco_out_buffered)
tran 0.05n 1m

meas tran t1 WHEN v(out)=1.65 RISE=1 FROM=0.75m
meas tran t2 WHEN v(out)=1.65 RISE=2 FROM=0.75m
meas tran period PARAM='t2-t1'
meas tran freq PARAM='1/period'

write PLL_top_tb.raw
.endc

**** end user architecture code
**.ends

* expanding   symbol:  PLL_top.sym # of pins=15
** sym_path: /foss/designs/CHIP-PLL/schematics/top/PLL_top.sym
** sch_path: /foss/designs/CHIP-PLL/schematics/top/PLL_top.sch
.subckt PLL_top vp vph gd clk_ref out d5 d3 a1 d2 d1 d0 d4 a2 a0 rst
*.ipin clk_ref
*.opin out
*.ipin gd
*.ipin vph
*.ipin vp
*.ipin a0
*.ipin a1
*.ipin a2
*.ipin d0
*.ipin d1
*.ipin d2
*.ipin d3
*.ipin d4
*.ipin d5
*.ipin rst
xRC vout_aftRC vout_preRC gd RC_filter
x2 vp clk_ref cref gd buffer_hv
xPFD gd vp cref UP DOWN cvco rst PFD_cell_2
xCP vp UP vout_preRC DOWN rst_n gd charge_pump_cell
xBUF vp vco_out_prebuff vco_out_buffered gd buf
xDiv gd vp vco_out_prebuff d0 d1 d2 d3 d4 d5 a0 a1 a2 cvco rst Divider_top
xVCO vp gd vco_out_prebuff vout_aftRC vco_core_0
x5 net2 vp gd net1 vco_out_buffered net1 d_flip_flop
xLS vph out vp net2 gd level_shifter
x10 rst rst_n vp gd inverter_x4
.ends

* expanding   symbol:  /foss/designs/CHIP-PLL/schematics/misc/RC_filter.sym # of pins=3
** sym_path: /foss/designs/CHIP-PLL/schematics/misc/RC_filter.sym
** sch_path: /foss/designs/CHIP-PLL/schematics/misc/RC_filter.sch
.subckt RC_filter out in gd
*.ipin in
*.opin out
*.ipin gd
XM1 gd out gd gd sg13_lv_nmos w=10u l=10u ng=1 m=1 mm_ok=1
XM3 gd out gd gd sg13_lv_nmos w=10u l=10u ng=1 m=1 mm_ok=1
XM4 gd out gd gd sg13_lv_nmos w=10u l=10u ng=1 m=1 mm_ok=1
XR2 out in gd rppd w=0.5e-6 l=0.5e-6 m=1 b=0 mm_ok=1
.ends

* expanding   symbol:  /foss/designs/CHIP-PLL/schematics/misc/buffer_hv.sym # of pins=4
** sym_path: /foss/designs/CHIP-PLL/schematics/misc/buffer_hv.sym
** sch_path: /foss/designs/CHIP-PLL/schematics/misc/buffer_hv.sch
.subckt buffer_hv vph in out gd
*.ipin in
*.opin out
*.ipin vph
*.ipin gd
XM1 buf_stage_1 in vph vph sg13_hv_pmos w=1u l=0.45u ng=1 m=1 mm_ok=1
XM2 buf_stage_1 in gd gd sg13_hv_nmos w=1u l=0.45u ng=1 m=1 mm_ok=1
XM3 out buf_stage_1 vph vph sg13_hv_pmos w=1u l=0.45u ng=1 m=1 mm_ok=1
XM4 out buf_stage_1 gd gd sg13_hv_nmos w=1u l=0.45u ng=1 m=1 mm_ok=1
.ends

* expanding   symbol:  /foss/designs/CHIP-PLL/schematics/PFD/PFD_cell_2.sym # of pins=7
** sym_path: /foss/designs/CHIP-PLL/schematics/PFD/PFD_cell_2.sym
** sch_path: /foss/designs/CHIP-PLL/schematics/PFD/PFD_cell_2.sch
.subckt PFD_cell_2 gnd vp cRef UP DOWN cVco rst
*.iopin gnd
*.iopin vp
*.ipin cRef
*.ipin cVco
*.ipin rst
*.opin UP
*.opin DOWN
x7 vp gnd pre_up post_nand pre_down NAND_2in
* noconn #net1
* noconn #net4
x9 rst reset_n vp gnd inverter_x4
xflipFlopCref cRef flip_flop_reset vp pre_up net1 vp gnd PFD_flip_flop
xFlipFlopCvco cVco flip_flop_reset vp pre_down net4 vp gnd PFD_flip_flop
XM4 UP rst gnd gnd sg13_lv_nmos w=0.45u l=0.15u ng=1 m=1 mm_ok=1
XM5 DOWN rst gnd gnd sg13_lv_nmos w=0.45u l=0.15u ng=1 m=1 mm_ok=1
x4 net6 UP vp gnd inverter_x4
x6 net5 DOWN vp gnd inverter_x4
x2 pre_up net6 vp gnd inverter_x4
x5 pre_down net5 vp gnd inverter_x4
x1 rst vp vp flip_flop_reset gnd reset_n PFD_passgate
x3 reset_n vp flip_flop_reset net3 gnd rst PFD_passgate
x8 gnd vp net3 net2 PFD_buffor
x11 post_nand net2 vp gnd inverter_x4
.ends

* expanding   symbol:  /foss/designs/CHIP-PLL/schematics/charge_pump/charge_pump_cell.sym # of pins=6
** sym_path: /foss/designs/CHIP-PLL/schematics/charge_pump/charge_pump_cell.sym
** sch_path: /foss/designs/CHIP-PLL/schematics/charge_pump/charge_pump_cell.sch
.subckt charge_pump_cell vp UP vout DN rst gd
*.iopin UP
*.iopin DN
*.iopin gd
*.iopin vp
*.opin vout
*.iopin rst
XM12 net1 net6 vp vp sg13_lv_pmos w=1u l=0.6u ng=1 m=1 mm_ok=1
XM3 net8 net15 vp vp sg13_lv_pmos w=1.6u l=0.6u ng=1 m=1 mm_ok=1
XM2 net5 net15 vp vp sg13_lv_pmos w=1.65u l=0.6u ng=1 m=1 mm_ok=1
XM7 net3 bias net5 vp sg13_lv_pmos w=1.6u l=0.6u ng=1 m=1 mm_ok=1
XM11 net9 UP vp vp sg13_lv_pmos w=1u l=0.6u ng=1 m=1 mm_ok=1
XM4 net9 UP gd gd sg13_lv_nmos w=1u l=0.6u ng=1 m=1 mm_ok=1
XM5 vout net9 net3 vp sg13_lv_pmos w=1u l=0.6u ng=1 m=1 mm_ok=1
XM13 vout DN net13 gd sg13_lv_nmos w=1u l=0.6u ng=1 m=1 mm_ok=1
XM14 net15 bias net8 vp sg13_lv_pmos w=1.6u l=0.6u ng=1 m=1 mm_ok=1
XM1 net15 bias net10 gd sg13_lv_nmos w=1.6u l=0.6u ng=1 m=1 mm_ok=1
XM17 net1 bias net2 gd sg13_lv_nmos w=4.8u l=0.6u ng=1 m=1 mm_ok=1
XM9 net2 net1 gd gd sg13_lv_nmos w=4.8u l=0.6u ng=1 m=1 mm_ok=1
XM10 net10 bias net7 gd sg13_lv_nmos w=1.6u l=0.6u ng=1 m=1 mm_ok=1
XM6 net7 net1 gd gd sg13_lv_nmos w=1.6u l=0.6u ng=1 m=1 mm_ok=1
XM8 net4 net1 gd gd sg13_lv_nmos w=1.6u l=0.6u ng=1 m=1 mm_ok=1
XM15 net13 bias net4 gd sg13_lv_nmos w=1.6u l=0.6u ng=1 m=1 mm_ok=1
x1 vp gd bias vbias
x2 vp net6 gd curr_source
XM16 vtest vtest vp vp sg13_lv_pmos w=1.8u l=1.8u ng=1 m=1 mm_ok=1
XM18 vtest vtest 0 0 sg13_lv_nmos w=0.6u l=1.8u ng=1 m=1 mm_ok=1
XM19 vout rst vtest vp sg13_lv_pmos w=1.8u l=0.6u ng=1 m=1 mm_ok=1
.ends

* expanding   symbol:  /foss/designs/CHIP-PLL/schematics/buf/buf.sym # of pins=4
** sym_path: /foss/designs/CHIP-PLL/schematics/buf/buf.sym
** sch_path: /foss/designs/CHIP-PLL/schematics/buf/buf.sch
.subckt buf VDD INPUT OUT GND
*.ipin INPUT
*.iopin VDD
*.iopin GND
*.opin OUT
XM1 net1 INPUT GND GND sg13_lv_nmos w=0.5u l=0.13u ng=1 m=1 mm_ok=1
XM2 net1 INPUT VDD VDD sg13_lv_pmos w=0.75u l=0.13u ng=1 m=1 mm_ok=1
XM3 net2 net1 GND GND sg13_lv_nmos w=1.5u l=0.13u ng=1 m=1 mm_ok=1
XM4 net2 net1 VDD VDD sg13_lv_pmos w=2.25u l=0.13u ng=1 m=1 mm_ok=1
XM5 net3 net2 GND GND sg13_lv_nmos w=4.5u l=0.13u ng=1 m=1 mm_ok=1
XM6 net3 net2 VDD VDD sg13_lv_pmos w=6.75u l=0.13u ng=1 m=1 mm_ok=1
XM7 OUT net3 GND GND sg13_lv_nmos w=4.5u l=0.13u ng=1 m=3 mm_ok=1
XM8 OUT net3 VDD VDD sg13_lv_pmos w=6.75u l=0.13u ng=1 m=3 mm_ok=1
.ends

* expanding   symbol:  /foss/designs/CHIP-PLL/schematics/divider/schematics/Divider_top.sym # of pins=14
** sym_path: /foss/designs/CHIP-PLL/schematics/divider/schematics/Divider_top.sym
** sch_path: /foss/designs/CHIP-PLL/schematics/divider/schematics/Divider_top.sch
.subckt Divider_top gd VP clk d0 d1 d2 d3 d4 d5 a0 a1 a2 out_div rst
*.iopin gd
*.ipin clk
*.iopin VP
*.opin out_div
*.ipin d0
*.ipin d1
*.ipin d2
*.ipin d3
*.ipin d4
*.ipin d5
*.ipin a0
*.ipin a1
*.ipin a2
*.ipin rst
x1 gd VP clk div2 div4 div8 div16 div32 div64 div128 2Div
x2 gd VP a0 MUX_out clk div2 div4 div8 div16 div32 div64 a1 div128 a2 MUX_8to1
x3 gd VP MUX_out rst d0 d1 d2 d3 d4 d5 out_div pdiv
.ends

* expanding   symbol:  /foss/designs/CHIP-PLL/schematics/vco/vco_cell/vco_core_0.sym # of pins=4
** sym_path: /foss/designs/CHIP-PLL/schematics/vco/vco_cell/vco_core_0.sym
** sch_path: /foss/designs/CHIP-PLL/schematics/vco/vco_cell/vco_core_0.sch
.subckt vco_core_0 vp gnd out in
*.ipin in
*.iopin vp
*.opin out
*.iopin gnd
XM1 pgt in gnd gnd sg13_lv_nmos w=0.8u l=0.16*4u ng=1 m=1 mm_ok=1
XM2 pgt pgt vp vp sg13_lv_pmos w=1.2u l=0.16*4u ng=1 m=1 mm_ok=1
x1 vp pgt out net1 in gnd vco_delay_cell_0
x2 vp pgt net1 net2 in gnd vco_delay_cell_0
x3 vp pgt net2 net3 in gnd vco_delay_cell_0
x4 vp pgt net3 5th in gnd vco_delay_cell_0
x7 vp pgt 5th out in gnd vco_delay_cell_0
.ends

* expanding   symbol:  /foss/designs/CHIP-PLL/schematics/divider/schematics/d_flip_flop.sym # of pins=6
** sym_path: /foss/designs/CHIP-PLL/schematics/divider/schematics/d_flip_flop.sym
** sch_path: /foss/designs/CHIP-PLL/schematics/divider/schematics/d_flip_flop.sch
.subckt d_flip_flop q VP GND q_ clk d
*.iopin GND
*.ipin clk
*.iopin VP
*.ipin d
*.opin q
*.opin q_
x2 VP GND net1 q q_ NOR_2in
x3 VP GND q q_ net3 NOR_2in
x4 VP GND net2 net1 clk NOR_2in
x5 VP GND net4 net2 net1 NOR_2in
x6 VP GND net3 net4 d NOR_2in
x1 VP GND net1 net3 clk net4 NAND_3in
.ends

* expanding   symbol:  /foss/designs/CHIP-PLL/schematics/misc/level_shifter.sym # of pins=5
** sym_path: /foss/designs/CHIP-PLL/schematics/misc/level_shifter.sym
** sch_path: /foss/designs/CHIP-PLL/schematics/misc/level_shifter.sch
.subckt level_shifter vph out vpl in gd
*.ipin in
*.opin out
*.ipin gd
*.ipin vph
*.ipin vpl
XM1 1_stage_out in vpl vpl sg13_lv_pmos w=2u l=0.45u ng=1 m=1 mm_ok=1
XM3 1_stage_out in net1 gd sg13_lv_nmos w=1u l=0.45u ng=1 m=1 mm_ok=1
XM4 net1 in gd gd sg13_lv_nmos w=1u l=0.45u ng=1 m=1 mm_ok=1
XM2 2_stage_out 1_stage_out vpl vpl sg13_lv_pmos w=2u l=0.45u ng=1 m=1 mm_ok=1
XM5 2_stage_out 1_stage_out net4 gd sg13_lv_nmos w=1u l=0.45u ng=1 m=1 mm_ok=1
XM6 net4 1_stage_out gd gd sg13_lv_nmos w=1u l=0.45u ng=1 m=1 mm_ok=1
XM7 net2 3_stage_out vph vph sg13_hv_pmos w=1u l=0.45u ng=1 m=1 mm_ok=1
XM8 3_stage_out 2_stage_out gd gd sg13_hv_nmos w=4u l=0.45u ng=1 m=1 mm_ok=1
XM9 4 1_stage_out net2 vph sg13_hv_pmos w=1u l=0.45u ng=1 m=1 mm_ok=1
XM10 3_stage_out 2_stage_out net3 vph sg13_hv_pmos w=2u l=0.45u ng=1 m=1 mm_ok=1
XM11 net3 4 vph vph sg13_hv_pmos w=2u l=0.45u ng=1 m=1 mm_ok=1
XM12 4 1_stage_out gd gd sg13_hv_nmos w=2u l=0.45u ng=1 m=1 mm_ok=1
XM15 buf_out_1 3_stage_out vph vph sg13_hv_pmos w=2u l=0.45u ng=1 m=1 mm_ok=1
XM14 buf_out_1 3_stage_out net5 gd sg13_hv_nmos w=1u l=0.45u ng=1 m=1 mm_ok=1
XM13 net5 3_stage_out gd gd sg13_hv_nmos w=1u l=0.45u ng=1 m=1 mm_ok=1
XM16 buf_out_2 buf_out_1 vph vph sg13_hv_pmos w=4u l=0.45u ng=1 m=2 mm_ok=1
XM17 buf_out_2 buf_out_1 net6 gd sg13_hv_nmos w=2u l=0.45u ng=1 m=2 mm_ok=1
XM18 net6 buf_out_1 gd gd sg13_hv_nmos w=2u l=0.45u ng=1 m=2 mm_ok=1
XM19 out buf_out_2 vph vph sg13_hv_pmos w=4u l=0.45u ng=1 m=8 mm_ok=1
XM20 out buf_out_2 net7 gd sg13_hv_nmos w=4u l=0.45u ng=1 m=4 mm_ok=1
XM21 net7 buf_out_2 gd gd sg13_hv_nmos w=4u l=0.45u ng=1 m=4 mm_ok=1
.ends

* expanding   symbol:  /foss/designs/CHIP-PLL/schematics/divider/schematics/inverter_x4.sym # of pins=4
** sym_path: /foss/designs/CHIP-PLL/schematics/divider/schematics/inverter_x4.sym
** sch_path: /foss/designs/CHIP-PLL/schematics/divider/schematics/inverter_x4.sch
.subckt inverter_x4 IN OUT VP GND
*.ipin IN
*.iopin VP
*.opin OUT
*.iopin GND
XM1 OUT IN GND GND sg13_lv_nmos w=0.60u l=0.13u ng=1 m=1 mm_ok=1
XM2 OUT IN VP VP sg13_lv_pmos w=0.60u l=0.13u ng=1 m=1 mm_ok=1
.ends

* expanding   symbol:  /foss/designs/CHIP-PLL/schematics/divider/schematics/NAND_2in.sym # of pins=5
** sym_path: /foss/designs/CHIP-PLL/schematics/divider/schematics/NAND_2in.sym
** sch_path: /foss/designs/CHIP-PLL/schematics/divider/schematics/NAND_2in.sch
.subckt NAND_2in VP GND a y b
*.opin y
*.iopin GND
*.ipin a
*.iopin VP
*.ipin b
XM1 y a net1 GND sg13_lv_nmos w=0.15u l=0.13u ng=1 m=1 mm_ok=1
XM3 net1 b GND GND sg13_lv_nmos w=0.15u l=0.13u ng=1 m=1 mm_ok=1
XM2 y b VP VP sg13_lv_pmos w=0.15u l=0.13u ng=1 m=1 mm_ok=1
XM4 y a VP VP sg13_lv_pmos w=0.15u l=0.13u ng=1 m=1 mm_ok=1
.ends

* expanding   symbol:  /foss/designs/CHIP-PLL/schematics/PFD/PFD_flip_flop.sym # of pins=7
** sym_path: /foss/designs/CHIP-PLL/schematics/PFD/PFD_flip_flop.sym
** sch_path: /foss/designs/CHIP-PLL/schematics/PFD/PFD_flip_flop.sch
.subckt PFD_flip_flop clk rst D Q NQ vp gd
*.ipin D
*.opin Q
*.opin NQ
*.ipin clk
*.ipin rst
*.ipin gd
*.ipin vp
x8 clk vp 1 net1 gd clk_n PFD_passgate
x4 clk vp 2 3 gd clk_n PFD_passgate
x7 clk_n vp 3 NQ gd clk PFD_passgate
C2 3 gd 0.2p
C1 NQ gd 0.2p
C3 1 gd 0.2p
C4 net1 gd 0.2p
x3 vp rst 3 Q gd PFD_NOR
x5 vp rst 2 net1 gd PFD_NOR
x2 clk clk_n vp gd inverter_x4
x6 Q NQ vp gd inverter_x8
x9 1 2 vp gd inverter_x8
x1 clk_n vp D 1 gd clk PFD_passgate
.ends

* expanding   symbol:  /foss/designs/CHIP-PLL/schematics/PFD/PFD_passgate.sym # of pins=6
** sym_path: /foss/designs/CHIP-PLL/schematics/PFD/PFD_passgate.sym
** sch_path: /foss/designs/CHIP-PLL/schematics/PFD/PFD_passgate.sch
.subckt PFD_passgate in_n vp A B gnd in_p
*.ipin in_n
*.ipin in_p
*.iopin vp
*.iopin gnd
*.iopin B
*.iopin A
XM4 B in_p A net1 sg13_lv_pmos w=0.3u l=0.15u ng=1 m=1 mm_ok=1
XM5 B in_n A net2 sg13_lv_nmos w=0.3u l=0.15u ng=1 m=1 mm_ok=1
XR1 vp net1 ntap1 R=262.8473 w=0.78e-6 l=0.78e-6
XR2 gnd net2 ptap1 R=262.8473 w=0.78e-6 l=0.78e-6
.ends

* expanding   symbol:  /foss/designs/CHIP-PLL/schematics/PFD/PFD_buffor.sym # of pins=4
** sym_path: /foss/designs/CHIP-PLL/schematics/PFD/PFD_buffor.sym
** sch_path: /foss/designs/CHIP-PLL/schematics/PFD/PFD_buffor.sch
.subckt PFD_buffor gnd vp out in
*.iopin gnd
*.iopin vp
*.ipin in
*.iopin out
XM1 out_stage1 in gnd gnd sg13_lv_nmos w=0.4u l=0.5u ng=1 m=1 mm_ok=1
XM4 out_stage1 in vp vp sg13_lv_pmos w=0.4u l=0.5u ng=1 m=1 mm_ok=1
XM2 out out_stage1 gnd gnd sg13_lv_nmos w=0.4u l=0.5u ng=1 m=1 mm_ok=1
XM3 out out_stage1 vp vp sg13_lv_pmos w=0.4u l=0.5u ng=1 m=1 mm_ok=1
.ends

* expanding   symbol:  /foss/designs/CHIP-PLL/schematics/charge_pump/vbias.sym # of pins=3
** sym_path: /foss/designs/CHIP-PLL/schematics/charge_pump/vbias.sym
** sch_path: /foss/designs/CHIP-PLL/schematics/charge_pump/vbias.sch
.subckt vbias vp gd vbias
*.opin vbias
*.iopin gd
*.iopin vp
XM5 net1 iref vp vp sg13_lv_pmos w=1.2u l=0.6u ng=1 m=1 mm_ok=1
XM6 vbias net1 net2 gd sg13_lv_nmos w=3.6u l=0.6u ng=1 m=1 mm_ok=1
XM2 net2 net2 gd gd sg13_lv_nmos w=1.2u l=0.6u ng=1 m=1 mm_ok=1
XM3 gd gd gd gd sg13_lv_nmos w=1.86u l=0.6u ng=1 m=1 mm_ok=1
XM7 vp vp vp vp sg13_lv_pmos w=1.375u l=0.6u ng=1 m=1 mm_ok=1
XR1 net1 vbias gd rppd w=1e-6 l=1.7e-6 m=1 b=0 mm_ok=1
x1 vp iref gd curr_source
.ends

* expanding   symbol:  /foss/designs/CHIP-PLL/schematics/charge_pump/curr_source.sym # of pins=3
** sym_path: /foss/designs/CHIP-PLL/schematics/charge_pump/curr_source.sym
** sch_path: /foss/designs/CHIP-PLL/schematics/charge_pump/curr_source.sch
.subckt curr_source vp iref gd
*.iopin vp
*.iopin gd
*.opin iref
XM9 net3 net3 gd gd sg13_lv_nmos w=1u l=0.6u ng=1 m=1 mm_ok=1
XM4 iref iref vp vp sg13_lv_pmos w=1.4u l=0.6u ng=1 m=1 mm_ok=1
XM5 net2 iref vp vp sg13_lv_pmos w=1.2u l=0.6u ng=1 m=1 mm_ok=1
XM10 iref net2 net1 gd sg13_lv_nmos w=1.2u l=0.6u ng=1 m=1 mm_ok=1
XM1 net2 net2 gd gd sg13_lv_nmos w=1.4u l=0.6u ng=1 m=1 mm_ok=1
XM3 vp vp net3 gd sg13_lv_nmos w=1u l=0.6u ng=1 m=1 mm_ok=1
XM6 vp net3 iref gd sg13_lv_nmos w=1u l=0.6u ng=1 m=1 mm_ok=1
XM2 gd gd gd gd sg13_lv_nmos w=0.4u l=0.6u ng=1 m=1 mm_ok=1
XR2 net1 gd gd rppd w=1e-6 l=1.7e-6 m=1 b=0 mm_ok=1
.ends

* expanding   symbol:  /foss/designs/CHIP-PLL/schematics/divider/schematics/2Div.sym # of pins=10
** sym_path: /foss/designs/CHIP-PLL/schematics/divider/schematics/2Div.sym
** sch_path: /foss/designs/CHIP-PLL/schematics/divider/schematics/2Div.sch
.subckt 2Div gd vp in div2 div4 div8 div16 div32 div64 div128
*.iopin gd
*.ipin in
*.iopin vp
*.opin div2
*.opin div4
*.opin div8
*.opin div16
*.opin div32
*.opin div64
*.opin div128
x1 div2 vp gd net1 in net1 d_flip_flop
x2 div4 vp gd net2 div2 net2 d_flip_flop
x3 div32 vp gd net5 div16 net5 d_flip_flop
x4 div64 vp gd net6 div32 net6 d_flip_flop
x5 div8 vp gd net3 div4 net3 d_flip_flop
x6 div16 vp gd net4 div8 net4 d_flip_flop
x7 div128 vp gd net7 div64 net7 d_flip_flop
.ends

* expanding   symbol:  /foss/designs/CHIP-PLL/schematics/divider/schematics/MUX_8to1.sym # of pins=14
** sym_path: /foss/designs/CHIP-PLL/schematics/divider/schematics/MUX_8to1.sym
** sch_path: /foss/designs/CHIP-PLL/schematics/divider/schematics/MUX_8to1.sch
.subckt MUX_8to1 gd vp A0 out in1 in2 in3 in4 in5 in6 in7 A1 in8 A2
*.iopin gd
*.iopin vp
*.opin out
*.ipin in1
*.ipin in2
*.ipin in3
*.ipin in4
*.ipin in5
*.ipin in6
*.ipin in7
*.ipin in8
*.ipin A0
*.ipin A1
*.ipin A2
x9 A0 net1 vp gd inverter
x10 A1 net2 vp gd inverter
x11 A2 net3 vp gd inverter
x28 out_unb out vp gd inverter
x29 in4 net8 vp gd inverter
x30 in8 net4 vp gd inverter
x31 in7 net5 vp gd inverter
x32 in6 net6 vp gd inverter
x33 in5 net7 vp gd inverter
x34 in1 net11 vp gd inverter
x35 in2 net10 vp gd inverter
x36 in3 net9 vp gd inverter
x1 en8_ vp gd en8 net4 out_unb passgate
x2 en7_ vp gd en7 net5 out_unb passgate
x3 en6_ vp gd en6 net6 out_unb passgate
x4 en5_ vp gd en5 net7 out_unb passgate
x5 en4_ vp gd en4 net8 out_unb passgate
x6 en3_ vp gd en3 net9 out_unb passgate
x7 en2_ vp gd en2 net10 out_unb passgate
x8 en1_ vp gd en1 net11 out_unb passgate
x13 en8_ en8 vp gd inverter
x15 en7_ en7 vp gd inverter
x17 en6_ en6 vp gd inverter
x19 en5_ en5 vp gd inverter
x21 en4_ en4 vp gd inverter
x23 en3_ en3 vp gd inverter
x25 en2_ en2 vp gd inverter
x27 en1_ en1 vp gd inverter
x12 vp gd net3 en8_ net2 net1 NAND_3in
x14 vp gd net2 en7_ net3 A0 NAND_3in
x16 vp gd net1 en6_ net3 A1 NAND_3in
x18 vp gd net3 en5_ A1 A0 NAND_3in
x20 vp gd net1 en4_ net2 A2 NAND_3in
x22 vp gd net2 en3_ A2 A0 NAND_3in
x24 vp gd net1 en2_ A2 A1 NAND_3in
x26 vp gd A2 en1_ A1 A0 NAND_3in
.ends

* expanding   symbol:  /foss/designs/CHIP-PLL/schematics/divider/schematics/pdiv.sym # of pins=11
** sym_path: /foss/designs/CHIP-PLL/schematics/divider/schematics/pdiv.sym
** sch_path: /foss/designs/CHIP-PLL/schematics/divider/schematics/pdiv.sch
.subckt pdiv gd VP clk reset d0 d1 d2 d3 d4 d5 out_div
*.iopin gd
*.ipin clk
*.iopin VP
*.ipin d0
*.ipin d1
*.ipin d2
*.ipin d3
*.ipin d4
*.ipin d5
*.opin out_div
*.ipin reset
x4 VP gd d0 d012 d1 d2 NAND_3in
x7 VP gd d3 d345 d4 d5 NAND_3in
x5 VP gd d012 bypass d345 NOR_2in
x6 bypass net4 VP gd inverter
x8 net3 out VP gd inverter_x4
x3 net4 VP gd bypass clk net1 passgate_scaled
x9 bypass VP gd net4 out net1 passgate_scaled
x1 gd VP clk out div2 div4 div8 div16 div32 div64 div_with_reset
x2 net3 VP gd div2 div4 div8 div16 div32 div64 d0 d1 d2 d3 d4 d5 count_data_check
x11 out_div VP gd net2 net1 net2 net5 d_flip_flop_reset
x10 reset net5 VP gd inverter
.ends

* expanding   symbol:  /foss/designs/CHIP-PLL/schematics/vco/vco_cell/vco_delay_cell_0.sym # of pins=6
** sym_path: /foss/designs/CHIP-PLL/schematics/vco/vco_cell/vco_delay_cell_0.sym
** sch_path: /foss/designs/CHIP-PLL/schematics/vco/vco_cell/vco_delay_cell_0.sch
.subckt vco_delay_cell_0 vp pgt in out ngt gnd
*.ipin in
*.opin out
*.iopin gnd
*.iopin vp
*.iopin pgt
*.iopin ngt
XM23 up pgt vp vp sg13_lv_pmos w=1.2u l=0.16*4u ng=1 m=1 mm_ok=1
XM24 out in up up sg13_lv_pmos w=1.2u l=0.16*2u ng=1 m=1 mm_ok=1
XM25 out in dn dn sg13_lv_nmos w=0.8u l=0.16*2u ng=1 m=1 mm_ok=1
XM26 dn ngt gnd gnd sg13_lv_nmos w=0.8u l=0.16*4u ng=1 m=1 mm_ok=1
.ends

* expanding   symbol:  /foss/designs/CHIP-PLL/schematics/divider/schematics/NOR_2in.sym # of pins=5
** sym_path: /foss/designs/CHIP-PLL/schematics/divider/schematics/NOR_2in.sym
** sch_path: /foss/designs/CHIP-PLL/schematics/divider/schematics/NOR_2in.sch
.subckt NOR_2in VP GND a y b
*.opin y
*.iopin GND
*.ipin a
*.iopin VP
*.ipin b
XM3 y a GND GND sg13_lv_nmos w=0.15u l=0.13u ng=1 m=1 mm_ok=1
XM2 y b net1 VP sg13_lv_pmos w=0.15u l=0.13u ng=1 m=1 mm_ok=1
XM4 net1 a VP VP sg13_lv_pmos w=0.15u l=0.13u ng=1 m=1 mm_ok=1
XM5 y b GND GND sg13_lv_nmos w=0.15u l=0.13u ng=1 m=1 mm_ok=1
.ends

* expanding   symbol:  /foss/designs/CHIP-PLL/schematics/divider/schematics/NAND_3in.sym # of pins=6
** sym_path: /foss/designs/CHIP-PLL/schematics/divider/schematics/NAND_3in.sym
** sch_path: /foss/designs/CHIP-PLL/schematics/divider/schematics/NAND_3in.sch
.subckt NAND_3in VP GND a y b c
*.opin y
*.iopin GND
*.ipin a
*.iopin VP
*.ipin b
*.ipin c
XM1 y a net2 GND sg13_lv_nmos w=0.15u l=0.13u ng=1 m=1 mm_ok=1
XM3 net2 b net1 GND sg13_lv_nmos w=0.15u l=0.13u ng=1 m=1 mm_ok=1
XM4 net1 c GND GND sg13_lv_nmos w=0.15u l=0.13u ng=1 m=1 mm_ok=1
XM7 y c VP VP sg13_lv_pmos w=0.15u l=0.13u ng=1 m=1 mm_ok=1
XM2 y a VP VP sg13_lv_pmos w=0.15u l=0.13u ng=1 m=1 mm_ok=1
XM5 y b VP VP sg13_lv_pmos w=0.15u l=0.13u ng=1 m=1 mm_ok=1
.ends

* expanding   symbol:  /foss/designs/CHIP-PLL/schematics/PFD/PFD_NOR.sym # of pins=5
** sym_path: /foss/designs/CHIP-PLL/schematics/PFD/PFD_NOR.sym
** sch_path: /foss/designs/CHIP-PLL/schematics/PFD/PFD_NOR.sch
.subckt PFD_NOR vp A B Out gd
*.ipin vp
*.ipin gd
*.ipin B
*.ipin A
*.opin Out
XM1 Out A net1 net3 sg13_lv_pmos w=0.3u l=0.15u ng=1 m=1 mm_ok=1
XM4 net1 B vp net3 sg13_lv_pmos w=0.3u l=0.15u ng=1 m=1 mm_ok=1
XM2 Out A gd net2 sg13_lv_nmos w=0.3u l=0.15u ng=1 m=1 mm_ok=1
XM3 Out B gd net2 sg13_lv_nmos w=0.3u l=0.15u ng=1 m=1 mm_ok=1
XR1 vp net3 ntap1 R=262.8473 w=0.78e-6 l=0.78e-6
XR2 gd net2 ptap1 R=262.8473 w=0.78e-6 l=0.78e-6
.ends

* expanding   symbol:  /foss/designs/CHIP-PLL/schematics/divider/schematics/inverter_x8.sym # of pins=4
** sym_path: /foss/designs/CHIP-PLL/schematics/divider/schematics/inverter_x8.sym
** sch_path: /foss/designs/CHIP-PLL/schematics/divider/schematics/inverter_x8.sch
.subckt inverter_x8 IN OUT VP GND
*.ipin IN
*.iopin VP
*.opin OUT
*.iopin GND
XM1 OUT IN GND GND sg13_lv_nmos w=1.20u l=0.13u ng=1 m=1 mm_ok=1
XM2 OUT IN VP VP sg13_lv_pmos w=1.20u l=0.13u ng=1 m=1 mm_ok=1
.ends

* expanding   symbol:  /foss/designs/CHIP-PLL/schematics/divider/schematics/inverter.sym # of pins=4
** sym_path: /foss/designs/CHIP-PLL/schematics/divider/schematics/inverter.sym
** sch_path: /foss/designs/CHIP-PLL/schematics/divider/schematics/inverter.sch
.subckt inverter IN OUT VP GND
*.ipin IN
*.iopin VP
*.opin OUT
*.iopin GND
XM1 OUT IN GND GND sg13_lv_nmos w=0.15u l=0.13u ng=1 m=1 mm_ok=1
XM2 OUT IN VP VP sg13_lv_pmos w=0.15u l=0.13u ng=1 m=1 mm_ok=1
.ends

* expanding   symbol:  /foss/designs/CHIP-PLL/schematics/divider/schematics/passgate.sym # of pins=6
** sym_path: /foss/designs/CHIP-PLL/schematics/divider/schematics/passgate.sym
** sch_path: /foss/designs/CHIP-PLL/schematics/divider/schematics/passgate.sch
.subckt passgate en_ VP GND en IO OI
*.iopin OI
*.iopin IO
*.iopin VP
*.iopin GND
*.ipin en_
*.ipin en
XM1 IO en OI GND sg13_lv_nmos w=0.15u l=0.13u ng=1 m=1 mm_ok=1
XM2 IO en_ OI VP sg13_lv_pmos w=0.15u l=0.13u ng=1 m=1 mm_ok=1
.ends

* expanding   symbol:  /foss/designs/CHIP-PLL/schematics/divider/schematics/passgate_scaled.sym # of pins=6
** sym_path: /foss/designs/CHIP-PLL/schematics/divider/schematics/passgate_scaled.sym
** sch_path: /foss/designs/CHIP-PLL/schematics/divider/schematics/passgate_scaled.sch
.subckt passgate_scaled en_ VP GND en IO OI
*.iopin OI
*.iopin IO
*.iopin VP
*.iopin GND
*.ipin en_
*.ipin en
XM1 IO en OI GND sg13_lv_nmos w=0.15u l=0.13u ng=1 m=1 mm_ok=1
XM2 IO en_ OI VP sg13_lv_pmos w=0.15u l=0.13u ng=1 m=1 mm_ok=1
.ends

* expanding   symbol:  /foss/designs/CHIP-PLL/schematics/divider/schematics/div_with_reset.sym # of pins=10
** sym_path: /foss/designs/CHIP-PLL/schematics/divider/schematics/div_with_reset.sym
** sch_path: /foss/designs/CHIP-PLL/schematics/divider/schematics/div_with_reset.sch
.subckt div_with_reset gd vp in reset div2 div4 div8 div16 div32 div64
*.iopin gd
*.ipin in
*.iopin vp
*.opin div2
*.opin div4
*.opin div8
*.opin div16
*.opin div32
*.opin div64
*.ipin reset
x1 net1 vp gd div4 net2 div4 reset d_flip_flop_reset
x2 net2 vp gd div2 in div2 reset d_flip_flop_reset
x3 net6 vp gd div64 net5 div64 reset d_flip_flop_reset
x4 net5 vp gd div32 net4 div32 reset d_flip_flop_reset
x5 net4 vp gd div16 net3 div16 reset d_flip_flop_reset
x6 net3 vp gd div8 net1 div8 reset d_flip_flop_reset
.ends

* expanding   symbol:  /foss/designs/CHIP-PLL/schematics/divider/schematics/count_data_check.sym # of pins=15
** sym_path: /foss/designs/CHIP-PLL/schematics/divider/schematics/count_data_check.sym
** sch_path: /foss/designs/CHIP-PLL/schematics/divider/schematics/count_data_check.sch
.subckt count_data_check out VP GND c0 c1 c2 c3 c4 c5 d0 d1 d2 d3 d4 d5
*.iopin GND
*.ipin c0
*.iopin VP
*.ipin c1
*.opin out
*.ipin c2
*.ipin c3
*.ipin c4
*.ipin c5
*.ipin d0
*.ipin d1
*.ipin d3
*.ipin d4
*.ipin d5
*.ipin d2
x7 VP GND y0 and012 y1 y2 NAND_3in
x8 VP GND y3 and345 y4 y5 NAND_3in
x9 VP GND and012 out and345 NOR_2in
x1 VP GND d0 y0 c0 XNOR
x2 VP GND d1 y1 c1 XNOR
x3 VP GND d2 y2 c2 XNOR
x4 VP GND d3 y3 c3 XNOR
x5 VP GND d4 y4 c4 XNOR
x6 VP GND d5 y5 c5 XNOR
.ends

* expanding   symbol:  /foss/designs/CHIP-PLL/schematics/divider/schematics/d_flip_flop_reset.sym # of pins=7
** sym_path: /foss/designs/CHIP-PLL/schematics/divider/schematics/d_flip_flop_reset.sym
** sch_path: /foss/designs/CHIP-PLL/schematics/divider/schematics/d_flip_flop_reset.sch
.subckt d_flip_flop_reset q VP GND q_ clk d reset
*.iopin GND
*.ipin clk
*.iopin VP
*.ipin d
*.opin q
*.opin q_
*.ipin reset
x3 VP GND net4 net2 net1 NAND_2in
x2 VP GND q q_ net3 reset NAND_3in_x2
x5 VP GND net3 net4 d reset NAND_3in_x2
x6 VP GND net2 net1 clk reset NAND_3in_x2
x4 VP GND net1 q q_ NAND_2in_x2
x1 VP GND net1 net3 clk net4 NAND_3in
.ends

* expanding   symbol:  /foss/designs/CHIP-PLL/schematics/divider/schematics/XNOR.sym # of pins=5
** sym_path: /foss/designs/CHIP-PLL/schematics/divider/schematics/XNOR.sym
** sch_path: /foss/designs/CHIP-PLL/schematics/divider/schematics/XNOR.sch
.subckt XNOR VP GND a y b
*.opin y
*.iopin GND
*.ipin a
*.iopin VP
*.ipin b
XM1 y a net1 GND sg13_lv_nmos w=0.15u l=0.13u ng=1 m=1 mm_ok=1
XM3 net1 _b GND GND sg13_lv_nmos w=0.15u l=0.13u ng=1 m=1 mm_ok=1
XM2 net2 a VP VP sg13_lv_pmos w=0.15u l=0.13u ng=1 m=4 mm_ok=1
XM4 net3 _a VP VP sg13_lv_pmos w=0.15u l=0.13u ng=1 m=4 mm_ok=1
XM5 y _a net4 GND sg13_lv_nmos w=0.15u l=0.13u ng=1 m=1 mm_ok=1
XM6 net4 b GND GND sg13_lv_nmos w=0.15u l=0.13u ng=1 m=1 mm_ok=1
XM7 y b net2 VP sg13_lv_pmos w=0.15u l=0.13u ng=1 m=4 mm_ok=1
XM8 y _b net3 VP sg13_lv_pmos w=0.15u l=0.13u ng=1 m=4 mm_ok=1
x1 a _a VP GND inverter
x2 b _b VP GND inverter
.ends

* expanding   symbol:  /foss/designs/CHIP-PLL/schematics/divider/schematics/NAND_3in_x2.sym # of pins=6
** sym_path: /foss/designs/CHIP-PLL/schematics/divider/schematics/NAND_3in_x2.sym
** sch_path: /foss/designs/CHIP-PLL/schematics/divider/schematics/NAND_3in_x2.sch
.subckt NAND_3in_x2 VP GND a y b c
*.opin y
*.iopin GND
*.ipin a
*.iopin VP
*.ipin b
*.ipin c
XM1 y a net2 GND sg13_lv_nmos w=0.150u l=0.13u ng=1 m=8 mm_ok=1
XM3 net2 b net1 GND sg13_lv_nmos w=0.150u l=0.13u ng=1 m=8 mm_ok=1
XM4 net1 c GND GND sg13_lv_nmos w=0.150u l=0.13u ng=1 m=8 mm_ok=1
XM7 y c VP VP sg13_lv_pmos w=0.150u l=0.13u ng=1 m=2 mm_ok=1
XM2 y a VP VP sg13_lv_pmos w=0.150u l=0.13u ng=1 m=2 mm_ok=1
XM5 y b VP VP sg13_lv_pmos w=0.150u l=0.13u ng=1 m=2 mm_ok=1
.ends

* expanding   symbol:  /foss/designs/CHIP-PLL/schematics/divider/schematics/NAND_2in_x2.sym # of pins=5
** sym_path: /foss/designs/CHIP-PLL/schematics/divider/schematics/NAND_2in_x2.sym
** sch_path: /foss/designs/CHIP-PLL/schematics/divider/schematics/NAND_2in_x2.sch
.subckt NAND_2in_x2 VP GND a y b
*.opin y
*.iopin GND
*.ipin a
*.iopin VP
*.ipin b
XM1 y a net1 GND sg13_lv_nmos w=0.15u l=0.13u ng=1 m=4 mm_ok=1
XM3 net1 b GND GND sg13_lv_nmos w=0.15u l=0.13u ng=1 m=4 mm_ok=1
XM2 y b VP VP sg13_lv_pmos w=0.15u l=0.13u ng=1 m=2 mm_ok=1
XM4 y a VP VP sg13_lv_pmos w=0.150u l=0.13u ng=1 m=2 mm_ok=1
.ends

.GLOBAL GND
.end
