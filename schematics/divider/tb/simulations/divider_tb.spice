** sch_path: /foss/designs/CHIP-PLL/divider/tb/divider_tb.sch
**.subckt divider_tb
V1 VP gnd! 1.2
V2 clk gnd! PULSE(0 1.2 0 100p 100p 3.335n 6.67n)
V0 gnd! 0 0
C2 div256 gnd! 1f
x1 div2 VP gnd! net2 clk net2 d_flip_flop
x2 div4 VP gnd! net1 div2 net1 d_flip_flop
x3 div8 VP gnd! net3 div4 net3 d_flip_flop
x4 div16 VP gnd! net4 div8 net4 d_flip_flop
x5 div32 VP gnd! net6 div16 net6 d_flip_flop
x6 div64 VP gnd! net5 div32 net5 d_flip_flop
x7 div128 VP gnd! net7 div64 net7 d_flip_flop
x8 div256 VP gnd! net8 div128 net8 d_flip_flop
V3 d gnd! PULSE(0 1.2 0 10p 10p 3.335n 6.67n)
x9 dov512 VP gnd! net10 div256 net10 d_flip_flop
x10 div1024 VP gnd! net9 dov512 net9 d_flip_flop
x11 div2048 VP gnd! net11 div1024 net11 d_flip_flop
x12 div4096 VP gnd! net12 div2048 net12 d_flip_flop
x13 div8192 VP gnd! net13 div4096 net13 d_flip_flop
**** begin user architecture code
 .lib cornerMOSlv.lib mos_tt

.param temp=27
.control
set maxdata = 1000
op
print all
save all

tran 50p 60u
write divider_tb.raw v(div8192)
set appendwrite

plot v(div16)
plot v(div256)
.endc

**** end user architecture code
**.ends

* expanding   symbol:  /foss/designs/CHIP-PLL/divider/schematics/d_flip_flop.sym # of pins=6
** sym_path: /foss/designs/CHIP-PLL/divider/schematics/d_flip_flop.sym
** sch_path: /foss/designs/CHIP-PLL/divider/schematics/d_flip_flop.sch
.subckt d_flip_flop q VP GND q_ clk d
*.iopin GND
*.ipin clk
*.iopin VP
*.ipin d
*.opin q
*.opin q_
x3 VP GND net4 net2 net1 NAND_2in
x2 VP GND net2 net1 clk NAND_2in
x4 VP GND net1 q q_ NAND_2in
x5 VP GND q q_ net3 NAND_2in
x6 VP GND net3 net4 d NAND_2in
x1 VP GND net1 net3 clk net4 NAND_3in
.ends

* expanding   symbol:  /foss/designs/CHIP-PLL/divider/schematics/NAND_2in.sym # of pins=5
** sym_path: /foss/designs/CHIP-PLL/divider/schematics/NAND_2in.sym
** sch_path: /foss/designs/CHIP-PLL/divider/schematics/NAND_2in.sch
.subckt NAND_2in VP GND a y b
*.opin y
*.iopin GND
*.ipin a
*.iopin VP
*.ipin b
XM1 y a net1 GND sg13_lv_nmos w=0.15u l=0.13u ng=1
XM3 net1 b GND GND sg13_lv_nmos w=0.15u l=0.13u ng=1
XM2 y b VP VP sg13_lv_pmos w=0.15u l=0.13u ng=1
XM4 y a VP VP sg13_lv_pmos w=0.15u l=0.13u ng=1
.ends

* expanding   symbol:  /foss/designs/CHIP-PLL/divider/schematics/NAND_3in.sym # of pins=6
** sym_path: /foss/designs/CHIP-PLL/divider/schematics/NAND_3in.sym
** sch_path: /foss/designs/CHIP-PLL/divider/schematics/NAND_3in.sch
.subckt NAND_3in VP GND a y b c
*.opin y
*.iopin GND
*.ipin a
*.iopin VP
*.ipin b
*.ipin c
XM1 y a net2 GND sg13_lv_nmos w=0.15u l=0.13u ng=1
XM3 net2 b net1 GND sg13_lv_nmos w=0.15u l=0.13u ng=1
XM4 net1 c GND GND sg13_lv_nmos w=0.15u l=0.13u ng=1
XM7 y c VP VP sg13_lv_pmos w=0.15u l=0.13u ng=1
XM2 y a VP VP sg13_lv_pmos w=0.15u l=0.13u ng=1
XM5 y b VP VP sg13_lv_pmos w=0.15u l=0.13u ng=1
.ends

.end
