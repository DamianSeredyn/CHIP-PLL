** sch_path: /foss/designs/CHIP-PLL/divider/schematics/NAND_3in_x2.sch
**.subckt NAND_3in_x2 VP GND a y b c
*.opin y
*.iopin GND
*.ipin a
*.iopin VP
*.ipin b
*.ipin c
XM1 y a net2 GND sg13_lv_nmos w=0.150u l=0.13u ng=1 m=8
XM3 net2 b net1 GND sg13_lv_nmos w=0.150u l=0.13u ng=1 m=8
XM4 net1 c GND GND sg13_lv_nmos w=0.150u l=0.13u ng=1 m=8
XM7 y c VP VP sg13_lv_pmos w=0.150u l=0.13u ng=1 m=2
XM2 y a VP VP sg13_lv_pmos w=0.150u l=0.13u ng=1 m=2
XM5 y b VP VP sg13_lv_pmos w=0.150u l=0.13u ng=1 m=2
**.ends
.end
