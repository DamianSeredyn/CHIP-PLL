** sch_path: /foss/designs/CHIP-PLL/divider/tb/MUX_8to1_tb.sch
**.subckt MUX_8to1_tb
x2 0 VP clk div2 div4 div8 div16 div32 div64 div128 2Div
V1 VP 0 {vdd}
V2 clk 0 PULSE(0 {vdd} 0 100p 100p 1.5625n 3.125n)
V3 a1 0 PULSE(0 {vdd} 0 100p 100p 3u 6u)
V4 a0 0 PULSE(0 {vdd} 0 100p 100p 1.5u 3u)
V5 a2 0 PULSE(0 {vdd} 0 100p 100p 6u 12u)
C9 out 0 1f
x1 0 VP a0 out clk div2 div4 div8 div16 div32 div64 a1 div128 a2 MUX_8to1
**** begin user architecture code
 .lib cornerMOSlv.lib mos_tt

.param temp=27
.param vdd=1.2
.control
set maxdata = 1000
op
print all
save all

tran 50p 12.01u
write MUX_8to1_tb.raw
set appendwrite

.endc

**** end user architecture code
**.ends

* expanding   symbol:  /foss/designs/CHIP-PLL/divider/schematics/2Div.sym # of pins=10
** sym_path: /foss/designs/CHIP-PLL/divider/schematics/2Div.sym
** sch_path: /foss/designs/CHIP-PLL/divider/schematics/2Div.sch
.subckt 2Div gd vp in div2 div4 div8 div16 div32 div64 div128
*.iopin gd
*.ipin in
*.iopin vp
*.opin div2
*.opin div4
*.opin div8
*.opin div16
*.opin div32
*.opin div64
*.opin div128
x1 div2 vp gd net1 in net1 d_flip_flop
x2 div4 vp gd net2 div2 net2 d_flip_flop
x3 div8 vp gd net3 div4 net3 d_flip_flop
x4 div16 vp gd net4 div8 net4 d_flip_flop
x5 div32 vp gd net5 div16 net5 d_flip_flop
x6 div64 vp gd net6 div32 net6 d_flip_flop
x7 div128 vp gd net7 div64 net7 d_flip_flop
.ends

* expanding   symbol:  /foss/designs/CHIP-PLL/divider/schematics/MUX_8to1.sym # of pins=14
** sym_path: /foss/designs/CHIP-PLL/divider/schematics/MUX_8to1.sym
** sch_path: /foss/designs/CHIP-PLL/divider/schematics/MUX_8to1.sch
.subckt MUX_8to1 gd vp A0 out in1 in2 in3 in4 in5 in6 in7 A1 in8 A2
*.iopin gd
*.iopin vp
*.opin out
*.ipin in1
*.ipin in2
*.ipin in3
*.ipin in4
*.ipin in5
*.ipin in6
*.ipin in7
*.ipin in8
*.ipin A0
*.ipin A1
*.ipin A2
x1 en8_ vp gd en8 net4 out_unb passgate
x2 en7_ vp gd en7 net5 out_unb passgate
x3 en6_ vp gd en6 net6 out_unb passgate
x4 en5_ vp gd en5 net7 out_unb passgate
x5 en4_ vp gd en4 net8 out_unb passgate
x6 en3_ vp gd en3 net9 out_unb passgate
x7 en2_ vp gd en2 net10 out_unb passgate
x8 en1_ vp gd en1 net11 out_unb passgate
x9 A0 net1 vp gd inverter
x10 A1 net2 vp gd inverter
x11 A2 net3 vp gd inverter
x13 en8_ en8 vp gd inverter
x15 en7_ en7 vp gd inverter
x17 en6_ en6 vp gd inverter
x19 en5_ en5 vp gd inverter
x21 en4_ en4 vp gd inverter
x23 en3_ en3 vp gd inverter
x25 en2_ en2 vp gd inverter
x27 en1_ en1 vp gd inverter
x28 in8 net4 vp gd inverter
x29 in7 net5 vp gd inverter
x30 in6 net6 vp gd inverter
x31 in5 net7 vp gd inverter
x32 in4 net8 vp gd inverter
x33 in3 net9 vp gd inverter
x34 in2 net10 vp gd inverter
x35 in1 net11 vp gd inverter
x12 vp gd net3 en8_ net2 net1 NAND_3in
x14 vp gd net2 en7_ net3 A0 NAND_3in
x16 vp gd net1 en6_ net3 A1 NAND_3in
x18 vp gd net3 en5_ A1 A0 NAND_3in
x20 vp gd net1 en4_ net2 A2 NAND_3in
x22 vp gd net2 en3_ A2 A0 NAND_3in
x24 vp gd net1 en2_ A2 A1 NAND_3in
x26 vp gd A2 en1_ A1 A0 NAND_3in
x37 out_unb out vp gd inverter
.ends

* expanding   symbol:  /foss/designs/CHIP-PLL/divider/schematics/d_flip_flop.sym # of pins=6
** sym_path: /foss/designs/CHIP-PLL/divider/schematics/d_flip_flop.sym
** sch_path: /foss/designs/CHIP-PLL/divider/schematics/d_flip_flop.sch
.subckt d_flip_flop q VP GND q_ clk d
*.iopin GND
*.ipin clk
*.iopin VP
*.ipin d
*.opin q
*.opin q_
x3 VP GND net4 net2 net1 NAND_2in
x2 VP GND net2 net1 clk NAND_2in
x4 VP GND net1 q q_ NAND_2in
x5 VP GND q q_ net3 NAND_2in
x6 VP GND net3 net4 d NAND_2in
x1 VP GND net1 net3 clk net4 NAND_3in
.ends

* expanding   symbol:  /foss/designs/CHIP-PLL/divider/schematics/passgate.sym # of pins=6
** sym_path: /foss/designs/CHIP-PLL/divider/schematics/passgate.sym
** sch_path: /foss/designs/CHIP-PLL/divider/schematics/passgate.sch
.subckt passgate en_ VP GND en IO OI
*.iopin OI
*.iopin IO
*.iopin VP
*.iopin GND
*.ipin en_
*.ipin en
XM1 IO en OI GND sg13_lv_nmos w=0.15u l=0.13u ng=1
XM2 IO en_ OI VP sg13_lv_pmos w=0.15u l=0.13u ng=1
.ends

* expanding   symbol:  /foss/designs/CHIP-PLL/divider/schematics/inverter.sym # of pins=4
** sym_path: /foss/designs/CHIP-PLL/divider/schematics/inverter.sym
** sch_path: /foss/designs/CHIP-PLL/divider/schematics/inverter.sch
.subckt inverter IN OUT VP GND
*.ipin IN
*.iopin VP
*.opin OUT
*.iopin GND
XM1 OUT IN GND GND sg13_lv_nmos w=0.15u l=0.13u ng=1
XM2 OUT IN VP VP sg13_lv_pmos w=0.15u l=0.13u ng=1
.ends

* expanding   symbol:  /foss/designs/CHIP-PLL/divider/schematics/NAND_3in.sym # of pins=6
** sym_path: /foss/designs/CHIP-PLL/divider/schematics/NAND_3in.sym
** sch_path: /foss/designs/CHIP-PLL/divider/schematics/NAND_3in.sch
.subckt NAND_3in VP GND a y b c
*.opin y
*.iopin GND
*.ipin a
*.iopin VP
*.ipin b
*.ipin c
XM1 y a net2 GND sg13_lv_nmos w=0.15u l=0.13u ng=1
XM3 net2 b net1 GND sg13_lv_nmos w=0.15u l=0.13u ng=1
XM4 net1 c GND GND sg13_lv_nmos w=0.15u l=0.13u ng=1
XM7 y c VP VP sg13_lv_pmos w=0.15u l=0.13u ng=1
XM2 y a VP VP sg13_lv_pmos w=0.15u l=0.13u ng=1
XM5 y b VP VP sg13_lv_pmos w=0.15u l=0.13u ng=1
.ends

* expanding   symbol:  /foss/designs/CHIP-PLL/divider/schematics/NAND_2in.sym # of pins=5
** sym_path: /foss/designs/CHIP-PLL/divider/schematics/NAND_2in.sym
** sch_path: /foss/designs/CHIP-PLL/divider/schematics/NAND_2in.sch
.subckt NAND_2in VP GND a y b
*.opin y
*.iopin GND
*.ipin a
*.iopin VP
*.ipin b
XM1 y a net1 GND sg13_lv_nmos w=0.15u l=0.13u ng=1
XM3 net1 b GND GND sg13_lv_nmos w=0.15u l=0.13u ng=1
XM2 y b VP VP sg13_lv_pmos w=0.15u l=0.13u ng=1
XM4 y a VP VP sg13_lv_pmos w=0.15u l=0.13u ng=1
.ends

.end
