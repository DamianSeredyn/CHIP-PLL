** sch_path: /foss/designs/CHIP-PLL/schematics/divider/tb/divider_top_tb.sch
**.subckt divider_top_tb
V1 VP 0 {vdd}
V2 clk 0 PULSE(0 {vdd} 0 100p 100p 1.5625n 3.125n)
V8 d4 0 0
V9 d5 0 0
V11 d0 0 0
V10 d1 0 {vdd}
V12 d2 0 {vdd}
V7 d3 0 0
V5 a1 0 0
V6 a0 0 {vdd}
V13 a2 0 0
x1 0 VP clk d0 d1 d2 d3 d4 d5 a0 a1 a2 out_div reset Divider_top
V4 reset 0 PWL( 0 {vdd} 200n {vdd} 200.1n 0)
C1 out_div 0 50f
**** begin user architecture code

.param temp=27
.param vdd=1.2
.control
set num_threads=12
set maxdata = 1000
op
print all
save all

tran 25p 1u

write divider_top_tb.raw
set appendwrite

.endc

 .lib cornerMOSlv.lib mos_tt

**** end user architecture code
**.ends

* expanding   symbol:  /foss/designs/CHIP-PLL/schematics/divider/schematics/Divider_top.sym # of pins=14
** sym_path: /foss/designs/CHIP-PLL/schematics/divider/schematics/Divider_top.sym
** sch_path: /foss/designs/CHIP-PLL/schematics/divider/schematics/Divider_top.sch
.subckt Divider_top gd VP clk d0 d1 d2 d3 d4 d5 a0 a1 a2 out_div rst
X0 MUX_8to1_0.passgate$1$2_0.B MUX_8to1_0.passgate$1$2_0.in_p MUX_8to1_0.passgate$1$2_0.A VP sg13_lv_pmos ad=0.102p pd=1.28u as=0.102p ps=1.28u w=0.3u l=0.15u
X1 a_n5129_5701# 2Div$2_0.d_flip_flop$3$2_2.NAND_2in_nmosx2$3$2_0.y 2Div$2_0.d_flip_flop$3$2_2.NAND_2in_nmosx2$3$2_0.b gd sg13_lv_nmos ad=57f pd=0.68u as=0.102p ps=1.28u w=0.3u l=0.13u
X2 a_1859_5656# pdiv$3_0.d_flip_flop_reset$2$2_0.reset gd gd sg13_lv_nmos ad=0.114p pd=0.98u as=0.114p ps=0.98u w=0.6u l=0.13u
X3 MUX_8to1_0.passgate$1$2_4.in_n MUX_8to1_0.passgate$1$2_4.in_p VP VP sg13_lv_pmos ad=0.204p pd=1.88u as=0.204p ps=1.88u w=0.6u l=0.13u
X4 2Div$2_0.d_flip_flop$3$2_5.NAND_2in_nmosx2$3$2_0.y 2Div$2_0.d_flip_flop$3$2_5.NAND_2in_nmosx2$3$2_0.a VP VP sg13_lv_pmos ad=55.5f pd=0.74u as=0.1005p ps=1.34u w=0.15u l=0.13u
X5 MUX_8to1_0.passgate$1$2_1.in_p a0 VP VP sg13_lv_pmos ad=0.1005p pd=1.34u as=55.5f ps=0.74u w=0.15u l=0.13u
X6 a_1553_5656# pdiv$3_0.d_flip_flop_reset$2$2_0.NAND_2in_nmosx2$1$2$2_0.y pdiv$3_0.d_flip_flop_reset$2$2_0.NAND_2in_nmosx2$1$2$2_0.b gd sg13_lv_nmos ad=0.114p pd=0.98u as=0.204p ps=1.88u w=0.6u l=0.13u
X7 MUX_8to1_0.in4 2Div$2_0.d_flip_flop$3$2_0.NAND_2in_nmosx2$3$2_0.b VP VP sg13_lv_pmos ad=55.5f pd=0.74u as=0.1005p ps=1.34u w=0.15u l=0.13u
X8 a_n2333_n2147# MUX_8to1_0.inverter_x4_ptap_mirror_fix$2$3_5.OUT a_n2435_n2147# gd sg13_lv_nmos ad=57f pd=0.68u as=57f ps=0.68u w=0.3u l=0.13u
X9 gd MUX_8to1_0.in6 a_n5129_n2147# gd sg13_lv_nmos ad=0.102p pd=1.28u as=57f ps=0.68u w=0.3u l=0.13u
X10 a_n399_16# pdiv$3_0.div_with_reset$3$2_0.d_flip_flop_reset$1$2_3.clk a_n501_16# gd sg13_lv_nmos ad=0.114p pd=0.98u as=0.114p ps=0.98u w=0.6u l=0.13u
X11 VP a2 MUX_8to1_0.passgate$1$2_6.in_p VP sg13_lv_pmos ad=55.5f pd=0.74u as=55.5f ps=0.74u w=0.15u l=0.13u
X12 pdiv$3_0.div_with_reset$3$2_0.d_flip_flop_reset$1$2_1.NAND_2in_nmosx2$1$1$5_0.b pdiv$3_0.passgate$3_1.A VP VP sg13_lv_pmos ad=55.5f pd=0.74u as=55.5f ps=0.74u w=0.15u l=0.13u
X13 VP a2 MUX_8to1_0.passgate$1$2_2.in_p VP sg13_lv_pmos ad=55.5f pd=0.74u as=55.5f ps=0.74u w=0.15u l=0.13u
X14 VP pdiv$3_0.div_with_reset$3$2_0.d_flip_flop_reset$1$2_5.NAND_2in_nmosx2$1$1$5_0.b pdiv$3_0.div_with_reset$3$2_0.d_flip_flop_reset$1$2_4.clk VP sg13_lv_pmos ad=0.102p pd=1.28u as=57f ps=0.68u w=0.3u l=0.13u
X15 pdiv$3_0.div_with_reset$3$2_0.d_flip_flop_reset$1$2_3.NAND_3in_nmosx3$1$1$3_1.a pdiv$3_0.div_with_reset$3$2_0.d_flip_flop_reset$1$2_3.NAND_2in_nmosx2$1$1$5_0.b a_n93_16# gd sg13_lv_nmos ad=0.204p pd=1.88u as=0.114p ps=0.98u w=0.6u l=0.13u
X16 pdiv$3_0.d_flip_flop_reset$2$2_0.d pdiv$3_0.d_flip_flop_reset$2$2_0.reset VP VP sg13_lv_pmos ad=55.5f pd=0.74u as=55.5f ps=0.74u w=0.15u l=0.13u
X17 a_6346_517# d2 VP VP sg13_lv_pmos ad=0.1005p pd=1.34u as=0.1005p ps=1.34u w=0.15u l=0.13u
X18 VP 2Div$2_0.d_flip_flop$3$2_2.d MUX_8to1_0.in2 VP sg13_lv_pmos ad=0.1005p pd=1.34u as=55.5f ps=0.74u w=0.15u l=0.13u
X19 VP pdiv$3_0.div_with_reset$3$2_0.d_flip_flop_reset$1$2_5.NAND_2in_nmosx2$1$1$5_0.y pdiv$3_0.div_with_reset$3$2_0.d_flip_flop_reset$1$2_5.NAND_2in_nmosx2$1$1$5_0.b VP sg13_lv_pmos ad=55.5f pd=0.74u as=0.1005p ps=1.34u w=0.15u l=0.13u
X20 gd 2Div$2_0.d_flip_flop$3$2_1.NAND_3in_nmosx3$1$2_0.y a_n6761_2647# gd sg13_lv_nmos ad=0.102p pd=1.28u as=57f ps=0.68u w=0.3u l=0.13u
X21 a_7018_n818# d3 VP VP sg13_lv_pmos ad=0.114p pd=0.98u as=0.204p ps=1.88u w=0.6u l=0.13u
X22 VP pdiv$3_0.div_with_reset$3$2_0.d_flip_flop_reset$1$2_4.NAND_2in_nmosx2$1$1$5_0.b pdiv$3_0.div_with_reset$3$2_0.d_flip_flop_reset$1$2_3.clk VP sg13_lv_pmos ad=0.102p pd=1.28u as=57f ps=0.68u w=0.3u l=0.13u
X23 a_6346_1847# d1 VP VP sg13_lv_pmos ad=0.1005p pd=1.34u as=0.1005p ps=1.34u w=0.15u l=0.13u
X24 MUX_8to1_0.passgate$1$2_1.A MUX_8to1_0.in6 VP VP sg13_lv_pmos ad=0.204p pd=1.88u as=0.204p ps=1.88u w=0.6u l=0.13u
X25 a_3103_16# pdiv$3_0.div_with_reset$3$2_0.d_flip_flop_reset$1$2_2.clk a_3001_16# gd sg13_lv_nmos ad=0.114p pd=0.98u as=0.114p ps=0.98u w=0.6u l=0.13u
X26 gd pdiv$3_0.d_flip_flop_reset$2$2_0.reset a_635_5248# gd sg13_lv_nmos ad=0.114p pd=0.98u as=0.114p ps=0.98u w=0.6u l=0.13u
X27 VP pdiv$3_0.passgate$3_1.A pdiv$3_0.count_data_check$2_0.c0 VP sg13_lv_pmos ad=55.5f pd=0.74u as=55.5f ps=0.74u w=0.15u l=0.13u
X28 pdiv$3_0.div_with_reset$3$2_0.d_flip_flop_reset$1$2_0.NAND_3in_nmosx3$1$1$3_1.a pdiv$3_0.div_with_reset$3$2_0.d_flip_flop_reset$1$2_0.clk VP VP sg13_lv_pmos ad=55.5f pd=0.74u as=55.5f ps=0.74u w=0.15u l=0.13u
X29 a_115_5656# pdiv$3_0.d_flip_flop_reset$2$2_0.NAND_2in_nmosx2$1$2$2_0.b out_div gd sg13_lv_nmos ad=0.114p pd=0.98u as=0.204p ps=1.88u w=0.6u l=0.13u
X30 a_6346_3133# d0 gd gd sg13_lv_nmos ad=0.1005p pd=1.34u as=0.1005p ps=1.34u w=0.15u l=0.13u
X31 VP pdiv$3_0.passgate$3_1.A pdiv$3_0.count_data_check$2_0.c1 VP sg13_lv_pmos ad=55.5f pd=0.74u as=55.5f ps=0.74u w=0.15u l=0.13u
X32 gd 2Div$2_0.d_flip_flop$3$2_0.NAND_2in_nmosx2$3$2_0.a a_n7537_2647# gd sg13_lv_nmos ad=0.102p pd=1.28u as=57f ps=0.68u w=0.3u l=0.13u
X33 pdiv$3_0.div_with_reset$3$2_0.d_flip_flop_reset$1$2_4.NAND_2in_nmosx2$1$1$5_0.b pdiv$3_0.passgate$3_1.A VP VP sg13_lv_pmos ad=55.5f pd=0.74u as=55.5f ps=0.74u w=0.15u l=0.13u
X34 VP 2Div$2_0.d_flip_flop$3$2_5.NAND_3in_nmosx3$1$2_0.y 2Div$2_0.d_flip_flop$3$2_5.d VP sg13_lv_pmos ad=0.1005p pd=1.34u as=55.5f ps=0.74u w=0.15u l=0.13u
X35 VP pdiv$3_0.div_with_reset$3$2_0.d_flip_flop_reset$1$2_1.NAND_2in_nmosx2$1$1$5_0.a pdiv$3_0.div_with_reset$3$2_0.d_flip_flop_reset$1$2_1.NAND_3in_nmosx3$1$1$3_1.a VP sg13_lv_pmos ad=55.5f pd=0.74u as=55.5f ps=0.74u w=0.15u l=0.13u
X36 pdiv$3_0.d_flip_flop_reset$2$2_0.NAND_3in_nmosx3$1$2$3_1.a pdiv$3_0.d_flip_flop_reset$2$2_0.NAND_2in_nmosx2$1$2$2_0.b a_1961_5248# gd sg13_lv_nmos ad=0.204p pd=1.88u as=0.114p ps=0.98u w=0.6u l=0.13u
X37 a_n399_n2600# pdiv$3_0.div_with_reset$3$2_0.d_flip_flop_reset$1$2_1.clk a_n501_n2600# gd sg13_lv_nmos ad=0.114p pd=0.98u as=0.114p ps=0.98u w=0.6u l=0.13u
X38 a_n9141_2647# MUX_8to1_0.in4 2Div$2_0.d_flip_flop$3$2_0.d gd sg13_lv_nmos ad=57f pd=0.68u as=0.102p ps=1.28u w=0.3u l=0.13u
X39 VP 2Div$2_0.d_flip_flop$3$2_0.d 2Div$2_0.d_flip_flop$3$2_0.NAND_2in_nmosx2$3$2_0.a VP sg13_lv_pmos ad=0.1005p pd=1.34u as=55.5f ps=0.74u w=0.15u l=0.13u
X40 VP pdiv$3_0.div_with_reset$3$2_0.d_flip_flop_reset$1$2_0.NAND_3in_nmosx3$1$1$3_1.a pdiv$3_0.div_with_reset$3$2_0.d_flip_flop_reset$1$2_0.NAND_2in_nmosx2$1$1$5_0.a VP sg13_lv_pmos ad=55.5f pd=0.74u as=0.1005p ps=1.34u w=0.15u l=0.13u
X41 a_n5157_n2585# MUX_8to1_0.in6 a_n5259_n2585# gd sg13_lv_nmos ad=57f pd=0.68u as=57f ps=0.68u w=0.3u l=0.13u
X42 VP 2Div$2_0.d_flip_flop$3$2_2.NAND_2in_nmosx2$3$2_0.b 2Div$2_0.d_flip_flop$3$2_2.NAND_3in_nmosx3$1$2_0.y VP sg13_lv_pmos ad=55.5f pd=0.74u as=0.1005p ps=1.34u w=0.15u l=0.13u
X43 VP clk 2Div$2_0.d_flip_flop$3$2_2.NAND_2in_nmosx2$3$2_0.b VP sg13_lv_pmos ad=0.1005p pd=1.34u as=55.5f ps=0.74u w=0.15u l=0.13u
X44 a_6702_n2099# pdiv$3_0.count_data_check$2_0.c4 gd gd sg13_lv_nmos ad=0.1005p pd=1.34u as=0.1005p ps=1.34u w=0.15u l=0.13u
X45 VP pdiv$3_0.d_flip_flop_reset$2$2_0.NAND_2in_nmosx2$1$2$2_0.y pdiv$3_0.d_flip_flop_reset$2$2_0.NAND_2in_nmosx2$1$2$2_0.b VP sg13_lv_pmos ad=55.5f pd=0.74u as=0.1005p ps=1.34u w=0.15u l=0.13u
X46 gd pdiv$3_0.count_data_check$2_0.c1 a_7428_2629# gd sg13_lv_nmos ad=0.1005p pd=1.34u as=55.5f ps=0.74u w=0.15u l=0.13u
X47 pdiv$3_0.div_with_reset$3$2_0.d_flip_flop_reset$1$2_0.NAND_2in_nmosx2$1$1$5_0.b pdiv$3_0.div_with_reset$3$2_0.d_flip_flop_reset$1$2_0.NAND_2in_nmosx2$1$1$5_0.y VP VP sg13_lv_pmos ad=0.1005p pd=1.34u as=55.5f ps=0.74u w=0.15u l=0.13u
X48 pdiv$3_0.count_data_check$2_0.c1 pdiv$3_0.passgate$3_1.A VP VP sg13_lv_pmos ad=55.5f pd=0.74u as=55.5f ps=0.74u w=0.15u l=0.13u
X49 a_6702_n3385# pdiv$3_0.count_data_check$2_0.c5 VP VP sg13_lv_pmos ad=0.1005p pd=1.34u as=0.1005p ps=1.34u w=0.15u l=0.13u
X50 a_n2435_n2147# a2 gd gd sg13_lv_nmos ad=57f pd=0.68u as=0.102p ps=1.28u w=0.3u l=0.13u
X51 pdiv$3_0.div_with_reset$3$2_0.d_flip_flop_reset$1$2_3.NAND_2in_nmosx2$1$1$5_0.b pdiv$3_0.div_with_reset$3$2_0.d_flip_flop_reset$1$2_3.NAND_2in_nmosx2$1$1$5_0.y a_n93_424# gd sg13_lv_nmos ad=0.204p pd=1.88u as=0.114p ps=0.98u w=0.6u l=0.13u
X52 VP pdiv$3_0.div_with_reset$3$2_0.d_flip_flop_reset$1$2_0.clk pdiv$3_0.div_with_reset$3$2_0.d_flip_flop_reset$1$2_0.NAND_3in_nmosx3$1$1$3_1.a VP sg13_lv_pmos ad=55.5f pd=0.74u as=55.5f ps=0.74u w=0.15u l=0.13u
X53 gd pdiv$3_0.div_with_reset$3$2_0.d_flip_flop_reset$1$2_4.NAND_2in_nmosx2$1$1$5_0.a a_2797_2632# gd sg13_lv_nmos ad=0.114p pd=0.98u as=0.114p ps=0.98u w=0.6u l=0.13u
X54 a_7018_1798# d1 VP VP sg13_lv_pmos ad=0.114p pd=0.98u as=0.204p ps=1.88u w=0.6u l=0.13u
X55 a_5109_n2600# pdiv$3_0.passgate$3_1.A gd gd sg13_lv_nmos ad=0.114p pd=0.98u as=0.114p ps=0.98u w=0.6u l=0.13u
X56 MUX_8to1_0.passgate$1$2_1.in_n MUX_8to1_0.passgate$1$2_1.in_p VP VP sg13_lv_pmos ad=0.204p pd=1.88u as=0.204p ps=1.88u w=0.6u l=0.13u
X57 VP 2Div$2_0.d_flip_flop$3$2_2.NAND_3in_nmosx3$1$2_0.y 2Div$2_0.d_flip_flop$3$2_2.d VP sg13_lv_pmos ad=0.1005p pd=1.34u as=55.5f ps=0.74u w=0.15u l=0.13u
X58 VP pdiv$3_0.div_with_reset$3$2_0.d_flip_flop_reset$1$2_2.clk pdiv$3_0.count_data_check$2_0.c2 VP sg13_lv_pmos ad=55.5f pd=0.74u as=0.1005p ps=1.34u w=0.15u l=0.13u
X59 a_n453_5248# pdiv$3_0.d_flip_flop_reset$2$2_0.NAND_3in_nmosx3$1$2$3_1.a a_n555_5248# gd sg13_lv_nmos ad=0.114p pd=0.98u as=0.114p ps=0.98u w=0.6u l=0.13u
X60 VP d4 pdiv$3_0.NOR_2in$3$2_0.A VP sg13_lv_pmos ad=0.1005p pd=1.34u as=55.5f ps=0.74u w=0.15u l=0.13u
X61 a_n195_3040# pdiv$3_0.passgate$3_1.A gd gd sg13_lv_nmos ad=0.114p pd=0.98u as=0.114p ps=0.98u w=0.6u l=0.13u
X62 2Div$2_0.d_flip_flop$3$2_5.NAND_2in_nmosx2$3$2_0.a 2Div$2_0.d_flip_flop$3$2_5.NAND_3in_nmosx3$1$2_0.y VP VP sg13_lv_pmos ad=55.5f pd=0.74u as=0.1005p ps=1.34u w=0.15u l=0.13u
X63 VP pdiv$3_0.d_flip_flop_reset$2$2_0.NAND_2in_nmosx2$1$2$2_0.a pdiv$3_0.d_flip_flop_reset$2$2_0.NAND_3in_nmosx3$1$2$3_1.a VP sg13_lv_pmos ad=55.5f pd=0.74u as=55.5f ps=0.74u w=0.15u l=0.13u
X64 a_4123_16# pdiv$3_0.count_data_check$2_0.c3 a_4021_16# gd sg13_lv_nmos ad=0.114p pd=0.98u as=0.114p ps=0.98u w=0.6u l=0.13u
X65 gd pdiv$3_0.passgate$3_1.A a_1709_16# gd sg13_lv_nmos ad=0.114p pd=0.98u as=0.114p ps=0.98u w=0.6u l=0.13u
X66 pdiv$3_0.d_flip_flop_reset$2$2_0.NAND_2in_nmosx2$1$2$2_0.b pdiv$3_0.d_flip_flop_reset$2$2_0.NAND_2in_nmosx2$1$2$2_0.y VP VP sg13_lv_pmos ad=0.1005p pd=1.34u as=55.5f ps=0.74u w=0.15u l=0.13u
X67 a_n5259_2647# 2Div$2_0.d_flip_flop$3$2_1.NAND_2in_nmosx2$3$2_0.b 2Div$2_0.d_flip_flop$3$2_1.NAND_3in_nmosx3$1$2_0.y gd sg13_lv_nmos ad=57f pd=0.68u as=0.102p ps=1.28u w=0.3u l=0.13u
X68 MUX_8to1_0.passgate$1$2_0.B MUX_8to1_0.passgate$1$2_6.in_n MUX_8to1_0.passgate$1$2_6.A gd sg13_lv_nmos ad=0.102p pd=1.28u as=0.102p ps=1.28u w=0.3u l=0.15u
X69 a_7357_5263# pdiv$3_0.count_data_check$2_0.XNOR$1$2_0.y gd gd sg13_lv_nmos ad=57f pd=0.68u as=0.102p ps=1.28u w=0.3u l=0.13u
X70 a_2015_2632# pdiv$3_0.div_with_reset$3$2_0.d_flip_flop_reset$1$2_5.NAND_3in_nmosx3$1$1$3_1.a a_1913_2632# gd sg13_lv_nmos ad=0.114p pd=0.98u as=0.114p ps=0.98u w=0.6u l=0.13u
X71 gd MUX_8to1_0.in7 a_n7509_n2147# gd sg13_lv_nmos ad=0.102p pd=1.28u as=57f ps=0.68u w=0.3u l=0.13u
X72 VP pdiv$3_0.div_with_reset$3$2_0.d_flip_flop_reset$1$2_1.NAND_2in_nmosx2$1$1$5_0.a pdiv$3_0.div_with_reset$3$2_0.d_flip_flop_reset$1$2_1.NAND_2in_nmosx2$1$1$5_0.y VP sg13_lv_pmos ad=0.102p pd=1.28u as=57f ps=0.68u w=0.3u l=0.13u
X73 MUX_8to1_0.inverter_x4_ptap_mirror_fix$2$3_5.OUT a0 gd gd sg13_lv_nmos ad=0.204p pd=1.88u as=0.204p ps=1.88u w=0.6u l=0.13u
X74 VP pdiv$3_0.passgate$3_1.A pdiv$3_0.div_with_reset$3$2_0.d_flip_flop_reset$1$2_3.NAND_2in_nmosx2$1$1$5_0.a VP sg13_lv_pmos ad=55.5f pd=0.74u as=55.5f ps=0.74u w=0.15u l=0.13u
X75 a_3001_16# pdiv$3_0.div_with_reset$3$2_0.d_flip_flop_reset$1$2_2.NAND_2in_nmosx2$1$1$5_0.a gd gd sg13_lv_nmos ad=0.114p pd=0.98u as=0.114p ps=0.98u w=0.6u l=0.13u
X76 pdiv$3_0.count_data_check$2_0.c3 pdiv$3_0.div_with_reset$3$2_0.d_flip_flop_reset$1$2_1.clk a_5211_16# gd sg13_lv_nmos ad=0.204p pd=1.88u as=0.114p ps=0.98u w=0.6u l=0.13u
X77 VP pdiv$3_0.div_with_reset$3$2_0.d_flip_flop_reset$1$2_3.NAND_2in_nmosx2$1$1$5_0.b pdiv$3_0.div_with_reset$3$2_0.d_flip_flop_reset$1$2_3.NAND_3in_nmosx3$1$1$3_1.a VP sg13_lv_pmos ad=55.5f pd=0.74u as=0.1005p ps=1.34u w=0.15u l=0.13u
X78 VP MUX_8to1_0.inverter_x4_ptap_mirror_fix$2$3_7.OUT MUX_8to1_0.passgate$1$2_7.in_p VP sg13_lv_pmos ad=55.5f pd=0.74u as=55.5f ps=0.74u w=0.15u l=0.13u
X79 VP 2Div$2_0.d_flip_flop$3$2_3.d 2Div$2_0.d_flip_flop$3$2_3.NAND_2in_nmosx2$3$2_0.a VP sg13_lv_pmos ad=0.1005p pd=1.34u as=55.5f ps=0.74u w=0.15u l=0.13u
X80 MUX_8to1_0.inverter_x4_ptap_mirror_fix$2$3_6.OUT a1 gd gd sg13_lv_nmos ad=0.204p pd=1.88u as=0.204p ps=1.88u w=0.6u l=0.13u
X81 VP d1 pdiv$3_0.NOR_2in$3$2_0.B VP sg13_lv_pmos ad=0.1005p pd=1.34u as=55.5f ps=0.74u w=0.15u l=0.13u
X82 a_n6421_3085# 2Div$2_0.d_flip_flop$3$2_1.NAND_2in_nmosx2$3$2_0.b MUX_8to1_0.in3 gd sg13_lv_nmos ad=57f pd=0.68u as=0.102p ps=1.28u w=0.3u l=0.13u
X83 pdiv$3_0.passgate$3_1.in_p pdiv$3_0.NOR_2in$3$2_0.B gd gd sg13_lv_nmos ad=0.102p pd=1.28u as=57f ps=0.68u w=0.3u l=0.15u
X84 a_4304_4466# pdiv$3_0.NOR_2in$3$2_0.A pdiv$3_0.passgate$3_1.in_p VP sg13_lv_pmos ad=57f pd=0.68u as=0.102p ps=1.28u w=0.3u l=0.15u
X85 a_1607_2632# pdiv$3_0.div_with_reset$3$2_0.d_flip_flop_reset$1$2_4.clk pdiv$3_0.count_data_check$2_0.c0 gd sg13_lv_nmos ad=0.114p pd=0.98u as=0.204p ps=1.88u w=0.6u l=0.13u
X86 VP 2Div$2_0.d_flip_flop$3$2_6.NAND_2in_nmosx2$3$2_0.a 2Div$2_0.d_flip_flop$3$2_6.NAND_3in_nmosx3$1$2_0.y VP sg13_lv_pmos ad=0.1005p pd=1.34u as=55.5f ps=0.74u w=0.15u l=0.13u
X87 2Div$2_0.d_flip_flop$3$2_0.NAND_2in_nmosx2$3$2_0.y 2Div$2_0.d_flip_flop$3$2_0.NAND_2in_nmosx2$3$2_0.a VP VP sg13_lv_pmos ad=55.5f pd=0.74u as=0.1005p ps=1.34u w=0.15u l=0.13u
X88 gd pdiv$3_0.passgate$3_1.A a_621_16# gd sg13_lv_nmos ad=0.114p pd=0.98u as=0.114p ps=0.98u w=0.6u l=0.13u
X89 a_n6013_5263# 2Div$2_0.d_flip_flop$3$2_2.NAND_3in_nmosx3$1$2_0.y 2Div$2_0.d_flip_flop$3$2_2.NAND_2in_nmosx2$3$2_0.a gd sg13_lv_nmos ad=57f pd=0.68u as=0.102p ps=1.28u w=0.3u l=0.13u
X90 pdiv$3_0.div_with_reset$3$2_0.d_flip_flop_reset$1$2_1.NAND_2in_nmosx2$1$1$5_0.a pdiv$3_0.div_with_reset$3$2_0.d_flip_flop_reset$1$2_1.NAND_3in_nmosx3$1$1$3_1.a a_927_n2600# gd sg13_lv_nmos ad=0.204p pd=1.88u as=0.114p ps=0.98u w=0.6u l=0.13u
X91 MUX_8to1_0.passgate$1$2_0.B MUX_8to1_0.passgate$1$2_5.in_p MUX_8to1_0.passgate$1$2_5.A VP sg13_lv_pmos ad=0.102p pd=1.28u as=0.102p ps=1.28u w=0.3u l=0.15u
X92 a_4803_2632# pdiv$3_0.div_with_reset$3$2_0.d_flip_flop_reset$1$2_3.clk pdiv$3_0.count_data_check$2_0.c1 gd sg13_lv_nmos ad=0.114p pd=0.98u as=0.204p ps=1.88u w=0.6u l=0.13u
X93 a_6702_1847# pdiv$3_0.count_data_check$2_0.c1 gd gd sg13_lv_nmos ad=0.1005p pd=1.34u as=0.1005p ps=1.34u w=0.15u l=0.13u
X94 a_7428_n2099# a_6346_n2099# pdiv$3_0.count_data_check$2_0.XNOR$1$2_0.y gd sg13_lv_nmos ad=55.5f pd=0.74u as=0.1005p ps=1.34u w=0.15u l=0.13u
X95 pdiv$3_0.div_with_reset$3$2_0.d_flip_flop_reset$1$2_2.NAND_3in_nmosx3$1$1$3_1.a pdiv$3_0.div_with_reset$3$2_0.d_flip_flop_reset$1$2_2.NAND_2in_nmosx2$1$1$5_0.a VP VP sg13_lv_pmos ad=55.5f pd=0.74u as=55.5f ps=0.74u w=0.15u l=0.13u
X96 MUX_8to1_0.passgate$1$2_1.A MUX_8to1_0.in6 gd gd sg13_lv_nmos ad=0.204p pd=1.88u as=0.204p ps=1.88u w=0.6u l=0.13u
X97 VP MUX_8to1_0.inverter_x4_ptap_mirror_fix$2$3_7.OUT MUX_8to1_0.passgate$1$2_4.in_p VP sg13_lv_pmos ad=55.5f pd=0.74u as=55.5f ps=0.74u w=0.15u l=0.13u
X98 pdiv$3_0.div_with_reset$3$2_0.d_flip_flop_reset$1$2_0.NAND_2in_nmosx2$1$1$5_0.a pdiv$3_0.div_with_reset$3$2_0.d_flip_flop_reset$1$2_0.NAND_3in_nmosx3$1$1$3_1.a VP VP sg13_lv_pmos ad=0.1005p pd=1.34u as=55.5f ps=0.74u w=0.15u l=0.13u
X99 pdiv$3_0.count_data_check$2_0.c3 pdiv$3_0.div_with_reset$3$2_0.d_flip_flop_reset$1$2_1.clk VP VP sg13_lv_pmos ad=0.1005p pd=1.34u as=55.5f ps=0.74u w=0.15u l=0.13u
X100 pdiv$3_0.div_with_reset$3$2_0.d_flip_flop_reset$1$2_4.NAND_2in_nmosx2$1$1$5_0.a pdiv$3_0.count_data_check$2_0.c1 VP VP sg13_lv_pmos ad=55.5f pd=0.74u as=55.5f ps=0.74u w=0.15u l=0.13u
X101 a_6702_3133# pdiv$3_0.count_data_check$2_0.c0 VP VP sg13_lv_pmos ad=0.1005p pd=1.34u as=0.1005p ps=1.34u w=0.15u l=0.13u
X102 a_7434_1258# a_6702_517# pdiv$3_0.count_data_check$2_0.XNOR$1$2_4.y VP sg13_lv_pmos ad=0.114p pd=0.98u as=0.204p ps=1.88u w=0.6u l=0.13u
X103 a_n7537_n2585# MUX_8to1_0.in7 a_n7639_n2585# gd sg13_lv_nmos ad=57f pd=0.68u as=57f ps=0.68u w=0.3u l=0.13u
X104 a_n2435_31# MUX_8to1_0.inverter_x4_ptap_mirror_fix$2$3_6.OUT gd gd sg13_lv_nmos ad=57f pd=0.68u as=0.102p ps=1.28u w=0.3u l=0.13u
X105 MUX_8to1_0.inverter_x4_ptap_mirror_fix$2$3_8.OUT clk gd gd sg13_lv_nmos ad=0.204p pd=1.88u as=0.204p ps=1.88u w=0.6u l=0.13u
X106 MUX_8to1_0.passgate$1$2_1.in_p MUX_8to1_0.inverter_x4_ptap_mirror_fix$2$3_6.OUT VP VP sg13_lv_pmos ad=55.5f pd=0.74u as=0.1005p ps=1.34u w=0.15u l=0.13u
X107 MUX_8to1_0.passgate$1$2_7.A MUX_8to1_0.in4 VP VP sg13_lv_pmos ad=0.204p pd=1.88u as=0.204p ps=1.88u w=0.6u l=0.13u
X108 a_n5129_3085# 2Div$2_0.d_flip_flop$3$2_1.NAND_2in_nmosx2$3$2_0.y 2Div$2_0.d_flip_flop$3$2_1.NAND_2in_nmosx2$3$2_0.b gd sg13_lv_nmos ad=57f pd=0.68u as=0.102p ps=1.28u w=0.3u l=0.13u
X109 VP 2Div$2_0.d_flip_flop$3$2_4.d 2Div$2_0.d_flip_flop$3$2_4.NAND_2in_nmosx2$3$2_0.a VP sg13_lv_pmos ad=0.1005p pd=1.34u as=55.5f ps=0.74u w=0.15u l=0.13u
X110 a_n6013_31# 2Div$2_0.d_flip_flop$3$2_6.NAND_3in_nmosx3$1$2_0.y 2Div$2_0.d_flip_flop$3$2_6.NAND_2in_nmosx2$3$2_0.a gd sg13_lv_nmos ad=57f pd=0.68u as=0.102p ps=1.28u w=0.3u l=0.13u
X111 VP pdiv$3_0.inverter_x8$3_0.IN pdiv$3_0.passgate$3_1.A VP sg13_lv_pmos ad=0.408p pd=3.08u as=0.408p ps=3.08u w=1.2u l=0.13u
X112 a_3817_2632# pdiv$3_0.count_data_check$2_0.c1 a_3715_2632# gd sg13_lv_nmos ad=0.114p pd=0.98u as=0.114p ps=0.98u w=0.6u l=0.13u
X113 pdiv$3_0.count_data_check$2_0.XNOR$1$2_4.y d2 a_7020_517# gd sg13_lv_nmos ad=0.1005p pd=1.34u as=55.5f ps=0.74u w=0.15u l=0.13u
X114 gd d1 a_5051_5701# gd sg13_lv_nmos ad=0.102p pd=1.28u as=57f ps=0.68u w=0.3u l=0.13u
X115 VP pdiv$3_0.d_flip_flop_reset$2$2_0.reset pdiv$3_0.d_flip_flop_reset$2$2_0.NAND_2in_nmosx2$1$2$2_0.a VP sg13_lv_pmos ad=55.5f pd=0.74u as=55.5f ps=0.74u w=0.15u l=0.13u
X116 a_n2333_5263# MUX_8to1_0.inverter_x4_ptap_mirror_fix$2$3_7.OUT a_n2435_5263# gd sg13_lv_nmos ad=57f pd=0.68u as=57f ps=0.68u w=0.3u l=0.13u
X117 a_3001_3040# pdiv$3_0.passgate$3_1.A gd gd sg13_lv_nmos ad=0.114p pd=0.98u as=0.114p ps=0.98u w=0.6u l=0.13u
X118 pdiv$3_0.div_with_reset$3$2_0.d_flip_flop_reset$1$2_4.NAND_3in_nmosx3$1$1$3_1.a pdiv$3_0.div_with_reset$3$2_0.d_flip_flop_reset$1$2_4.NAND_2in_nmosx2$1$1$5_0.b a_3103_2632# gd sg13_lv_nmos ad=0.204p pd=1.88u as=0.114p ps=0.98u w=0.6u l=0.13u
X119 gd pdiv$3_0.passgate$3_1.A a_3817_n2600# gd sg13_lv_nmos ad=0.114p pd=0.98u as=0.114p ps=0.98u w=0.6u l=0.13u
X120 out_div pdiv$3_0.d_flip_flop_reset$2$2_0.NAND_2in_nmosx2$1$2$2_0.b VP VP sg13_lv_pmos ad=57f pd=0.68u as=0.102p ps=1.28u w=0.3u l=0.13u
X121 pdiv$3_0.div_with_reset$3$2_0.d_flip_flop_reset$1$2_5.NAND_2in_nmosx2$1$1$5_0.b pdiv$3_0.div_with_reset$3$2_0.d_flip_flop_reset$1$2_5.NAND_2in_nmosx2$1$1$5_0.y a_n93_3040# gd sg13_lv_nmos ad=0.204p pd=1.88u as=0.114p ps=0.98u w=0.6u l=0.13u
X122 gd 2Div$2_0.d_flip_flop$3$2_0.d a_n8393_2647# gd sg13_lv_nmos ad=0.102p pd=1.28u as=57f ps=0.68u w=0.3u l=0.13u
X123 pdiv$3_0.div_with_reset$3$2_0.d_flip_flop_reset$1$2_2.NAND_2in_nmosx2$1$1$5_0.b pdiv$3_0.div_with_reset$3$2_0.d_flip_flop_reset$1$2_2.NAND_2in_nmosx2$1$1$5_0.y VP VP sg13_lv_pmos ad=0.1005p pd=1.34u as=55.5f ps=0.74u w=0.15u l=0.13u
X124 a_4021_16# pdiv$3_0.passgate$3_1.A gd gd sg13_lv_nmos ad=0.114p pd=0.98u as=0.114p ps=0.98u w=0.6u l=0.13u
X125 a_2695_3040# pdiv$3_0.div_with_reset$3$2_0.d_flip_flop_reset$1$2_4.NAND_2in_nmosx2$1$1$5_0.y pdiv$3_0.div_with_reset$3$2_0.d_flip_flop_reset$1$2_4.NAND_2in_nmosx2$1$1$5_0.b gd sg13_lv_nmos ad=0.114p pd=0.98u as=0.204p ps=1.88u w=0.6u l=0.13u
X126 pdiv$3_0.div_with_reset$3$2_0.d_flip_flop_reset$1$2_0.NAND_2in_nmosx2$1$1$5_0.b pdiv$3_0.passgate$3_1.A VP VP sg13_lv_pmos ad=55.5f pd=0.74u as=55.5f ps=0.74u w=0.15u l=0.13u
X127 a_n8393_31# 2Div$2_0.d_flip_flop$3$2_5.NAND_3in_nmosx3$1$2_0.y 2Div$2_0.d_flip_flop$3$2_5.NAND_2in_nmosx2$3$2_0.a gd sg13_lv_nmos ad=57f pd=0.68u as=0.102p ps=1.28u w=0.3u l=0.13u
X128 pdiv$3_0.div_with_reset$3$2_0.d_flip_flop_reset$1$2_4.NAND_3in_nmosx3$1$1$3_1.a pdiv$3_0.div_with_reset$3$2_0.d_flip_flop_reset$1$2_4.NAND_2in_nmosx2$1$1$5_0.b VP VP sg13_lv_pmos ad=0.1005p pd=1.34u as=55.5f ps=0.74u w=0.15u l=0.13u
X129 VP pdiv$3_0.div_with_reset$3$2_0.d_flip_flop_reset$1$2_3.clk pdiv$3_0.count_data_check$2_0.c1 VP sg13_lv_pmos ad=55.5f pd=0.74u as=0.1005p ps=1.34u w=0.15u l=0.13u
X130 a_3103_n2600# pdiv$3_0.div_with_reset$3$2_0.d_flip_flop_reset$1$2_0.clk a_3001_n2600# gd sg13_lv_nmos ad=0.114p pd=0.98u as=0.114p ps=0.98u w=0.6u l=0.13u
X131 MUX_8to1_0.passgate$1$2_0.A MUX_8to1_0.in7 gd gd sg13_lv_nmos ad=0.204p pd=1.88u as=0.204p ps=1.88u w=0.6u l=0.13u
X132 a_597_n2192# pdiv$3_0.div_with_reset$3$2_0.d_flip_flop_reset$1$2_1.NAND_2in_nmosx2$1$1$5_0.b gd gd sg13_lv_nmos ad=0.114p pd=0.98u as=0.204p ps=1.88u w=0.6u l=0.13u
X133 a_7428_517# a_6346_517# pdiv$3_0.count_data_check$2_0.XNOR$1$2_4.y gd sg13_lv_nmos ad=55.5f pd=0.74u as=0.1005p ps=1.34u w=0.15u l=0.13u
X134 VP pdiv$3_0.div_with_reset$3$2_0.d_flip_flop_reset$1$2_1.NAND_2in_nmosx2$1$1$5_0.y pdiv$3_0.div_with_reset$3$2_0.d_flip_flop_reset$1$2_1.NAND_2in_nmosx2$1$1$5_0.b VP sg13_lv_pmos ad=55.5f pd=0.74u as=0.1005p ps=1.34u w=0.15u l=0.13u
X135 pdiv$3_0.div_with_reset$3$2_0.d_flip_flop_reset$1$2_1.NAND_2in_nmosx2$1$1$5_0.a pdiv$3_0.div_with_reset$3$2_0.d_flip_flop_reset$1$2_1.NAND_3in_nmosx3$1$1$3_1.a VP VP sg13_lv_pmos ad=0.1005p pd=1.34u as=55.5f ps=0.74u w=0.15u l=0.13u
X136 gd pdiv$3_0.passgate$3_1.A a_2797_n2192# gd sg13_lv_nmos ad=0.114p pd=0.98u as=0.114p ps=0.98u w=0.6u l=0.13u
X137 gd 2Div$2_0.d_flip_flop$3$2_2.NAND_3in_nmosx3$1$2_0.y a_n6761_5263# gd sg13_lv_nmos ad=0.102p pd=1.28u as=57f ps=0.68u w=0.3u l=0.13u
X138 VP pdiv$3_0.div_with_reset$3$2_0.d_flip_flop_reset$1$2_1.NAND_3in_nmosx3$1$1$3_1.a pdiv$3_0.div_with_reset$3$2_0.d_flip_flop_reset$1$2_1.NAND_2in_nmosx2$1$1$5_0.a VP sg13_lv_pmos ad=55.5f pd=0.74u as=0.1005p ps=1.34u w=0.15u l=0.13u
X139 VP pdiv$3_0.div_with_reset$3$2_0.d_flip_flop_reset$1$2_0.NAND_2in_nmosx2$1$1$5_0.b pdiv$3_0.div_with_reset$3$2_0.d_flip_flop_reset$1$2_0.q VP sg13_lv_pmos ad=0.102p pd=1.28u as=57f ps=0.68u w=0.3u l=0.13u
X140 VP pdiv$3_0.d_flip_flop_reset$2$2_0.reset pdiv$3_0.d_flip_flop_reset$2$2_0.NAND_2in_nmosx2$1$2$2_0.b VP sg13_lv_pmos ad=55.5f pd=0.74u as=55.5f ps=0.74u w=0.15u l=0.13u
X141 MUX_8to1_0.passgate$1$2_0.B MUX_8to1_0.passgate$1$2_4.in_p MUX_8to1_0.inverter_x4_ptap_mirror_fix$2$3_10.OUT VP sg13_lv_pmos ad=0.102p pd=1.28u as=0.102p ps=1.28u w=0.3u l=0.15u
X142 pdiv$3_0.count_data_check$2_0.NAND_3in$2_1/NAND_3in_nmosx3$5$1$2_0.y pdiv$3_0.count_data_check$2_0.XNOR$1$2_4.y a_7459_5701# gd sg13_lv_nmos ad=0.102p pd=1.28u as=57f ps=0.68u w=0.3u l=0.13u
X143 a_6346_n769# d3 VP VP sg13_lv_pmos ad=0.1005p pd=1.34u as=0.1005p ps=1.34u w=0.15u l=0.13u
X144 gd 2Div$2_0.d_flip_flop$3$2_6.d a_n6013_31# gd sg13_lv_nmos ad=0.102p pd=1.28u as=57f ps=0.68u w=0.3u l=0.13u
X145 pdiv$3_0.div_with_reset$3$2_0.d_flip_flop_reset$1$2_5.NAND_2in_nmosx2$1$1$5_0.a pdiv$3_0.div_with_reset$3$2_0.d_flip_flop_reset$1$2_5.NAND_3in_nmosx3$1$1$3_1.a a_927_2632# gd sg13_lv_nmos ad=0.204p pd=1.88u as=0.114p ps=0.98u w=0.6u l=0.13u
X146 pdiv$3_0.div_with_reset$3$2_0.d_flip_flop_reset$1$2_5.NAND_2in_nmosx2$1$1$5_0.a pdiv$3_0.div_with_reset$3$2_0.d_flip_flop_reset$1$2_5.NAND_3in_nmosx3$1$1$3_1.a VP VP sg13_lv_pmos ad=0.1005p pd=1.34u as=55.5f ps=0.74u w=0.15u l=0.13u
X147 VP pdiv$3_0.passgate$3_1.A pdiv$3_0.count_data_check$2_0.c2 VP sg13_lv_pmos ad=55.5f pd=0.74u as=55.5f ps=0.74u w=0.15u l=0.13u
X148 MUX_8to1_0.passgate$1$2_0.A MUX_8to1_0.in7 VP VP sg13_lv_pmos ad=0.204p pd=1.88u as=0.204p ps=1.88u w=0.6u l=0.13u
X149 VP 2Div$2_0.d_flip_flop$3$2_5.d MUX_8to1_0.in6 VP sg13_lv_pmos ad=0.1005p pd=1.34u as=55.5f ps=0.74u w=0.15u l=0.13u
X150 MUX_8to1_0.inverter_x4_ptap_mirror_fix$2$3_7.OUT a2 VP VP sg13_lv_pmos ad=0.204p pd=1.88u as=0.204p ps=1.88u w=0.6u l=0.13u
X151 pdiv$3_0.div_with_reset$3$2_0.d_flip_flop_reset$1$2_0.NAND_2in_nmosx2$1$1$5_0.a pdiv$3_0.passgate$3_1.A VP VP sg13_lv_pmos ad=55.5f pd=0.74u as=55.5f ps=0.74u w=0.15u l=0.13u
X152 VP pdiv$3_0.count_data_check$2_0.NAND_3in$2_0/NAND_3in_nmosx3$5$1$2_0.y a_6888_6498# VP sg13_lv_pmos ad=0.102p pd=1.28u as=57f ps=0.68u w=0.3u l=0.15u
X153 a_6346_n3385# d5 gd gd sg13_lv_nmos ad=0.1005p pd=1.34u as=0.1005p ps=1.34u w=0.15u l=0.13u
X154 VP pdiv$3_0.passgate$3_1.A pdiv$3_0.count_data_check$2_0.c3 VP sg13_lv_pmos ad=55.5f pd=0.74u as=55.5f ps=0.74u w=0.15u l=0.13u
X155 VP pdiv$3_0.passgate$3_1.B pdiv$3_0.d_flip_flop_reset$2$2_0.NAND_3in_nmosx3$1$2$3_1.a VP sg13_lv_pmos ad=55.5f pd=0.74u as=55.5f ps=0.74u w=0.15u l=0.13u
X156 a_4123_2632# pdiv$3_0.count_data_check$2_0.c1 a_4021_2632# gd sg13_lv_nmos ad=0.114p pd=0.98u as=0.114p ps=0.98u w=0.6u l=0.13u
X157 VP 2Div$2_0.d_flip_flop$3$2_0.NAND_2in_nmosx2$3$2_0.a 2Div$2_0.d_flip_flop$3$2_0.NAND_3in_nmosx3$1$2_0.y VP sg13_lv_pmos ad=0.1005p pd=1.34u as=55.5f ps=0.74u w=0.15u l=0.13u
X158 MUX_8to1_0.passgate$1$2_0.B MUX_8to1_0.passgate$1$2_1.in_n MUX_8to1_0.passgate$1$2_1.A gd sg13_lv_nmos ad=0.102p pd=1.28u as=0.102p ps=1.28u w=0.3u l=0.15u
X159 a_1859_5248# pdiv$3_0.d_flip_flop_reset$2$2_0.NAND_2in_nmosx2$1$2$2_0.a gd gd sg13_lv_nmos ad=0.114p pd=0.98u as=0.114p ps=0.98u w=0.6u l=0.13u
X160 2Div$2_0.d_flip_flop$3$2_6.NAND_2in_nmosx2$3$2_0.y 2Div$2_0.d_flip_flop$3$2_6.NAND_2in_nmosx2$3$2_0.a VP VP sg13_lv_pmos ad=55.5f pd=0.74u as=0.1005p ps=1.34u w=0.15u l=0.13u
X161 a_7434_n3434# a_6702_n3385# pdiv$3_0.count_data_check$2_0.XNOR$1$2_3.y VP sg13_lv_pmos ad=0.114p pd=0.98u as=0.204p ps=1.88u w=0.6u l=0.13u
X162 gd pdiv$3_0.count_data_check$2_0.c0 a_7428_3133# gd sg13_lv_nmos ad=0.1005p pd=1.34u as=55.5f ps=0.74u w=0.15u l=0.13u
X163 a_1553_5248# pdiv$3_0.d_flip_flop_reset$2$2_0.NAND_2in_nmosx2$1$2$2_0.b pdiv$3_0.d_flip_flop_reset$2$2_0.NAND_3in_nmosx3$1$2$3_1.a gd sg13_lv_nmos ad=0.114p pd=0.98u as=0.204p ps=1.88u w=0.6u l=0.13u
X164 pdiv$3_0.div_with_reset$3$2_0.d_flip_flop_reset$1$2_3.NAND_2in_nmosx2$1$1$5_0.b pdiv$3_0.div_with_reset$3$2_0.d_flip_flop_reset$1$2_3.clk VP VP sg13_lv_pmos ad=55.5f pd=0.74u as=55.5f ps=0.74u w=0.15u l=0.13u
X165 pdiv$3_0.div_with_reset$3$2_0.d_flip_flop_reset$1$2_1.NAND_2in_nmosx2$1$1$5_0.b pdiv$3_0.div_with_reset$3$2_0.d_flip_flop_reset$1$2_1.NAND_2in_nmosx2$1$1$5_0.y VP VP sg13_lv_pmos ad=0.1005p pd=1.34u as=55.5f ps=0.74u w=0.15u l=0.13u
X166 2Div$2_0.d_flip_flop$3$2_6.NAND_2in_nmosx2$3$2_0.b 2Div$2_0.d_flip_flop$3$2_6.NAND_2in_nmosx2$3$2_0.y VP VP sg13_lv_pmos ad=55.5f pd=0.74u as=0.1005p ps=1.34u w=0.15u l=0.13u
X167 pdiv$3_0.div_with_reset$3$2_0.d_flip_flop_reset$1$2_5.NAND_3in_nmosx3$1$1$3_1.a MUX_8to1_0.out VP VP sg13_lv_pmos ad=55.5f pd=0.74u as=55.5f ps=0.74u w=0.15u l=0.13u
X168 a_7434_3874# a_6702_3133# pdiv$3_0.count_data_check$2_0.XNOR$1$2_1.y VP sg13_lv_pmos ad=0.114p pd=0.98u as=0.204p ps=1.88u w=0.6u l=0.13u
X169 VP 2Div$2_0.d_flip_flop$3$2_4.d MUX_8to1_0.in7 VP sg13_lv_pmos ad=0.1005p pd=1.34u as=55.5f ps=0.74u w=0.15u l=0.13u
X170 VP 2Div$2_0.d_flip_flop$3$2_6.NAND_2in_nmosx2$3$2_0.b 2Div$2_0.d_flip_flop$3$2_6.NAND_3in_nmosx3$1$2_0.y VP sg13_lv_pmos ad=55.5f pd=0.74u as=0.1005p ps=1.34u w=0.15u l=0.13u
X171 gd 2Div$2_0.d_flip_flop$3$2_5.d a_n8801_469# gd sg13_lv_nmos ad=0.102p pd=1.28u as=57f ps=0.68u w=0.3u l=0.13u
X172 MUX_8to1_0.passgate$1$2_2.in_p a1 VP VP sg13_lv_pmos ad=55.5f pd=0.74u as=0.1005p ps=1.34u w=0.15u l=0.13u
X173 MUX_8to1_0.passgate$1$2_0.B MUX_8to1_0.passgate$1$2_2.in_p MUX_8to1_0.inverter_x4_ptap_mirror_fix$2$3_4.OUT VP sg13_lv_pmos ad=0.102p pd=1.28u as=0.102p ps=1.28u w=0.3u l=0.15u
X174 VP MUX_8to1_0.in5 2Div$2_0.d_flip_flop$3$2_5.NAND_2in_nmosx2$3$2_0.b VP sg13_lv_pmos ad=0.1005p pd=1.34u as=55.5f ps=0.74u w=0.15u l=0.13u
X175 VP MUX_8to1_0.inverter_x4_ptap_mirror_fix$2$3_5.OUT MUX_8to1_0.passgate$1$2_0.in_p VP sg13_lv_pmos ad=55.5f pd=0.74u as=55.5f ps=0.74u w=0.15u l=0.13u
X176 a_n5259_5263# 2Div$2_0.d_flip_flop$3$2_2.NAND_2in_nmosx2$3$2_0.b 2Div$2_0.d_flip_flop$3$2_2.NAND_3in_nmosx3$1$2_0.y gd sg13_lv_nmos ad=57f pd=0.68u as=0.102p ps=1.28u w=0.3u l=0.13u
X177 a_621_2632# pdiv$3_0.count_data_check$2_0.c0 a_519_2632# gd sg13_lv_nmos ad=0.114p pd=0.98u as=0.114p ps=0.98u w=0.6u l=0.13u
X178 a_1913_n2600# pdiv$3_0.passgate$3_1.A gd gd sg13_lv_nmos ad=0.114p pd=0.98u as=0.114p ps=0.98u w=0.6u l=0.13u
X179 2Div$2_0.d_flip_flop$3$2_4.NAND_2in_nmosx2$3$2_0.a 2Div$2_0.d_flip_flop$3$2_4.NAND_3in_nmosx3$1$2_0.y VP VP sg13_lv_pmos ad=55.5f pd=0.74u as=0.1005p ps=1.34u w=0.15u l=0.13u
X180 gd 2Div$2_0.d_flip_flop$3$2_6.NAND_2in_nmosx2$3$2_0.b a_n5741_469# gd sg13_lv_nmos ad=0.102p pd=1.28u as=57f ps=0.68u w=0.3u l=0.13u
X181 pdiv$3_0.count_data_check$2_0.c3 pdiv$3_0.passgate$3_1.A VP VP sg13_lv_pmos ad=55.5f pd=0.74u as=55.5f ps=0.74u w=0.15u l=0.13u
X182 2Div$2_0.d_flip_flop$3$2_5.NAND_3in_nmosx3$1$2_0.y MUX_8to1_0.in5 VP VP sg13_lv_pmos ad=55.5f pd=0.74u as=55.5f ps=0.74u w=0.15u l=0.13u
X183 a_1961_5656# pdiv$3_0.passgate$3_1.B a_1859_5656# gd sg13_lv_nmos ad=0.114p pd=0.98u as=0.114p ps=0.98u w=0.6u l=0.13u
X184 VP pdiv$3_0.div_with_reset$3$2_0.d_flip_flop_reset$1$2_5.NAND_3in_nmosx3$1$1$3_1.a pdiv$3_0.count_data_check$2_0.c0 VP sg13_lv_pmos ad=55.5f pd=0.74u as=55.5f ps=0.74u w=0.15u l=0.13u
X185 VP pdiv$3_0.div_with_reset$3$2_0.d_flip_flop_reset$1$2_0.NAND_2in_nmosx2$1$1$5_0.a pdiv$3_0.div_with_reset$3$2_0.d_flip_flop_reset$1$2_0.NAND_3in_nmosx3$1$1$3_1.a VP sg13_lv_pmos ad=55.5f pd=0.74u as=55.5f ps=0.74u w=0.15u l=0.13u
X186 MUX_8to1_0.passgate$1$2_1.in_p a0 a_n2333_31# gd sg13_lv_nmos ad=0.102p pd=1.28u as=57f ps=0.68u w=0.3u l=0.13u
X187 pdiv$3_0.count_data_check$2_0.c5 pdiv$3_0.div_with_reset$3$2_0.d_flip_flop_reset$1$2_0.NAND_3in_nmosx3$1$1$3_1.a VP VP sg13_lv_pmos ad=55.5f pd=0.74u as=55.5f ps=0.74u w=0.15u l=0.13u
X188 a_1655_5656# pdiv$3_0.passgate$3_1.B a_1553_5656# gd sg13_lv_nmos ad=0.114p pd=0.98u as=0.114p ps=0.98u w=0.6u l=0.13u
X189 a_n195_2632# pdiv$3_0.div_with_reset$3$2_0.d_flip_flop_reset$1$2_5.NAND_2in_nmosx2$1$1$5_0.a gd gd sg13_lv_nmos ad=0.114p pd=0.98u as=0.114p ps=0.98u w=0.6u l=0.13u
X190 a_n9141_n2585# MUX_8to1_0.in8 2Div$2_0.d_flip_flop$3$2_3.d gd sg13_lv_nmos ad=57f pd=0.68u as=0.102p ps=1.28u w=0.3u l=0.13u
X191 a_597_424# pdiv$3_0.div_with_reset$3$2_0.d_flip_flop_reset$1$2_3.NAND_2in_nmosx2$1$1$5_0.b gd gd sg13_lv_nmos ad=0.114p pd=0.98u as=0.204p ps=1.88u w=0.6u l=0.13u
X192 pdiv$3_0.div_with_reset$3$2_0.d_flip_flop_reset$1$2_4.NAND_2in_nmosx2$1$1$5_0.a pdiv$3_0.passgate$3_1.A VP VP sg13_lv_pmos ad=55.5f pd=0.74u as=55.5f ps=0.74u w=0.15u l=0.13u
X193 a_6346_n2099# d4 VP VP sg13_lv_pmos ad=0.1005p pd=1.34u as=0.1005p ps=1.34u w=0.15u l=0.13u
X194 VP MUX_8to1_0.inverter_x4_ptap_mirror_fix$2$3_7.OUT MUX_8to1_0.passgate$1$2_5.in_p VP sg13_lv_pmos ad=55.5f pd=0.74u as=55.5f ps=0.74u w=0.15u l=0.13u
X195 gd pdiv$3_0.passgate$3_1.A a_n399_n2192# gd sg13_lv_nmos ad=0.114p pd=0.98u as=0.114p ps=0.98u w=0.6u l=0.13u
X196 VP 2Div$2_0.d_flip_flop$3$2_6.NAND_3in_nmosx3$1$2_0.y 2Div$2_0.d_flip_flop$3$2_6.d VP sg13_lv_pmos ad=0.1005p pd=1.34u as=55.5f ps=0.74u w=0.15u l=0.13u
X197 pdiv$3_0.div_with_reset$3$2_0.d_flip_flop_reset$1$2_4.NAND_2in_nmosx2$1$1$5_0.b pdiv$3_0.div_with_reset$3$2_0.d_flip_flop_reset$1$2_4.NAND_2in_nmosx2$1$1$5_0.y VP VP sg13_lv_pmos ad=0.1005p pd=1.34u as=55.5f ps=0.74u w=0.15u l=0.13u
X198 a_6702_517# pdiv$3_0.count_data_check$2_0.c2 VP VP sg13_lv_pmos ad=0.1005p pd=1.34u as=0.1005p ps=1.34u w=0.15u l=0.13u
X199 VP pdiv$3_0.d_flip_flop_reset$2$2_0.NAND_3in_nmosx3$1$2$3_1.a pdiv$3_0.d_flip_flop_reset$2$2_0.NAND_2in_nmosx2$1$2$2_0.a VP sg13_lv_pmos ad=55.5f pd=0.74u as=0.1005p ps=1.34u w=0.15u l=0.13u
X200 pdiv$3_0.count_data_check$2_0.NAND_3in$2_0/NAND_3in_nmosx3$5$1$2_0.y pdiv$3_0.count_data_check$2_0.XNOR$1$2_0.y VP VP sg13_lv_pmos ad=55.5f pd=0.74u as=0.1005p ps=1.34u w=0.15u l=0.13u
X201 a_4541_n2192# pdiv$3_0.count_data_check$2_0.c5 gd gd sg13_lv_nmos ad=0.114p pd=0.98u as=0.204p ps=1.88u w=0.6u l=0.13u
X202 a_6702_1847# pdiv$3_0.count_data_check$2_0.c1 VP VP sg13_lv_pmos ad=0.1005p pd=1.34u as=0.1005p ps=1.34u w=0.15u l=0.13u
X203 VP pdiv$3_0.d_flip_flop_reset$2$2_0.d pdiv$3_0.d_flip_flop_reset$2$2_0.NAND_2in_nmosx2$1$2$2_0.a VP sg13_lv_pmos ad=55.5f pd=0.74u as=55.5f ps=0.74u w=0.15u l=0.13u
X204 a_n6761_2647# MUX_8to1_0.in3 2Div$2_0.d_flip_flop$3$2_1.d gd sg13_lv_nmos ad=57f pd=0.68u as=0.102p ps=1.28u w=0.3u l=0.13u
X205 VP 2Div$2_0.d_flip_flop$3$2_1.d 2Div$2_0.d_flip_flop$3$2_1.NAND_2in_nmosx2$3$2_0.a VP sg13_lv_pmos ad=0.1005p pd=1.34u as=55.5f ps=0.74u w=0.15u l=0.13u
X206 VP 2Div$2_0.d_flip_flop$3$2_4.NAND_2in_nmosx2$3$2_0.b 2Div$2_0.d_flip_flop$3$2_4.NAND_3in_nmosx3$1$2_0.y VP sg13_lv_pmos ad=55.5f pd=0.74u as=0.1005p ps=1.34u w=0.15u l=0.13u
X207 a_n2435_5701# MUX_8to1_0.inverter_x4_ptap_mirror_fix$2$3_6.OUT gd gd sg13_lv_nmos ad=57f pd=0.68u as=0.102p ps=1.28u w=0.3u l=0.13u
X208 pdiv$3_0.div_with_reset$3$2_0.d_flip_flop_reset$1$2_2.NAND_2in_nmosx2$1$1$5_0.y pdiv$3_0.div_with_reset$3$2_0.d_flip_flop_reset$1$2_2.NAND_2in_nmosx2$1$1$5_0.b VP VP sg13_lv_pmos ad=57f pd=0.68u as=0.102p ps=1.28u w=0.3u l=0.13u
X209 pdiv$3_0.count_data_check$2_0.XNOR$1$2_5.y d3 a_7020_13# gd sg13_lv_nmos ad=0.1005p pd=1.34u as=55.5f ps=0.74u w=0.15u l=0.13u
X210 a_7020_13# a_6702_n769# gd gd sg13_lv_nmos ad=55.5f pd=0.74u as=0.1005p ps=1.34u w=0.15u l=0.13u
X211 a_839_5248# pdiv$3_0.d_flip_flop_reset$2$2_0.reset gd gd sg13_lv_nmos ad=0.114p pd=0.98u as=0.114p ps=0.98u w=0.6u l=0.13u
X212 a_5051_5263# d5 a_4949_5263# gd sg13_lv_nmos ad=57f pd=0.68u as=57f ps=0.68u w=0.3u l=0.13u
X213 a_6702_3133# pdiv$3_0.count_data_check$2_0.c0 gd gd sg13_lv_nmos ad=0.1005p pd=1.34u as=0.1005p ps=1.34u w=0.15u l=0.13u
X214 VP MUX_8to1_0.inverter_x4_ptap_mirror_fix$2$3_7.OUT MUX_8to1_0.passgate$1$2_3.in_p VP sg13_lv_pmos ad=55.5f pd=0.74u as=55.5f ps=0.74u w=0.15u l=0.13u
X215 gd pdiv$3_0.passgate$3_1.A a_621_n2600# gd sg13_lv_nmos ad=0.114p pd=0.98u as=0.114p ps=0.98u w=0.6u l=0.13u
X216 a_533_5248# pdiv$3_0.d_flip_flop_reset$2$2_0.NAND_3in_nmosx3$1$2$3_1.a pdiv$3_0.d_flip_flop_reset$2$2_0.NAND_2in_nmosx2$1$2$2_0.a gd sg13_lv_nmos ad=0.114p pd=0.98u as=0.204p ps=1.88u w=0.6u l=0.13u
X217 pdiv$3_0.div_with_reset$3$2_0.d_flip_flop_reset$1$2_3.NAND_2in_nmosx2$1$1$5_0.b pdiv$3_0.div_with_reset$3$2_0.d_flip_flop_reset$1$2_3.NAND_2in_nmosx2$1$1$5_0.y VP VP sg13_lv_pmos ad=0.1005p pd=1.34u as=55.5f ps=0.74u w=0.15u l=0.13u
X218 VP a_6346_n3385# a_7434_n3434# VP sg13_lv_pmos ad=0.204p pd=1.88u as=0.114p ps=0.98u w=0.6u l=0.13u
X219 pdiv$3_0.count_data_check$2_0.NAND_3in$2_1/NAND_3in_nmosx3$5$1$2_0.y pdiv$3_0.count_data_check$2_0.XNOR$1$2_2.y VP VP sg13_lv_pmos ad=55.5f pd=0.74u as=0.1005p ps=1.34u w=0.15u l=0.13u
X220 a_n5157_31# MUX_8to1_0.in4 a_n5259_31# gd sg13_lv_nmos ad=57f pd=0.68u as=57f ps=0.68u w=0.3u l=0.13u
X221 a_n7537_2647# MUX_8to1_0.in3 a_n7639_2647# gd sg13_lv_nmos ad=57f pd=0.68u as=57f ps=0.68u w=0.3u l=0.13u
X222 pdiv$3_0.div_with_reset$3$2_0.d_flip_flop_reset$1$2_5.NAND_3in_nmosx3$1$1$3_1.a pdiv$3_0.div_with_reset$3$2_0.d_flip_flop_reset$1$2_5.NAND_2in_nmosx2$1$1$5_0.b VP VP sg13_lv_pmos ad=0.1005p pd=1.34u as=55.5f ps=0.74u w=0.15u l=0.13u
X223 a_n6761_n2585# MUX_8to1_0.in7 2Div$2_0.d_flip_flop$3$2_4.d gd sg13_lv_nmos ad=57f pd=0.68u as=0.102p ps=1.28u w=0.3u l=0.13u
X224 a_2695_n2600# pdiv$3_0.div_with_reset$3$2_0.d_flip_flop_reset$1$2_0.NAND_2in_nmosx2$1$1$5_0.b pdiv$3_0.div_with_reset$3$2_0.d_flip_flop_reset$1$2_0.NAND_3in_nmosx3$1$1$3_1.a gd sg13_lv_nmos ad=0.114p pd=0.98u as=0.204p ps=1.88u w=0.6u l=0.13u
X225 a_3793_n2192# pdiv$3_0.div_with_reset$3$2_0.d_flip_flop_reset$1$2_0.NAND_2in_nmosx2$1$1$5_0.b gd gd sg13_lv_nmos ad=0.114p pd=0.98u as=0.204p ps=1.88u w=0.6u l=0.13u
X226 pdiv$3_0.passgate$3_1.B pdiv$3_0.passgate$3_1.in_n pdiv$3_0.passgate$3_1.A gd sg13_lv_nmos ad=0.102p pd=1.28u as=0.102p ps=1.28u w=0.3u l=0.15u
X227 VP pdiv$3_0.div_with_reset$3$2_0.d_flip_flop_reset$1$2_0.NAND_3in_nmosx3$1$1$3_1.a pdiv$3_0.count_data_check$2_0.c5 VP sg13_lv_pmos ad=55.5f pd=0.74u as=55.5f ps=0.74u w=0.15u l=0.13u
X228 a_n8801_469# 2Div$2_0.d_flip_flop$3$2_5.NAND_2in_nmosx2$3$2_0.b MUX_8to1_0.in6 gd sg13_lv_nmos ad=57f pd=0.68u as=0.102p ps=1.28u w=0.3u l=0.13u
X229 a_n93_424# pdiv$3_0.div_with_reset$3$2_0.d_flip_flop_reset$1$2_3.clk a_n195_424# gd sg13_lv_nmos ad=0.114p pd=0.98u as=0.114p ps=0.98u w=0.6u l=0.13u
X230 a_7020_2629# a_6702_1847# gd gd sg13_lv_nmos ad=55.5f pd=0.74u as=0.1005p ps=1.34u w=0.15u l=0.13u
X231 a_n5741_469# 2Div$2_0.d_flip_flop$3$2_6.NAND_2in_nmosx2$3$2_0.a 2Div$2_0.d_flip_flop$3$2_6.NAND_2in_nmosx2$3$2_0.y gd sg13_lv_nmos ad=57f pd=0.68u as=0.102p ps=1.28u w=0.3u l=0.13u
X232 pdiv$3_0.div_with_reset$3$2_0.d_flip_flop_reset$1$2_2.NAND_2in_nmosx2$1$1$5_0.a pdiv$3_0.count_data_check$2_0.c3 VP VP sg13_lv_pmos ad=55.5f pd=0.74u as=55.5f ps=0.74u w=0.15u l=0.13u
X233 2Div$2_0.d_flip_flop$3$2_1.NAND_2in_nmosx2$3$2_0.a 2Div$2_0.d_flip_flop$3$2_1.NAND_3in_nmosx3$1$2_0.y VP VP sg13_lv_pmos ad=55.5f pd=0.74u as=0.1005p ps=1.34u w=0.15u l=0.13u
X234 pdiv$3_0.count_data_check$2_0.c4 pdiv$3_0.div_with_reset$3$2_0.d_flip_flop_reset$1$2_1.NAND_3in_nmosx3$1$1$3_1.a VP VP sg13_lv_pmos ad=55.5f pd=0.74u as=55.5f ps=0.74u w=0.15u l=0.13u
X235 gd 2Div$2_0.d_flip_flop$3$2_0.d a_n8801_3085# gd sg13_lv_nmos ad=0.102p pd=1.28u as=57f ps=0.68u w=0.3u l=0.13u
X236 gd 2Div$2_0.d_flip_flop$3$2_3.d a_n8393_n2585# gd sg13_lv_nmos ad=0.102p pd=1.28u as=57f ps=0.68u w=0.3u l=0.13u
X237 a_n7537_31# MUX_8to1_0.in5 a_n7639_31# gd sg13_lv_nmos ad=57f pd=0.68u as=57f ps=0.68u w=0.3u l=0.13u
X238 a_7434_n818# a_6702_n769# pdiv$3_0.count_data_check$2_0.XNOR$1$2_5.y VP sg13_lv_pmos ad=0.114p pd=0.98u as=0.204p ps=1.88u w=0.6u l=0.13u
X239 a_n6761_31# MUX_8to1_0.in5 2Div$2_0.d_flip_flop$3$2_6.d gd sg13_lv_nmos ad=57f pd=0.68u as=0.102p ps=1.28u w=0.3u l=0.13u
X240 pdiv$3_0.div_with_reset$3$2_0.d_flip_flop_reset$1$2_3.NAND_2in_nmosx2$1$1$5_0.y pdiv$3_0.div_with_reset$3$2_0.d_flip_flop_reset$1$2_3.NAND_2in_nmosx2$1$1$5_0.a a_597_424# gd sg13_lv_nmos ad=0.204p pd=1.88u as=0.114p ps=0.98u w=0.6u l=0.13u
X241 VP 2Div$2_0.d_flip_flop$3$2_5.NAND_2in_nmosx2$3$2_0.b 2Div$2_0.d_flip_flop$3$2_5.NAND_2in_nmosx2$3$2_0.y VP sg13_lv_pmos ad=0.1005p pd=1.34u as=55.5f ps=0.74u w=0.15u l=0.13u
X242 a_1607_n2600# pdiv$3_0.div_with_reset$3$2_0.d_flip_flop_reset$1$2_0.clk pdiv$3_0.count_data_check$2_0.c4 gd sg13_lv_nmos ad=0.114p pd=0.98u as=0.204p ps=1.88u w=0.6u l=0.13u
X243 MUX_8to1_0.inverter_x4_ptap_mirror_fix$2$3_8.OUT clk VP VP sg13_lv_pmos ad=0.204p pd=1.88u as=0.204p ps=1.88u w=0.6u l=0.13u
X244 a_4949_5701# d2 pdiv$3_0.NOR_2in$3$2_0.B gd sg13_lv_nmos ad=57f pd=0.68u as=0.102p ps=1.28u w=0.3u l=0.13u
X245 VP 2Div$2_0.d_flip_flop$3$2_3.d MUX_8to1_0.in8 VP sg13_lv_pmos ad=0.1005p pd=1.34u as=55.5f ps=0.74u w=0.15u l=0.13u
X246 VP pdiv$3_0.passgate$3_1.B pdiv$3_0.d_flip_flop_reset$2$2_0.NAND_2in_nmosx2$1$2$2_0.b VP sg13_lv_pmos ad=55.5f pd=0.74u as=55.5f ps=0.74u w=0.15u l=0.13u
X247 VP 2Div$2_0.d_flip_flop$3$2_0.d MUX_8to1_0.in4 VP sg13_lv_pmos ad=0.1005p pd=1.34u as=55.5f ps=0.74u w=0.15u l=0.13u
X248 a_n195_424# pdiv$3_0.passgate$3_1.A gd gd sg13_lv_nmos ad=0.114p pd=0.98u as=0.114p ps=0.98u w=0.6u l=0.13u
X249 gd pdiv$3_0.inverter_x8$3_0.IN pdiv$3_0.passgate$3_1.A gd sg13_lv_nmos ad=0.204p pd=1.88u as=0.204p ps=1.88u w=0.6u l=0.13u
X250 a_1345_n2192# pdiv$3_0.count_data_check$2_0.c4 gd gd sg13_lv_nmos ad=0.114p pd=0.98u as=0.204p ps=1.88u w=0.6u l=0.13u
X251 2Div$2_0.d_flip_flop$3$2_3.NAND_2in_nmosx2$3$2_0.a 2Div$2_0.d_flip_flop$3$2_3.NAND_3in_nmosx3$1$2_0.y VP VP sg13_lv_pmos ad=55.5f pd=0.74u as=0.1005p ps=1.34u w=0.15u l=0.13u
X252 a_3001_2632# pdiv$3_0.div_with_reset$3$2_0.d_flip_flop_reset$1$2_4.NAND_2in_nmosx2$1$1$5_0.a gd gd sg13_lv_nmos ad=0.114p pd=0.98u as=0.114p ps=0.98u w=0.6u l=0.13u
X253 a_n5129_n2147# 2Div$2_0.d_flip_flop$3$2_4.NAND_2in_nmosx2$3$2_0.y 2Div$2_0.d_flip_flop$3$2_4.NAND_2in_nmosx2$3$2_0.b gd sg13_lv_nmos ad=57f pd=0.68u as=0.102p ps=1.28u w=0.3u l=0.13u
X254 pdiv$3_0.div_with_reset$3$2_0.d_flip_flop_reset$1$2_5.NAND_3in_nmosx3$1$1$3_1.a pdiv$3_0.div_with_reset$3$2_0.d_flip_flop_reset$1$2_5.NAND_2in_nmosx2$1$1$5_0.b a_n93_2632# gd sg13_lv_nmos ad=0.204p pd=1.88u as=0.114p ps=0.98u w=0.6u l=0.13u
X255 2Div$2_0.d_flip_flop$3$2_1.NAND_2in_nmosx2$3$2_0.y 2Div$2_0.d_flip_flop$3$2_1.NAND_2in_nmosx2$3$2_0.a VP VP sg13_lv_pmos ad=55.5f pd=0.74u as=0.1005p ps=1.34u w=0.15u l=0.13u
X256 gd pdiv$3_0.passgate$3_1.A a_n399_3040# gd sg13_lv_nmos ad=0.114p pd=0.98u as=0.114p ps=0.98u w=0.6u l=0.13u
X257 a_2695_2632# pdiv$3_0.div_with_reset$3$2_0.d_flip_flop_reset$1$2_4.NAND_2in_nmosx2$1$1$5_0.b pdiv$3_0.div_with_reset$3$2_0.d_flip_flop_reset$1$2_4.NAND_3in_nmosx3$1$1$3_1.a gd sg13_lv_nmos ad=0.114p pd=0.98u as=0.204p ps=1.88u w=0.6u l=0.13u
X258 VP pdiv$3_0.d_flip_flop_reset$2$2_0.NAND_3in_nmosx3$1$2$3_1.a pdiv$3_0.d_flip_flop_reset$2$2_0.d VP sg13_lv_pmos ad=55.5f pd=0.74u as=55.5f ps=0.74u w=0.15u l=0.13u
X259 MUX_8to1_0.inverter_x4_ptap_mirror_fix$2$3_5.OUT a0 VP VP sg13_lv_pmos ad=0.204p pd=1.88u as=0.204p ps=1.88u w=0.6u l=0.13u
X260 MUX_8to1_0.passgate$1$2_0.in_n MUX_8to1_0.passgate$1$2_0.in_p VP VP sg13_lv_pmos ad=0.204p pd=1.88u as=0.204p ps=1.88u w=0.6u l=0.13u
X261 gd pdiv$3_0.count_data_check$2_0.c2 a_7428_517# gd sg13_lv_nmos ad=0.1005p pd=1.34u as=55.5f ps=0.74u w=0.15u l=0.13u
X262 pdiv$3_0.div_with_reset$3$2_0.d_flip_flop_reset$1$2_5.NAND_2in_nmosx2$1$1$5_0.b MUX_8to1_0.out VP VP sg13_lv_pmos ad=55.5f pd=0.74u as=55.5f ps=0.74u w=0.15u l=0.13u
X263 a_3793_3040# pdiv$3_0.div_with_reset$3$2_0.d_flip_flop_reset$1$2_4.NAND_2in_nmosx2$1$1$5_0.b gd gd sg13_lv_nmos ad=0.114p pd=0.98u as=0.204p ps=1.88u w=0.6u l=0.13u
X264 pdiv$3_0.div_with_reset$3$2_0.d_flip_flop_reset$1$2_2.NAND_3in_nmosx3$1$1$3_1.a pdiv$3_0.div_with_reset$3$2_0.d_flip_flop_reset$1$2_2.NAND_2in_nmosx2$1$1$5_0.b VP VP sg13_lv_pmos ad=0.1005p pd=1.34u as=55.5f ps=0.74u w=0.15u l=0.13u
X265 a_7459_5263# pdiv$3_0.count_data_check$2_0.XNOR$1$2_3.y a_7357_5263# gd sg13_lv_nmos ad=57f pd=0.68u as=57f ps=0.68u w=0.3u l=0.13u
X266 VP out_div pdiv$3_0.d_flip_flop_reset$2$2_0.d VP sg13_lv_pmos ad=55.5f pd=0.74u as=0.1005p ps=1.34u w=0.15u l=0.13u
X267 2Div$2_0.d_flip_flop$3$2_1.NAND_2in_nmosx2$3$2_0.b 2Div$2_0.d_flip_flop$3$2_1.NAND_2in_nmosx2$3$2_0.y VP VP sg13_lv_pmos ad=55.5f pd=0.74u as=0.1005p ps=1.34u w=0.15u l=0.13u
X268 gd MUX_8to1_0.in3 a_n7509_3085# gd sg13_lv_nmos ad=0.102p pd=1.28u as=57f ps=0.68u w=0.3u l=0.13u
X269 pdiv$3_0.count_data_check$2_0.c0 pdiv$3_0.div_with_reset$3$2_0.d_flip_flop_reset$1$2_5.NAND_3in_nmosx3$1$1$3_1.a VP VP sg13_lv_pmos ad=55.5f pd=0.74u as=55.5f ps=0.74u w=0.15u l=0.13u
X270 MUX_8to1_0.inverter_x4_ptap_mirror_fix$2$3_6.OUT a1 VP VP sg13_lv_pmos ad=0.204p pd=1.88u as=0.204p ps=1.88u w=0.6u l=0.13u
X271 pdiv$3_0.div_with_reset$3$2_0.d_flip_flop_reset$1$2_1.NAND_2in_nmosx2$1$1$5_0.a pdiv$3_0.passgate$3_1.A VP VP sg13_lv_pmos ad=55.5f pd=0.74u as=55.5f ps=0.74u w=0.15u l=0.13u
X272 a_6346_n2099# d4 gd gd sg13_lv_nmos ad=0.1005p pd=1.34u as=0.1005p ps=1.34u w=0.15u l=0.13u
X273 pdiv$3_0.div_with_reset$3$2_0.d_flip_flop_reset$1$2_1.NAND_3in_nmosx3$1$1$3_1.a pdiv$3_0.div_with_reset$3$2_0.d_flip_flop_reset$1$2_1.NAND_2in_nmosx2$1$1$5_0.b a_n93_n2600# gd sg13_lv_nmos ad=0.204p pd=1.88u as=0.114p ps=0.98u w=0.6u l=0.13u
X274 gd 2Div$2_0.d_flip_flop$3$2_4.d a_n6013_n2585# gd sg13_lv_nmos ad=0.102p pd=1.28u as=57f ps=0.68u w=0.3u l=0.13u
X275 gd pdiv$3_0.div_with_reset$3$2_0.d_flip_flop_reset$1$2_3.NAND_2in_nmosx2$1$1$5_0.a a_n399_16# gd sg13_lv_nmos ad=0.114p pd=0.98u as=0.114p ps=0.98u w=0.6u l=0.13u
X276 VP 2Div$2_0.d_flip_flop$3$2_0.NAND_2in_nmosx2$3$2_0.b 2Div$2_0.d_flip_flop$3$2_0.NAND_3in_nmosx3$1$2_0.y VP sg13_lv_pmos ad=55.5f pd=0.74u as=0.1005p ps=1.34u w=0.15u l=0.13u
X277 VP pdiv$3_0.div_with_reset$3$2_0.d_flip_flop_reset$1$2_1.clk pdiv$3_0.count_data_check$2_0.c3 VP sg13_lv_pmos ad=55.5f pd=0.74u as=0.1005p ps=1.34u w=0.15u l=0.13u
X278 a_n147_5248# pdiv$3_0.d_flip_flop_reset$2$2_0.NAND_3in_nmosx3$1$2$3_1.a a_n249_5248# gd sg13_lv_nmos ad=0.114p pd=0.98u as=0.114p ps=0.98u w=0.6u l=0.13u
X279 VP MUX_8to1_0.in3 2Div$2_0.d_flip_flop$3$2_0.NAND_2in_nmosx2$3$2_0.b VP sg13_lv_pmos ad=0.1005p pd=1.34u as=55.5f ps=0.74u w=0.15u l=0.13u
X280 VP 2Div$2_0.d_flip_flop$3$2_3.NAND_2in_nmosx2$3$2_0.b 2Div$2_0.d_flip_flop$3$2_3.NAND_3in_nmosx3$1$2_0.y VP sg13_lv_pmos ad=55.5f pd=0.74u as=0.1005p ps=1.34u w=0.15u l=0.13u
X281 a_7434_n1358# a_6702_n2099# pdiv$3_0.count_data_check$2_0.XNOR$1$2_0.y VP sg13_lv_pmos ad=0.114p pd=0.98u as=0.204p ps=1.88u w=0.6u l=0.13u
X282 MUX_8to1_0.passgate$1$2_0.B MUX_8to1_0.passgate$1$2_3.in_p MUX_8to1_0.inverter_x4_ptap_mirror_fix$2$3_8.OUT VP sg13_lv_pmos ad=0.102p pd=1.28u as=0.102p ps=1.28u w=0.3u l=0.15u
X283 a_2797_n2600# pdiv$3_0.div_with_reset$3$2_0.d_flip_flop_reset$1$2_0.clk a_2695_n2600# gd sg13_lv_nmos ad=0.114p pd=0.98u as=0.114p ps=0.98u w=0.6u l=0.13u
X284 a_1709_2632# pdiv$3_0.div_with_reset$3$2_0.d_flip_flop_reset$1$2_5.NAND_3in_nmosx3$1$1$3_1.a a_1607_2632# gd sg13_lv_nmos ad=0.114p pd=0.98u as=0.114p ps=0.98u w=0.6u l=0.13u
X285 pdiv$3_0.div_with_reset$3$2_0.d_flip_flop_reset$1$2_5.NAND_2in_nmosx2$1$1$5_0.a pdiv$3_0.passgate$3_1.A VP VP sg13_lv_pmos ad=55.5f pd=0.74u as=55.5f ps=0.74u w=0.15u l=0.13u
X286 a_6346_n3385# d5 VP VP sg13_lv_pmos ad=0.1005p pd=1.34u as=0.1005p ps=1.34u w=0.15u l=0.13u
X287 2Div$2_0.d_flip_flop$3$2_4.NAND_2in_nmosx2$3$2_0.b 2Div$2_0.d_flip_flop$3$2_4.NAND_2in_nmosx2$3$2_0.y VP VP sg13_lv_pmos ad=55.5f pd=0.74u as=0.1005p ps=1.34u w=0.15u l=0.13u
X288 pdiv$3_0.div_with_reset$3$2_0.d_flip_flop_reset$1$2_3.NAND_2in_nmosx2$1$1$5_0.b pdiv$3_0.passgate$3_1.A VP VP sg13_lv_pmos ad=55.5f pd=0.74u as=55.5f ps=0.74u w=0.15u l=0.13u
X289 a_4905_2632# pdiv$3_0.div_with_reset$3$2_0.d_flip_flop_reset$1$2_4.NAND_3in_nmosx3$1$1$3_1.a a_4803_2632# gd sg13_lv_nmos ad=0.114p pd=0.98u as=0.114p ps=0.98u w=0.6u l=0.13u
X290 a_7434_1798# a_6702_1847# pdiv$3_0.count_data_check$2_0.XNOR$1$2_2.y VP sg13_lv_pmos ad=0.114p pd=0.98u as=0.204p ps=1.88u w=0.6u l=0.13u
X291 VP pdiv$3_0.div_with_reset$3$2_0.d_flip_flop_reset$1$2_1.clk pdiv$3_0.div_with_reset$3$2_0.d_flip_flop_reset$1$2_1.NAND_3in_nmosx3$1$1$3_1.a VP sg13_lv_pmos ad=55.5f pd=0.74u as=55.5f ps=0.74u w=0.15u l=0.13u
X292 a_n501_n2600# pdiv$3_0.div_with_reset$3$2_0.d_flip_flop_reset$1$2_1.NAND_2in_nmosx2$1$1$5_0.b pdiv$3_0.div_with_reset$3$2_0.d_flip_flop_reset$1$2_1.NAND_3in_nmosx3$1$1$3_1.a gd sg13_lv_nmos ad=0.114p pd=0.98u as=0.204p ps=1.88u w=0.6u l=0.13u
X293 gd 2Div$2_0.d_flip_flop$3$2_4.d a_n6421_n2147# gd sg13_lv_nmos ad=0.102p pd=1.28u as=57f ps=0.68u w=0.3u l=0.13u
X294 pdiv$3_0.div_with_reset$3$2_0.d_flip_flop_reset$1$2_5.NAND_3in_nmosx3$1$1$3_1.a pdiv$3_0.div_with_reset$3$2_0.d_flip_flop_reset$1$2_5.NAND_2in_nmosx2$1$1$5_0.a VP VP sg13_lv_pmos ad=55.5f pd=0.74u as=55.5f ps=0.74u w=0.15u l=0.13u
X295 a_n5259_n2585# 2Div$2_0.d_flip_flop$3$2_4.NAND_2in_nmosx2$3$2_0.b 2Div$2_0.d_flip_flop$3$2_4.NAND_3in_nmosx3$1$2_0.y gd sg13_lv_nmos ad=57f pd=0.68u as=0.102p ps=1.28u w=0.3u l=0.13u
X296 gd 2Div$2_0.d_flip_flop$3$2_1.d a_n6013_2647# gd sg13_lv_nmos ad=0.102p pd=1.28u as=57f ps=0.68u w=0.3u l=0.13u
X297 a_n93_n2600# pdiv$3_0.div_with_reset$3$2_0.d_flip_flop_reset$1$2_1.clk a_n195_n2600# gd sg13_lv_nmos ad=0.114p pd=0.98u as=0.114p ps=0.98u w=0.6u l=0.13u
X298 gd pdiv$3_0.passgate$3_1.A a_n399_424# gd sg13_lv_nmos ad=0.114p pd=0.98u as=0.114p ps=0.98u w=0.6u l=0.13u
X299 VP pdiv$3_0.div_with_reset$3$2_0.d_flip_flop_reset$1$2_2.NAND_2in_nmosx2$1$1$5_0.y pdiv$3_0.div_with_reset$3$2_0.d_flip_flop_reset$1$2_2.NAND_2in_nmosx2$1$1$5_0.b VP sg13_lv_pmos ad=55.5f pd=0.74u as=0.1005p ps=1.34u w=0.15u l=0.13u
X300 pdiv$3_0.div_with_reset$3$2_0.d_flip_flop_reset$1$2_0.clk pdiv$3_0.div_with_reset$3$2_0.d_flip_flop_reset$1$2_1.NAND_2in_nmosx2$1$1$5_0.b a_1345_n2192# gd sg13_lv_nmos ad=0.204p pd=1.88u as=0.114p ps=0.98u w=0.6u l=0.13u
X301 pdiv$3_0.div_with_reset$3$2_0.d_flip_flop_reset$1$2_4.NAND_2in_nmosx2$1$1$5_0.y pdiv$3_0.div_with_reset$3$2_0.d_flip_flop_reset$1$2_4.NAND_2in_nmosx2$1$1$5_0.b VP VP sg13_lv_pmos ad=57f pd=0.68u as=0.102p ps=1.28u w=0.3u l=0.13u
X302 VP pdiv$3_0.div_with_reset$3$2_0.d_flip_flop_reset$1$2_4.NAND_2in_nmosx2$1$1$5_0.b pdiv$3_0.div_with_reset$3$2_0.d_flip_flop_reset$1$2_4.NAND_3in_nmosx3$1$1$3_1.a VP sg13_lv_pmos ad=55.5f pd=0.74u as=0.1005p ps=1.34u w=0.15u l=0.13u
X303 pdiv$3_0.div_with_reset$3$2_0.d_flip_flop_reset$1$2_3.NAND_2in_nmosx2$1$1$5_0.a pdiv$3_0.div_with_reset$3$2_0.d_flip_flop_reset$1$2_3.NAND_3in_nmosx3$1$1$3_1.a VP VP sg13_lv_pmos ad=0.1005p pd=1.34u as=55.5f ps=0.74u w=0.15u l=0.13u
X304 pdiv$3_0.div_with_reset$3$2_0.d_flip_flop_reset$1$2_5.NAND_2in_nmosx2$1$1$5_0.b pdiv$3_0.div_with_reset$3$2_0.d_flip_flop_reset$1$2_5.NAND_2in_nmosx2$1$1$5_0.y VP VP sg13_lv_pmos ad=0.1005p pd=1.34u as=55.5f ps=0.74u w=0.15u l=0.13u
X305 gd pdiv$3_0.passgate$3_1.A a_3817_2632# gd sg13_lv_nmos ad=0.114p pd=0.98u as=0.114p ps=0.98u w=0.6u l=0.13u
X306 MUX_8to1_0.passgate$1$2_0.B MUX_8to1_0.passgate$1$2_6.in_p MUX_8to1_0.passgate$1$2_6.A VP sg13_lv_pmos ad=0.102p pd=1.28u as=0.102p ps=1.28u w=0.3u l=0.15u
X307 a_5211_n2600# pdiv$3_0.div_with_reset$3$2_0.d_flip_flop_reset$1$2_0.NAND_3in_nmosx3$1$1$3_1.a a_5109_n2600# gd sg13_lv_nmos ad=0.114p pd=0.98u as=0.114p ps=0.98u w=0.6u l=0.13u
X308 pdiv$3_0.NOR_2in$3$2_0.A d5 VP VP sg13_lv_pmos ad=55.5f pd=0.74u as=55.5f ps=0.74u w=0.15u l=0.13u
X309 VP 2Div$2_0.d_flip_flop$3$2_5.d 2Div$2_0.d_flip_flop$3$2_5.NAND_2in_nmosx2$3$2_0.a VP sg13_lv_pmos ad=0.1005p pd=1.34u as=55.5f ps=0.74u w=0.15u l=0.13u
X310 pdiv$3_0.d_flip_flop_reset$2$2_0.NAND_3in_nmosx3$1$2$3_1.a pdiv$3_0.passgate$3_1.B VP VP sg13_lv_pmos ad=55.5f pd=0.74u as=55.5f ps=0.74u w=0.15u l=0.13u
X311 pdiv$3_0.count_data_check$2_0.NAND_3in$2_0/NAND_3in_nmosx3$5$1$2_0.y pdiv$3_0.count_data_check$2_0.XNOR$1$2_5.y VP VP sg13_lv_pmos ad=0.1005p pd=1.34u as=55.5f ps=0.74u w=0.15u l=0.13u
X312 pdiv$3_0.d_flip_flop_reset$2$2_0.reset reset gd gd sg13_lv_nmos ad=0.204p pd=1.88u as=0.204p ps=1.88u w=0.6u l=0.13u
X313 a_7018_n3434# d5 VP VP sg13_lv_pmos ad=0.114p pd=0.98u as=0.204p ps=1.88u w=0.6u l=0.13u
X314 MUX_8to1_0.passgate$1$2_5.in_n MUX_8to1_0.passgate$1$2_5.in_p VP VP sg13_lv_pmos ad=0.204p pd=1.88u as=0.204p ps=1.88u w=0.6u l=0.13u
X315 a_n8393_2647# 2Div$2_0.d_flip_flop$3$2_0.NAND_3in_nmosx3$1$2_0.y 2Div$2_0.d_flip_flop$3$2_0.NAND_2in_nmosx2$3$2_0.a gd sg13_lv_nmos ad=57f pd=0.68u as=0.102p ps=1.28u w=0.3u l=0.13u
X316 2Div$2_0.d_flip_flop$3$2_0.d MUX_8to1_0.in4 VP VP sg13_lv_pmos ad=55.5f pd=0.74u as=0.1005p ps=1.34u w=0.15u l=0.13u
X317 pdiv$3_0.div_with_reset$3$2_0.d_flip_flop_reset$1$2_1.NAND_2in_nmosx2$1$1$5_0.a pdiv$3_0.count_data_check$2_0.c4 VP VP sg13_lv_pmos ad=55.5f pd=0.74u as=55.5f ps=0.74u w=0.15u l=0.13u
X318 a_n7509_n2147# 2Div$2_0.d_flip_flop$3$2_3.NAND_2in_nmosx2$3$2_0.y 2Div$2_0.d_flip_flop$3$2_3.NAND_2in_nmosx2$3$2_0.b gd sg13_lv_nmos ad=57f pd=0.68u as=0.102p ps=1.28u w=0.3u l=0.13u
X319 VP a_6346_n2099# a_7434_n1358# VP sg13_lv_pmos ad=0.204p pd=1.88u as=0.114p ps=0.98u w=0.6u l=0.13u
X320 gd 2Div$2_0.d_flip_flop$3$2_0.NAND_2in_nmosx2$3$2_0.b a_n8121_3085# gd sg13_lv_nmos ad=0.102p pd=1.28u as=57f ps=0.68u w=0.3u l=0.13u
X321 a_n2435_3085# a1 gd gd sg13_lv_nmos ad=57f pd=0.68u as=0.102p ps=1.28u w=0.3u l=0.13u
X322 pdiv$3_0.div_with_reset$3$2_0.d_flip_flop_reset$1$2_3.NAND_3in_nmosx3$1$1$3_1.a pdiv$3_0.div_with_reset$3$2_0.d_flip_flop_reset$1$2_3.clk VP VP sg13_lv_pmos ad=55.5f pd=0.74u as=55.5f ps=0.74u w=0.15u l=0.13u
X323 pdiv$3_0.NOR_2in$3$2_0.B d0 VP VP sg13_lv_pmos ad=55.5f pd=0.74u as=55.5f ps=0.74u w=0.15u l=0.13u
X324 gd 2Div$2_0.d_flip_flop$3$2_6.d a_n6421_469# gd sg13_lv_nmos ad=0.102p pd=1.28u as=57f ps=0.68u w=0.3u l=0.13u
X325 a_1709_16# pdiv$3_0.div_with_reset$3$2_0.d_flip_flop_reset$1$2_3.NAND_3in_nmosx3$1$1$3_1.a a_1607_16# gd sg13_lv_nmos ad=0.114p pd=0.98u as=0.114p ps=0.98u w=0.6u l=0.13u
X326 pdiv$3_0.count_data_check$2_0.NAND_3in$2_1/NAND_3in_nmosx3$5$1$2_0.y pdiv$3_0.count_data_check$2_0.XNOR$1$2_4.y VP VP sg13_lv_pmos ad=0.1005p pd=1.34u as=55.5f ps=0.74u w=0.15u l=0.13u
X327 VP 2Div$2_0.d_flip_flop$3$2_0.NAND_2in_nmosx2$3$2_0.b 2Div$2_0.d_flip_flop$3$2_0.NAND_2in_nmosx2$3$2_0.y VP sg13_lv_pmos ad=0.1005p pd=1.34u as=55.5f ps=0.74u w=0.15u l=0.13u
X328 VP 2Div$2_0.d_flip_flop$3$2_2.d 2Div$2_0.d_flip_flop$3$2_2.NAND_2in_nmosx2$3$2_0.a VP sg13_lv_pmos ad=0.1005p pd=1.34u as=55.5f ps=0.74u w=0.15u l=0.13u
X329 VP pdiv$3_0.div_with_reset$3$2_0.d_flip_flop_reset$1$2_3.NAND_3in_nmosx3$1$1$3_1.a pdiv$3_0.count_data_check$2_0.c2 VP sg13_lv_pmos ad=55.5f pd=0.74u as=55.5f ps=0.74u w=0.15u l=0.13u
X330 a_5211_16# pdiv$3_0.div_with_reset$3$2_0.d_flip_flop_reset$1$2_2.NAND_3in_nmosx3$1$1$3_1.a a_5109_16# gd sg13_lv_nmos ad=0.114p pd=0.98u as=0.114p ps=0.98u w=0.6u l=0.13u
X331 gd pdiv$3_0.div_with_reset$3$2_0.d_flip_flop_reset$1$2_2.NAND_2in_nmosx2$1$1$5_0.a a_2797_16# gd sg13_lv_nmos ad=0.114p pd=0.98u as=0.114p ps=0.98u w=0.6u l=0.13u
X332 a_n6761_5263# MUX_8to1_0.in2 2Div$2_0.d_flip_flop$3$2_2.d gd sg13_lv_nmos ad=57f pd=0.68u as=0.102p ps=1.28u w=0.3u l=0.13u
X333 a_3103_424# pdiv$3_0.div_with_reset$3$2_0.d_flip_flop_reset$1$2_2.clk a_3001_424# gd sg13_lv_nmos ad=0.114p pd=0.98u as=0.114p ps=0.98u w=0.6u l=0.13u
X334 a_n195_n2600# pdiv$3_0.div_with_reset$3$2_0.d_flip_flop_reset$1$2_1.NAND_2in_nmosx2$1$1$5_0.a gd gd sg13_lv_nmos ad=0.114p pd=0.98u as=0.114p ps=0.98u w=0.6u l=0.13u
X335 pdiv$3_0.div_with_reset$3$2_0.d_flip_flop_reset$1$2_2.NAND_2in_nmosx2$1$1$5_0.a pdiv$3_0.passgate$3_1.A VP VP sg13_lv_pmos ad=55.5f pd=0.74u as=55.5f ps=0.74u w=0.15u l=0.13u
X336 a_n399_424# pdiv$3_0.div_with_reset$3$2_0.d_flip_flop_reset$1$2_3.clk a_n501_424# gd sg13_lv_nmos ad=0.114p pd=0.98u as=0.114p ps=0.98u w=0.6u l=0.13u
X337 pdiv$3_0.count_data_check$2_0.XNOR$1$2_4.y pdiv$3_0.count_data_check$2_0.c2 a_7018_1258# VP sg13_lv_pmos ad=0.204p pd=1.88u as=0.114p ps=0.98u w=0.6u l=0.13u
X338 2Div$2_0.d_flip_flop$3$2_3.NAND_2in_nmosx2$3$2_0.b 2Div$2_0.d_flip_flop$3$2_3.NAND_2in_nmosx2$3$2_0.y VP VP sg13_lv_pmos ad=55.5f pd=0.74u as=0.1005p ps=1.34u w=0.15u l=0.13u
X339 a_2015_16# pdiv$3_0.div_with_reset$3$2_0.d_flip_flop_reset$1$2_3.NAND_3in_nmosx3$1$1$3_1.a a_1913_16# gd sg13_lv_nmos ad=0.114p pd=0.98u as=0.114p ps=0.98u w=0.6u l=0.13u
X340 VP pdiv$3_0.div_with_reset$3$2_0.d_flip_flop_reset$1$2_1.NAND_3in_nmosx3$1$1$3_1.a pdiv$3_0.count_data_check$2_0.c4 VP sg13_lv_pmos ad=55.5f pd=0.74u as=55.5f ps=0.74u w=0.15u l=0.13u
X341 a_863_5656# pdiv$3_0.d_flip_flop_reset$2$2_0.NAND_2in_nmosx2$1$2$2_0.a pdiv$3_0.d_flip_flop_reset$2$2_0.NAND_2in_nmosx2$1$2$2_0.y gd sg13_lv_nmos ad=0.114p pd=0.98u as=0.204p ps=1.88u w=0.6u l=0.13u
X342 VP a2 MUX_8to1_0.passgate$1$2_1.in_p VP sg13_lv_pmos ad=55.5f pd=0.74u as=55.5f ps=0.74u w=0.15u l=0.13u
X343 a_621_16# pdiv$3_0.count_data_check$2_0.c2 a_519_16# gd sg13_lv_nmos ad=0.114p pd=0.98u as=0.114p ps=0.98u w=0.6u l=0.13u
X344 a_n7639_n2585# 2Div$2_0.d_flip_flop$3$2_3.NAND_2in_nmosx2$3$2_0.b 2Div$2_0.d_flip_flop$3$2_3.NAND_3in_nmosx3$1$2_0.y gd sg13_lv_nmos ad=57f pd=0.68u as=0.102p ps=1.28u w=0.3u l=0.13u
X345 gd 2Div$2_0.d_flip_flop$3$2_3.d a_n8801_n2147# gd sg13_lv_nmos ad=0.102p pd=1.28u as=57f ps=0.68u w=0.3u l=0.13u
X346 a_6702_n769# pdiv$3_0.count_data_check$2_0.c3 VP VP sg13_lv_pmos ad=0.1005p pd=1.34u as=0.1005p ps=1.34u w=0.15u l=0.13u
X347 a_5109_2632# pdiv$3_0.passgate$3_1.A gd gd sg13_lv_nmos ad=0.114p pd=0.98u as=0.114p ps=0.98u w=0.6u l=0.13u
X348 gd pdiv$3_0.count_data_check$2_0.NAND_3in$2_1/NAND_3in_nmosx3$5$1$2_0.y pdiv$3_0.inverter_x8$3_0.IN gd sg13_lv_nmos ad=57f pd=0.68u as=0.102p ps=1.28u w=0.3u l=0.15u
X349 MUX_8to1_0.in7 2Div$2_0.d_flip_flop$3$2_4.NAND_2in_nmosx2$3$2_0.b VP VP sg13_lv_pmos ad=55.5f pd=0.74u as=0.1005p ps=1.34u w=0.15u l=0.13u
X350 2Div$2_0.d_flip_flop$3$2_2.NAND_2in_nmosx2$3$2_0.a 2Div$2_0.d_flip_flop$3$2_2.NAND_3in_nmosx3$1$2_0.y VP VP sg13_lv_pmos ad=55.5f pd=0.74u as=0.1005p ps=1.34u w=0.15u l=0.13u
X351 MUX_8to1_0.in5 2Div$2_0.d_flip_flop$3$2_6.NAND_2in_nmosx2$3$2_0.b VP VP sg13_lv_pmos ad=55.5f pd=0.74u as=0.1005p ps=1.34u w=0.15u l=0.13u
X352 gd pdiv$3_0.count_data_check$2_0.c5 a_7428_n2603# gd sg13_lv_nmos ad=0.1005p pd=1.34u as=55.5f ps=0.74u w=0.15u l=0.13u
X353 VP pdiv$3_0.d_flip_flop_reset$2$2_0.reset pdiv$3_0.d_flip_flop_reset$2$2_0.d VP sg13_lv_pmos ad=55.5f pd=0.74u as=55.5f ps=0.74u w=0.15u l=0.13u
X354 MUX_8to1_0.passgate$1$2_0.in_p a2 VP VP sg13_lv_pmos ad=55.5f pd=0.74u as=0.1005p ps=1.34u w=0.15u l=0.13u
X355 a_7020_3133# a_6702_3133# gd gd sg13_lv_nmos ad=55.5f pd=0.74u as=0.1005p ps=1.34u w=0.15u l=0.13u
X356 pdiv$3_0.div_with_reset$3$2_0.d_flip_flop_reset$1$2_4.NAND_2in_nmosx2$1$1$5_0.a pdiv$3_0.div_with_reset$3$2_0.d_flip_flop_reset$1$2_4.NAND_3in_nmosx3$1$1$3_1.a a_4123_2632# gd sg13_lv_nmos ad=0.204p pd=1.88u as=0.114p ps=0.98u w=0.6u l=0.13u
X357 a_4021_n2600# pdiv$3_0.passgate$3_1.A gd gd sg13_lv_nmos ad=0.114p pd=0.98u as=0.114p ps=0.98u w=0.6u l=0.13u
X358 pdiv$3_0.div_with_reset$3$2_0.d_flip_flop_reset$1$2_3.NAND_3in_nmosx3$1$1$3_1.a pdiv$3_0.div_with_reset$3$2_0.d_flip_flop_reset$1$2_3.NAND_2in_nmosx2$1$1$5_0.b VP VP sg13_lv_pmos ad=0.1005p pd=1.34u as=55.5f ps=0.74u w=0.15u l=0.13u
X359 pdiv$3_0.div_with_reset$3$2_0.d_flip_flop_reset$1$2_5.NAND_2in_nmosx2$1$1$5_0.b pdiv$3_0.passgate$3_1.A VP VP sg13_lv_pmos ad=55.5f pd=0.74u as=55.5f ps=0.74u w=0.15u l=0.13u
X360 VP 2Div$2_0.d_flip_flop$3$2_3.NAND_2in_nmosx2$3$2_0.b 2Div$2_0.d_flip_flop$3$2_3.NAND_2in_nmosx2$3$2_0.y VP sg13_lv_pmos ad=0.1005p pd=1.34u as=55.5f ps=0.74u w=0.15u l=0.13u
X361 a_n93_16# pdiv$3_0.div_with_reset$3$2_0.d_flip_flop_reset$1$2_3.clk a_n195_16# gd sg13_lv_nmos ad=0.114p pd=0.98u as=0.114p ps=0.98u w=0.6u l=0.13u
X362 2Div$2_0.d_flip_flop$3$2_1.NAND_3in_nmosx3$1$2_0.y MUX_8to1_0.in2 VP VP sg13_lv_pmos ad=55.5f pd=0.74u as=55.5f ps=0.74u w=0.15u l=0.13u
X363 pdiv$3_0.count_data_check$2_0.XNOR$1$2_3.y d5 a_7020_n2603# gd sg13_lv_nmos ad=0.1005p pd=1.34u as=55.5f ps=0.74u w=0.15u l=0.13u
X364 a_n6421_469# 2Div$2_0.d_flip_flop$3$2_6.NAND_2in_nmosx2$3$2_0.b MUX_8to1_0.in5 gd sg13_lv_nmos ad=57f pd=0.68u as=0.102p ps=1.28u w=0.3u l=0.13u
X365 a_1961_5248# pdiv$3_0.passgate$3_1.B a_1859_5248# gd sg13_lv_nmos ad=0.114p pd=0.98u as=0.114p ps=0.98u w=0.6u l=0.13u
X366 pdiv$3_0.count_data_check$2_0.c0 pdiv$3_0.passgate$3_1.A VP VP sg13_lv_pmos ad=55.5f pd=0.74u as=55.5f ps=0.74u w=0.15u l=0.13u
X367 pdiv$3_0.div_with_reset$3$2_0.d_flip_flop_reset$1$2_0.NAND_2in_nmosx2$1$1$5_0.b pdiv$3_0.div_with_reset$3$2_0.d_flip_flop_reset$1$2_0.clk VP VP sg13_lv_pmos ad=55.5f pd=0.74u as=55.5f ps=0.74u w=0.15u l=0.13u
X368 pdiv$3_0.passgate$3_1.B pdiv$3_0.passgate$3_1.in_p MUX_8to1_0.out gd sg13_lv_nmos ad=0.102p pd=1.28u as=0.102p ps=1.28u w=0.3u l=0.15u
X369 a_1655_5248# pdiv$3_0.passgate$3_1.B a_1553_5248# gd sg13_lv_nmos ad=0.114p pd=0.98u as=0.114p ps=0.98u w=0.6u l=0.13u
X370 a_1345_3040# pdiv$3_0.count_data_check$2_0.c0 gd gd sg13_lv_nmos ad=0.114p pd=0.98u as=0.204p ps=1.88u w=0.6u l=0.13u
X371 pdiv$3_0.div_with_reset$3$2_0.d_flip_flop_reset$1$2_4.NAND_2in_nmosx2$1$1$5_0.a pdiv$3_0.div_with_reset$3$2_0.d_flip_flop_reset$1$2_4.NAND_3in_nmosx3$1$1$3_1.a VP VP sg13_lv_pmos ad=0.1005p pd=1.34u as=55.5f ps=0.74u w=0.15u l=0.13u
X372 pdiv$3_0.div_with_reset$3$2_0.d_flip_flop_reset$1$2_0.NAND_3in_nmosx3$1$1$3_1.a pdiv$3_0.div_with_reset$3$2_0.d_flip_flop_reset$1$2_0.NAND_2in_nmosx2$1$1$5_0.b a_3103_n2600# gd sg13_lv_nmos ad=0.204p pd=1.88u as=0.114p ps=0.98u w=0.6u l=0.13u
X373 VP pdiv$3_0.div_with_reset$3$2_0.d_flip_flop_reset$1$2_4.NAND_2in_nmosx2$1$1$5_0.y pdiv$3_0.div_with_reset$3$2_0.d_flip_flop_reset$1$2_4.NAND_2in_nmosx2$1$1$5_0.b VP sg13_lv_pmos ad=55.5f pd=0.74u as=0.1005p ps=1.34u w=0.15u l=0.13u
X374 pdiv$3_0.div_with_reset$3$2_0.d_flip_flop_reset$1$2_1.NAND_2in_nmosx2$1$1$5_0.y pdiv$3_0.div_with_reset$3$2_0.d_flip_flop_reset$1$2_1.NAND_2in_nmosx2$1$1$5_0.a a_597_n2192# gd sg13_lv_nmos ad=0.204p pd=1.88u as=0.114p ps=0.98u w=0.6u l=0.13u
X375 gd pdiv$3_0.passgate$3_1.A a_3817_16# gd sg13_lv_nmos ad=0.114p pd=0.98u as=0.114p ps=0.98u w=0.6u l=0.13u
X376 2Div$2_0.d_flip_flop$3$2_2.NAND_2in_nmosx2$3$2_0.y 2Div$2_0.d_flip_flop$3$2_2.NAND_2in_nmosx2$3$2_0.a VP VP sg13_lv_pmos ad=55.5f pd=0.74u as=0.1005p ps=1.34u w=0.15u l=0.13u
X377 pdiv$3_0.div_with_reset$3$2_0.d_flip_flop_reset$1$2_2.NAND_2in_nmosx2$1$1$5_0.b pdiv$3_0.div_with_reset$3$2_0.d_flip_flop_reset$1$2_2.NAND_2in_nmosx2$1$1$5_0.y a_3103_424# gd sg13_lv_nmos ad=0.204p pd=1.88u as=0.114p ps=0.98u w=0.6u l=0.13u
X378 gd 2Div$2_0.d_flip_flop$3$2_5.d a_n8393_31# gd sg13_lv_nmos ad=0.102p pd=1.28u as=57f ps=0.68u w=0.3u l=0.13u
X379 pdiv$3_0.div_with_reset$3$2_0.d_flip_flop_reset$1$2_5.NAND_2in_nmosx2$1$1$5_0.a pdiv$3_0.count_data_check$2_0.c0 VP VP sg13_lv_pmos ad=55.5f pd=0.74u as=55.5f ps=0.74u w=0.15u l=0.13u
X380 VP pdiv$3_0.passgate$3_1.A pdiv$3_0.div_with_reset$3$2_0.d_flip_flop_reset$1$2_1.NAND_2in_nmosx2$1$1$5_0.b VP sg13_lv_pmos ad=55.5f pd=0.74u as=55.5f ps=0.74u w=0.15u l=0.13u
X381 a_2695_424# pdiv$3_0.div_with_reset$3$2_0.d_flip_flop_reset$1$2_2.NAND_2in_nmosx2$1$1$5_0.y pdiv$3_0.div_with_reset$3$2_0.d_flip_flop_reset$1$2_2.NAND_2in_nmosx2$1$1$5_0.b gd sg13_lv_nmos ad=0.114p pd=0.98u as=0.204p ps=1.88u w=0.6u l=0.13u
X382 gd 2Div$2_0.d_flip_flop$3$2_2.NAND_2in_nmosx2$3$2_0.b a_n5741_5701# gd sg13_lv_nmos ad=0.102p pd=1.28u as=57f ps=0.68u w=0.3u l=0.13u
X383 gd pdiv$3_0.passgate$3_1.A a_621_2632# gd sg13_lv_nmos ad=0.114p pd=0.98u as=0.114p ps=0.98u w=0.6u l=0.13u
X384 a_3001_n2192# pdiv$3_0.passgate$3_1.A gd gd sg13_lv_nmos ad=0.114p pd=0.98u as=0.114p ps=0.98u w=0.6u l=0.13u
X385 a_n501_424# pdiv$3_0.div_with_reset$3$2_0.d_flip_flop_reset$1$2_3.NAND_2in_nmosx2$1$1$5_0.y pdiv$3_0.div_with_reset$3$2_0.d_flip_flop_reset$1$2_3.NAND_2in_nmosx2$1$1$5_0.b gd sg13_lv_nmos ad=0.114p pd=0.98u as=0.204p ps=1.88u w=0.6u l=0.13u
X386 2Div$2_0.d_flip_flop$3$2_2.NAND_2in_nmosx2$3$2_0.b 2Div$2_0.d_flip_flop$3$2_2.NAND_2in_nmosx2$3$2_0.y VP VP sg13_lv_pmos ad=55.5f pd=0.74u as=0.1005p ps=1.34u w=0.15u l=0.13u
X387 pdiv$3_0.d_flip_flop_reset$2$2_0.NAND_2in_nmosx2$1$2$2_0.b pdiv$3_0.passgate$3_1.B VP VP sg13_lv_pmos ad=55.5f pd=0.74u as=55.5f ps=0.74u w=0.15u l=0.13u
X388 a_n2435_2647# a1 gd gd sg13_lv_nmos ad=57f pd=0.68u as=0.102p ps=1.28u w=0.3u l=0.13u
X389 gd pdiv$3_0.div_with_reset$3$2_0.d_flip_flop_reset$1$2_5.NAND_2in_nmosx2$1$1$5_0.a a_n399_2632# gd sg13_lv_nmos ad=0.114p pd=0.98u as=0.114p ps=0.98u w=0.6u l=0.13u
X390 VP 2Div$2_0.d_flip_flop$3$2_4.NAND_2in_nmosx2$3$2_0.b 2Div$2_0.d_flip_flop$3$2_4.NAND_2in_nmosx2$3$2_0.y VP sg13_lv_pmos ad=0.1005p pd=1.34u as=55.5f ps=0.74u w=0.15u l=0.13u
X391 pdiv$3_0.count_data_check$2_0.c4 pdiv$3_0.div_with_reset$3$2_0.d_flip_flop_reset$1$2_0.clk a_2015_n2600# gd sg13_lv_nmos ad=0.204p pd=1.88u as=0.114p ps=0.98u w=0.6u l=0.13u
X392 gd pdiv$3_0.count_data_check$2_0.c3 a_7428_13# gd sg13_lv_nmos ad=0.1005p pd=1.34u as=55.5f ps=0.74u w=0.15u l=0.13u
X393 VP pdiv$3_0.div_with_reset$3$2_0.d_flip_flop_reset$1$2_4.NAND_3in_nmosx3$1$1$3_1.a pdiv$3_0.count_data_check$2_0.c1 VP sg13_lv_pmos ad=55.5f pd=0.74u as=55.5f ps=0.74u w=0.15u l=0.13u
X394 VP pdiv$3_0.passgate$3_1.A pdiv$3_0.div_with_reset$3$2_0.d_flip_flop_reset$1$2_2.NAND_2in_nmosx2$1$1$5_0.b VP sg13_lv_pmos ad=55.5f pd=0.74u as=55.5f ps=0.74u w=0.15u l=0.13u
X395 a_2797_424# pdiv$3_0.div_with_reset$3$2_0.d_flip_flop_reset$1$2_2.clk a_2695_424# gd sg13_lv_nmos ad=0.114p pd=0.98u as=0.114p ps=0.98u w=0.6u l=0.13u
X396 VP pdiv$3_0.div_with_reset$3$2_0.d_flip_flop_reset$1$2_4.NAND_2in_nmosx2$1$1$5_0.a pdiv$3_0.div_with_reset$3$2_0.d_flip_flop_reset$1$2_4.NAND_3in_nmosx3$1$1$3_1.a VP sg13_lv_pmos ad=55.5f pd=0.74u as=55.5f ps=0.74u w=0.15u l=0.13u
X397 a_4803_n2600# pdiv$3_0.div_with_reset$3$2_0.d_flip_flop_reset$1$2_0.q pdiv$3_0.count_data_check$2_0.c5 gd sg13_lv_nmos ad=0.114p pd=0.98u as=0.204p ps=1.88u w=0.6u l=0.13u
X398 MUX_8to1_0.passgate$1$2_0.in_n MUX_8to1_0.passgate$1$2_0.in_p gd gd sg13_lv_nmos ad=0.204p pd=1.88u as=0.204p ps=1.88u w=0.6u l=0.13u
X399 VP pdiv$3_0.div_with_reset$3$2_0.d_flip_flop_reset$1$2_0.clk pdiv$3_0.div_with_reset$3$2_0.d_flip_flop_reset$1$2_0.NAND_2in_nmosx2$1$1$5_0.b VP sg13_lv_pmos ad=55.5f pd=0.74u as=55.5f ps=0.74u w=0.15u l=0.13u
X400 pdiv$3_0.count_data_check$2_0.c2 pdiv$3_0.div_with_reset$3$2_0.d_flip_flop_reset$1$2_3.NAND_3in_nmosx3$1$1$3_1.a VP VP sg13_lv_pmos ad=55.5f pd=0.74u as=55.5f ps=0.74u w=0.15u l=0.13u
X401 pdiv$3_0.div_with_reset$3$2_0.d_flip_flop_reset$1$2_1.NAND_3in_nmosx3$1$1$3_1.a pdiv$3_0.div_with_reset$3$2_0.d_flip_flop_reset$1$2_1.clk VP VP sg13_lv_pmos ad=55.5f pd=0.74u as=55.5f ps=0.74u w=0.15u l=0.13u
X402 MUX_8to1_0.passgate$1$2_3.in_p MUX_8to1_0.inverter_x4_ptap_mirror_fix$2$3_5.OUT a_n2333_5701# gd sg13_lv_nmos ad=0.102p pd=1.28u as=57f ps=0.68u w=0.3u l=0.13u
X403 a_941_5248# pdiv$3_0.d_flip_flop_reset$2$2_0.d a_839_5248# gd sg13_lv_nmos ad=0.114p pd=0.98u as=0.114p ps=0.98u w=0.6u l=0.13u
X404 pdiv$3_0.d_flip_flop_reset$2$2_0.NAND_3in_nmosx3$1$2$3_1.a pdiv$3_0.d_flip_flop_reset$2$2_0.NAND_2in_nmosx2$1$2$2_0.a VP VP sg13_lv_pmos ad=55.5f pd=0.74u as=55.5f ps=0.74u w=0.15u l=0.13u
X405 VP pdiv$3_0.passgate$3_1.A pdiv$3_0.count_data_check$2_0.c4 VP sg13_lv_pmos ad=55.5f pd=0.74u as=55.5f ps=0.74u w=0.15u l=0.13u
X406 pdiv$3_0.div_with_reset$3$2_0.d_flip_flop_reset$1$2_0.NAND_2in_nmosx2$1$1$5_0.a pdiv$3_0.count_data_check$2_0.c5 VP VP sg13_lv_pmos ad=55.5f pd=0.74u as=55.5f ps=0.74u w=0.15u l=0.13u
X407 a_7018_n1358# d4 VP VP sg13_lv_pmos ad=0.114p pd=0.98u as=0.204p ps=1.88u w=0.6u l=0.13u
X408 pdiv$3_0.div_with_reset$3$2_0.d_flip_flop_reset$1$2_3.NAND_2in_nmosx2$1$1$5_0.a pdiv$3_0.div_with_reset$3$2_0.d_flip_flop_reset$1$2_3.NAND_3in_nmosx3$1$1$3_1.a a_927_16# gd sg13_lv_nmos ad=0.204p pd=1.88u as=0.114p ps=0.98u w=0.6u l=0.13u
X409 gd d4 a_5051_5263# gd sg13_lv_nmos ad=0.102p pd=1.28u as=57f ps=0.68u w=0.3u l=0.13u
X410 gd 2Div$2_0.d_flip_flop$3$2_2.d a_n6013_5263# gd sg13_lv_nmos ad=0.102p pd=1.28u as=57f ps=0.68u w=0.3u l=0.13u
X411 a_635_5248# pdiv$3_0.d_flip_flop_reset$2$2_0.d a_533_5248# gd sg13_lv_nmos ad=0.114p pd=0.98u as=0.114p ps=0.98u w=0.6u l=0.13u
X412 VP 2Div$2_0.d_flip_flop$3$2_6.NAND_2in_nmosx2$3$2_0.b 2Div$2_0.d_flip_flop$3$2_6.NAND_2in_nmosx2$3$2_0.y VP sg13_lv_pmos ad=0.1005p pd=1.34u as=55.5f ps=0.74u w=0.15u l=0.13u
X413 MUX_8to1_0.in8 2Div$2_0.d_flip_flop$3$2_3.NAND_2in_nmosx2$3$2_0.b VP VP sg13_lv_pmos ad=55.5f pd=0.74u as=0.1005p ps=1.34u w=0.15u l=0.13u
X414 MUX_8to1_0.inverter_x4_ptap_mirror_fix$2$3_10.OUT MUX_8to1_0.in3 VP VP sg13_lv_pmos ad=0.204p pd=1.88u as=0.204p ps=1.88u w=0.6u l=0.13u
X415 a_n7639_2647# 2Div$2_0.d_flip_flop$3$2_0.NAND_2in_nmosx2$3$2_0.b 2Div$2_0.d_flip_flop$3$2_0.NAND_3in_nmosx3$1$2_0.y gd sg13_lv_nmos ad=57f pd=0.68u as=0.102p ps=1.28u w=0.3u l=0.13u
X416 pdiv$3_0.div_with_reset$3$2_0.d_flip_flop_reset$1$2_3.NAND_2in_nmosx2$1$1$5_0.a pdiv$3_0.passgate$3_1.A VP VP sg13_lv_pmos ad=55.5f pd=0.74u as=55.5f ps=0.74u w=0.15u l=0.13u
X417 pdiv$3_0.count_data_check$2_0.XNOR$1$2_1.y pdiv$3_0.count_data_check$2_0.c0 a_7018_3874# VP sg13_lv_pmos ad=0.204p pd=1.88u as=0.114p ps=0.98u w=0.6u l=0.13u
X418 pdiv$3_0.div_with_reset$3$2_0.d_flip_flop_reset$1$2_3.NAND_3in_nmosx3$1$1$3_1.a pdiv$3_0.div_with_reset$3$2_0.d_flip_flop_reset$1$2_3.NAND_2in_nmosx2$1$1$5_0.a VP VP sg13_lv_pmos ad=55.5f pd=0.74u as=55.5f ps=0.74u w=0.15u l=0.13u
X419 a_n6013_n2585# 2Div$2_0.d_flip_flop$3$2_4.NAND_3in_nmosx3$1$2_0.y 2Div$2_0.d_flip_flop$3$2_4.NAND_2in_nmosx2$3$2_0.a gd sg13_lv_nmos ad=57f pd=0.68u as=0.102p ps=1.28u w=0.3u l=0.13u
X420 MUX_8to1_0.passgate$1$2_7.in_n MUX_8to1_0.passgate$1$2_7.in_p VP VP sg13_lv_pmos ad=0.204p pd=1.88u as=0.204p ps=1.88u w=0.6u l=0.13u
X421 a_2695_16# pdiv$3_0.div_with_reset$3$2_0.d_flip_flop_reset$1$2_2.NAND_2in_nmosx2$1$1$5_0.b pdiv$3_0.div_with_reset$3$2_0.d_flip_flop_reset$1$2_2.NAND_3in_nmosx3$1$1$3_1.a gd sg13_lv_nmos ad=0.114p pd=0.98u as=0.204p ps=1.88u w=0.6u l=0.13u
X422 a_n8801_3085# 2Div$2_0.d_flip_flop$3$2_0.NAND_2in_nmosx2$3$2_0.b MUX_8to1_0.in4 gd sg13_lv_nmos ad=57f pd=0.68u as=0.102p ps=1.28u w=0.3u l=0.13u
X423 MUX_8to1_0.passgate$1$2_2.in_p a0 VP VP sg13_lv_pmos ad=0.1005p pd=1.34u as=55.5f ps=0.74u w=0.15u l=0.13u
X424 VP 2Div$2_0.d_flip_flop$3$2_5.NAND_2in_nmosx2$3$2_0.a 2Div$2_0.d_flip_flop$3$2_5.NAND_3in_nmosx3$1$2_0.y VP sg13_lv_pmos ad=0.1005p pd=1.34u as=55.5f ps=0.74u w=0.15u l=0.13u
X425 a_2015_n2600# pdiv$3_0.div_with_reset$3$2_0.d_flip_flop_reset$1$2_1.NAND_3in_nmosx3$1$1$3_1.a a_1913_n2600# gd sg13_lv_nmos ad=0.114p pd=0.98u as=0.114p ps=0.98u w=0.6u l=0.13u
X426 pdiv$3_0.d_flip_flop_reset$2$2_0.NAND_2in_nmosx2$1$2$2_0.y pdiv$3_0.d_flip_flop_reset$2$2_0.NAND_2in_nmosx2$1$2$2_0.a VP VP sg13_lv_pmos ad=57f pd=0.68u as=0.102p ps=1.28u w=0.3u l=0.13u
X427 VP pdiv$3_0.div_with_reset$3$2_0.d_flip_flop_reset$1$2_2.NAND_2in_nmosx2$1$1$5_0.b pdiv$3_0.div_with_reset$3$2_0.d_flip_flop_reset$1$2_2.NAND_3in_nmosx3$1$1$3_1.a VP sg13_lv_pmos ad=55.5f pd=0.74u as=0.1005p ps=1.34u w=0.15u l=0.13u
X428 VP pdiv$3_0.div_with_reset$3$2_0.d_flip_flop_reset$1$2_0.NAND_2in_nmosx2$1$1$5_0.b pdiv$3_0.div_with_reset$3$2_0.d_flip_flop_reset$1$2_0.NAND_3in_nmosx3$1$1$3_1.a VP sg13_lv_pmos ad=55.5f pd=0.74u as=0.1005p ps=1.34u w=0.15u l=0.13u
X429 MUX_8to1_0.passgate$1$2_2.in_p a0 a_n2333_n2585# gd sg13_lv_nmos ad=0.102p pd=1.28u as=57f ps=0.68u w=0.3u l=0.13u
X430 gd pdiv$3_0.passgate$3_1.A a_2797_424# gd sg13_lv_nmos ad=0.114p pd=0.98u as=0.114p ps=0.98u w=0.6u l=0.13u
X431 MUX_8to1_0.in3 2Div$2_0.d_flip_flop$3$2_1.NAND_2in_nmosx2$3$2_0.b VP VP sg13_lv_pmos ad=55.5f pd=0.74u as=0.1005p ps=1.34u w=0.15u l=0.13u
X432 a_n399_n2192# pdiv$3_0.div_with_reset$3$2_0.d_flip_flop_reset$1$2_1.clk a_n501_n2192# gd sg13_lv_nmos ad=0.114p pd=0.98u as=0.114p ps=0.98u w=0.6u l=0.13u
X433 a_n399_3040# MUX_8to1_0.out a_n501_3040# gd sg13_lv_nmos ad=0.114p pd=0.98u as=0.114p ps=0.98u w=0.6u l=0.13u
X434 pdiv$3_0.d_flip_flop_reset$2$2_0.reset reset VP VP sg13_lv_pmos ad=0.204p pd=1.88u as=0.204p ps=1.88u w=0.6u l=0.13u
X435 pdiv$3_0.d_flip_flop_reset$2$2_0.NAND_2in_nmosx2$1$2$2_0.a pdiv$3_0.d_flip_flop_reset$2$2_0.reset VP VP sg13_lv_pmos ad=55.5f pd=0.74u as=55.5f ps=0.74u w=0.15u l=0.13u
X436 a_n93_3040# MUX_8to1_0.out a_n195_3040# gd sg13_lv_nmos ad=0.114p pd=0.98u as=0.114p ps=0.98u w=0.6u l=0.13u
X437 pdiv$3_0.div_with_reset$3$2_0.d_flip_flop_reset$1$2_0.q pdiv$3_0.div_with_reset$3$2_0.d_flip_flop_reset$1$2_0.NAND_2in_nmosx2$1$1$5_0.b a_4541_n2192# gd sg13_lv_nmos ad=0.204p pd=1.88u as=0.114p ps=0.98u w=0.6u l=0.13u
X438 pdiv$3_0.div_with_reset$3$2_0.d_flip_flop_reset$1$2_4.NAND_2in_nmosx2$1$1$5_0.y pdiv$3_0.div_with_reset$3$2_0.d_flip_flop_reset$1$2_4.NAND_2in_nmosx2$1$1$5_0.a a_3793_3040# gd sg13_lv_nmos ad=0.204p pd=1.88u as=0.114p ps=0.98u w=0.6u l=0.13u
X439 MUX_8to1_0.passgate$1$2_0.B MUX_8to1_0.passgate$1$2_7.in_n MUX_8to1_0.passgate$1$2_7.A gd sg13_lv_nmos ad=0.102p pd=1.28u as=0.102p ps=1.28u w=0.3u l=0.15u
X440 pdiv$3_0.div_with_reset$3$2_0.d_flip_flop_reset$1$2_1.NAND_3in_nmosx3$1$1$3_1.a pdiv$3_0.div_with_reset$3$2_0.d_flip_flop_reset$1$2_1.NAND_2in_nmosx2$1$1$5_0.a VP VP sg13_lv_pmos ad=55.5f pd=0.74u as=55.5f ps=0.74u w=0.15u l=0.13u
X441 MUX_8to1_0.passgate$1$2_5.in_n MUX_8to1_0.passgate$1$2_5.in_p gd gd sg13_lv_nmos ad=0.204p pd=1.88u as=0.204p ps=1.88u w=0.6u l=0.13u
X442 pdiv$3_0.count_data_check$2_0.NAND_3in$2_0/NAND_3in_nmosx3$5$1$2_0.y pdiv$3_0.count_data_check$2_0.XNOR$1$2_5.y a_7459_5263# gd sg13_lv_nmos ad=0.102p pd=1.28u as=57f ps=0.68u w=0.3u l=0.13u
X443 a_n7509_3085# 2Div$2_0.d_flip_flop$3$2_0.NAND_2in_nmosx2$3$2_0.y 2Div$2_0.d_flip_flop$3$2_0.NAND_2in_nmosx2$3$2_0.b gd sg13_lv_nmos ad=57f pd=0.68u as=0.102p ps=1.28u w=0.3u l=0.13u
X444 VP 2Div$2_0.d_flip_flop$3$2_4.NAND_2in_nmosx2$3$2_0.a 2Div$2_0.d_flip_flop$3$2_4.NAND_3in_nmosx3$1$2_0.y VP sg13_lv_pmos ad=0.1005p pd=1.34u as=55.5f ps=0.74u w=0.15u l=0.13u
X445 MUX_8to1_0.passgate$1$2_6.in_p MUX_8to1_0.inverter_x4_ptap_mirror_fix$2$3_5.OUT VP VP sg13_lv_pmos ad=0.1005p pd=1.34u as=55.5f ps=0.74u w=0.15u l=0.13u
X446 gd pdiv$3_0.count_data_check$2_0.c4 a_7428_n2099# gd sg13_lv_nmos ad=0.1005p pd=1.34u as=55.5f ps=0.74u w=0.15u l=0.13u
X447 a_n555_5248# out_div pdiv$3_0.d_flip_flop_reset$2$2_0.d gd sg13_lv_nmos ad=0.114p pd=0.98u as=0.204p ps=1.88u w=0.6u l=0.13u
X448 a_3793_424# pdiv$3_0.div_with_reset$3$2_0.d_flip_flop_reset$1$2_2.NAND_2in_nmosx2$1$1$5_0.b gd gd sg13_lv_nmos ad=0.114p pd=0.98u as=0.204p ps=1.88u w=0.6u l=0.13u
X449 VP pdiv$3_0.NOR_2in$3$2_0.B a_4304_4466# VP sg13_lv_pmos ad=0.102p pd=1.28u as=57f ps=0.68u w=0.3u l=0.15u
X450 a_n9141_31# MUX_8to1_0.in6 2Div$2_0.d_flip_flop$3$2_5.d gd sg13_lv_nmos ad=57f pd=0.68u as=0.102p ps=1.28u w=0.3u l=0.13u
X451 a_n249_5248# pdiv$3_0.d_flip_flop_reset$2$2_0.reset gd gd sg13_lv_nmos ad=0.114p pd=0.98u as=0.114p ps=0.98u w=0.6u l=0.13u
X452 a_825_n2600# pdiv$3_0.passgate$3_1.A gd gd sg13_lv_nmos ad=0.114p pd=0.98u as=0.114p ps=0.98u w=0.6u l=0.13u
X453 gd 2Div$2_0.d_flip_flop$3$2_3.NAND_2in_nmosx2$3$2_0.b a_n8121_n2147# gd sg13_lv_nmos ad=0.102p pd=1.28u as=57f ps=0.68u w=0.3u l=0.13u
X454 MUX_8to1_0.passgate$1$2_0.B MUX_8to1_0.passgate$1$2_1.in_p MUX_8to1_0.passgate$1$2_1.A VP sg13_lv_pmos ad=0.102p pd=1.28u as=0.102p ps=1.28u w=0.3u l=0.15u
X455 pdiv$3_0.count_data_check$2_0.XNOR$1$2_0.y d4 a_7020_n2099# gd sg13_lv_nmos ad=0.1005p pd=1.34u as=55.5f ps=0.74u w=0.15u l=0.13u
X456 pdiv$3_0.count_data_check$2_0.XNOR$1$2_3.y pdiv$3_0.count_data_check$2_0.c5 a_7018_n3434# VP sg13_lv_pmos ad=0.204p pd=1.88u as=0.114p ps=0.98u w=0.6u l=0.13u
X457 gd 2Div$2_0.d_flip_flop$3$2_1.NAND_2in_nmosx2$3$2_0.a a_n5157_2647# gd sg13_lv_nmos ad=0.102p pd=1.28u as=57f ps=0.68u w=0.3u l=0.13u
X458 gd pdiv$3_0.passgate$3_1.A a_1709_2632# gd sg13_lv_nmos ad=0.114p pd=0.98u as=0.114p ps=0.98u w=0.6u l=0.13u
X459 a_3715_16# pdiv$3_0.div_with_reset$3$2_0.d_flip_flop_reset$1$2_2.NAND_3in_nmosx3$1$1$3_1.a pdiv$3_0.div_with_reset$3$2_0.d_flip_flop_reset$1$2_2.NAND_2in_nmosx2$1$1$5_0.a gd sg13_lv_nmos ad=0.114p pd=0.98u as=0.204p ps=1.88u w=0.6u l=0.13u
X460 pdiv$3_0.count_data_check$2_0.c1 pdiv$3_0.div_with_reset$3$2_0.d_flip_flop_reset$1$2_4.NAND_3in_nmosx3$1$1$3_1.a VP VP sg13_lv_pmos ad=55.5f pd=0.74u as=55.5f ps=0.74u w=0.15u l=0.13u
X461 pdiv$3_0.div_with_reset$3$2_0.d_flip_flop_reset$1$2_0.NAND_2in_nmosx2$1$1$5_0.y pdiv$3_0.div_with_reset$3$2_0.d_flip_flop_reset$1$2_0.NAND_2in_nmosx2$1$1$5_0.a a_3793_n2192# gd sg13_lv_nmos ad=0.204p pd=1.88u as=0.114p ps=0.98u w=0.6u l=0.13u
X462 VP 2Div$2_0.d_flip_flop$3$2_6.d 2Div$2_0.d_flip_flop$3$2_6.NAND_2in_nmosx2$3$2_0.a VP sg13_lv_pmos ad=0.1005p pd=1.34u as=55.5f ps=0.74u w=0.15u l=0.13u
X463 VP pdiv$3_0.passgate$3_1.A pdiv$3_0.div_with_reset$3$2_0.d_flip_flop_reset$1$2_4.NAND_2in_nmosx2$1$1$5_0.b VP sg13_lv_pmos ad=55.5f pd=0.74u as=55.5f ps=0.74u w=0.15u l=0.13u
X464 MUX_8to1_0.passgate$1$2_2.in_n MUX_8to1_0.passgate$1$2_2.in_p gd gd sg13_lv_nmos ad=0.204p pd=1.88u as=0.204p ps=1.88u w=0.6u l=0.13u
X465 pdiv$3_0.count_data_check$2_0.XNOR$1$2_5.y pdiv$3_0.count_data_check$2_0.c3 a_7018_n818# VP sg13_lv_pmos ad=0.204p pd=1.88u as=0.114p ps=0.98u w=0.6u l=0.13u
X466 a_4905_16# pdiv$3_0.div_with_reset$3$2_0.d_flip_flop_reset$1$2_2.NAND_3in_nmosx3$1$1$3_1.a a_4803_16# gd sg13_lv_nmos ad=0.114p pd=0.98u as=0.114p ps=0.98u w=0.6u l=0.13u
X467 gd 2Div$2_0.d_flip_flop$3$2_6.NAND_2in_nmosx2$3$2_0.a a_n5157_31# gd sg13_lv_nmos ad=0.102p pd=1.28u as=57f ps=0.68u w=0.3u l=0.13u
X468 a_6702_n769# pdiv$3_0.count_data_check$2_0.c3 gd gd sg13_lv_nmos ad=0.1005p pd=1.34u as=0.1005p ps=1.34u w=0.15u l=0.13u
X469 VP d3 pdiv$3_0.NOR_2in$3$2_0.A VP sg13_lv_pmos ad=55.5f pd=0.74u as=0.1005p ps=1.34u w=0.15u l=0.13u
X470 2Div$2_0.d_flip_flop$3$2_1.d MUX_8to1_0.in3 VP VP sg13_lv_pmos ad=55.5f pd=0.74u as=0.1005p ps=1.34u w=0.15u l=0.13u
X471 a_n8393_n2585# 2Div$2_0.d_flip_flop$3$2_3.NAND_3in_nmosx3$1$2_0.y 2Div$2_0.d_flip_flop$3$2_3.NAND_2in_nmosx2$3$2_0.a gd sg13_lv_nmos ad=57f pd=0.68u as=0.102p ps=1.28u w=0.3u l=0.13u
X472 a_3001_424# pdiv$3_0.passgate$3_1.A gd gd sg13_lv_nmos ad=0.114p pd=0.98u as=0.114p ps=0.98u w=0.6u l=0.13u
X473 pdiv$3_0.d_flip_flop_reset$2$2_0.NAND_2in_nmosx2$1$2$2_0.b pdiv$3_0.d_flip_flop_reset$2$2_0.reset VP VP sg13_lv_pmos ad=55.5f pd=0.74u as=55.5f ps=0.74u w=0.15u l=0.13u
X474 2Div$2_0.d_flip_flop$3$2_2.NAND_3in_nmosx3$1$2_0.y clk VP VP sg13_lv_pmos ad=55.5f pd=0.74u as=55.5f ps=0.74u w=0.15u l=0.13u
X475 a_1709_n2600# pdiv$3_0.div_with_reset$3$2_0.d_flip_flop_reset$1$2_1.NAND_3in_nmosx3$1$1$3_1.a a_1607_n2600# gd sg13_lv_nmos ad=0.114p pd=0.98u as=0.114p ps=0.98u w=0.6u l=0.13u
X476 gd 2Div$2_0.d_flip_flop$3$2_1.NAND_2in_nmosx2$3$2_0.b a_n5741_3085# gd sg13_lv_nmos ad=0.102p pd=1.28u as=57f ps=0.68u w=0.3u l=0.13u
X477 MUX_8to1_0.passgate$1$2_0.B MUX_8to1_0.passgate$1$2_0.in_n MUX_8to1_0.passgate$1$2_0.A gd sg13_lv_nmos ad=0.102p pd=1.28u as=0.102p ps=1.28u w=0.3u l=0.15u
X478 gd pdiv$3_0.NOR_2in$3$2_0.A pdiv$3_0.passgate$3_1.in_p gd sg13_lv_nmos ad=57f pd=0.68u as=0.102p ps=1.28u w=0.3u l=0.15u
X479 gd 2Div$2_0.d_flip_flop$3$2_4.NAND_2in_nmosx2$3$2_0.b a_n5741_n2147# gd sg13_lv_nmos ad=0.102p pd=1.28u as=57f ps=0.68u w=0.3u l=0.13u
X480 a_7428_2629# a_6346_1847# pdiv$3_0.count_data_check$2_0.XNOR$1$2_2.y gd sg13_lv_nmos ad=55.5f pd=0.74u as=0.1005p ps=1.34u w=0.15u l=0.13u
X481 a_4021_2632# pdiv$3_0.passgate$3_1.A gd gd sg13_lv_nmos ad=0.114p pd=0.98u as=0.114p ps=0.98u w=0.6u l=0.13u
X482 pdiv$3_0.div_with_reset$3$2_0.d_flip_flop_reset$1$2_0.NAND_3in_nmosx3$1$1$3_1.a pdiv$3_0.div_with_reset$3$2_0.d_flip_flop_reset$1$2_0.NAND_2in_nmosx2$1$1$5_0.b VP VP sg13_lv_pmos ad=0.1005p pd=1.34u as=55.5f ps=0.74u w=0.15u l=0.13u
X483 VP 2Div$2_0.d_flip_flop$3$2_1.NAND_2in_nmosx2$3$2_0.b 2Div$2_0.d_flip_flop$3$2_1.NAND_2in_nmosx2$3$2_0.y VP sg13_lv_pmos ad=0.1005p pd=1.34u as=55.5f ps=0.74u w=0.15u l=0.13u
X484 VP a_6346_517# a_7434_1258# VP sg13_lv_pmos ad=0.204p pd=1.88u as=0.114p ps=0.98u w=0.6u l=0.13u
X485 gd 2Div$2_0.d_flip_flop$3$2_5.NAND_2in_nmosx2$3$2_0.a a_n7537_31# gd sg13_lv_nmos ad=0.102p pd=1.28u as=57f ps=0.68u w=0.3u l=0.13u
X486 VP d2 pdiv$3_0.NOR_2in$3$2_0.B VP sg13_lv_pmos ad=55.5f pd=0.74u as=0.1005p ps=1.34u w=0.15u l=0.13u
X487 pdiv$3_0.div_with_reset$3$2_0.d_flip_flop_reset$1$2_3.NAND_2in_nmosx2$1$1$5_0.y pdiv$3_0.div_with_reset$3$2_0.d_flip_flop_reset$1$2_3.NAND_2in_nmosx2$1$1$5_0.b VP VP sg13_lv_pmos ad=57f pd=0.68u as=0.102p ps=1.28u w=0.3u l=0.13u
X488 gd 2Div$2_0.d_flip_flop$3$2_6.NAND_3in_nmosx3$1$2_0.y a_n6761_31# gd sg13_lv_nmos ad=0.102p pd=1.28u as=57f ps=0.68u w=0.3u l=0.13u
X489 a_3715_2632# pdiv$3_0.div_with_reset$3$2_0.d_flip_flop_reset$1$2_4.NAND_3in_nmosx3$1$1$3_1.a pdiv$3_0.div_with_reset$3$2_0.d_flip_flop_reset$1$2_4.NAND_2in_nmosx2$1$1$5_0.a gd sg13_lv_nmos ad=0.114p pd=0.98u as=0.204p ps=1.88u w=0.6u l=0.13u
X490 2Div$2_0.d_flip_flop$3$2_6.NAND_2in_nmosx2$3$2_0.a 2Div$2_0.d_flip_flop$3$2_6.NAND_3in_nmosx3$1$2_0.y VP VP sg13_lv_pmos ad=55.5f pd=0.74u as=0.1005p ps=1.34u w=0.15u l=0.13u
X491 pdiv$3_0.count_data_check$2_0.c2 pdiv$3_0.passgate$3_1.A VP VP sg13_lv_pmos ad=55.5f pd=0.74u as=55.5f ps=0.74u w=0.15u l=0.13u
X492 pdiv$3_0.div_with_reset$3$2_0.d_flip_flop_reset$1$2_2.NAND_2in_nmosx2$1$1$5_0.a pdiv$3_0.div_with_reset$3$2_0.d_flip_flop_reset$1$2_2.NAND_3in_nmosx3$1$1$3_1.a VP VP sg13_lv_pmos ad=0.1005p pd=1.34u as=55.5f ps=0.74u w=0.15u l=0.13u
X493 pdiv$3_0.div_with_reset$3$2_0.d_flip_flop_reset$1$2_2.NAND_2in_nmosx2$1$1$5_0.y pdiv$3_0.div_with_reset$3$2_0.d_flip_flop_reset$1$2_2.NAND_2in_nmosx2$1$1$5_0.a a_3793_424# gd sg13_lv_nmos ad=0.204p pd=1.88u as=0.114p ps=0.98u w=0.6u l=0.13u
X494 a_n2435_5263# MUX_8to1_0.inverter_x4_ptap_mirror_fix$2$3_6.OUT gd gd sg13_lv_nmos ad=57f pd=0.68u as=0.102p ps=1.28u w=0.3u l=0.13u
X495 a_n8121_3085# 2Div$2_0.d_flip_flop$3$2_0.NAND_2in_nmosx2$3$2_0.a 2Div$2_0.d_flip_flop$3$2_0.NAND_2in_nmosx2$3$2_0.y gd sg13_lv_nmos ad=57f pd=0.68u as=0.102p ps=1.28u w=0.3u l=0.13u
X496 MUX_8to1_0.passgate$1$2_4.in_p MUX_8to1_0.inverter_x4_ptap_mirror_fix$2$3_5.OUT a_n2333_3085# gd sg13_lv_nmos ad=0.102p pd=1.28u as=57f ps=0.68u w=0.3u l=0.13u
X497 VP 2Div$2_0.d_flip_flop$3$2_3.NAND_2in_nmosx2$3$2_0.a 2Div$2_0.d_flip_flop$3$2_3.NAND_3in_nmosx3$1$2_0.y VP sg13_lv_pmos ad=0.1005p pd=1.34u as=55.5f ps=0.74u w=0.15u l=0.13u
X498 a_519_n2600# pdiv$3_0.div_with_reset$3$2_0.d_flip_flop_reset$1$2_1.NAND_3in_nmosx3$1$1$3_1.a pdiv$3_0.div_with_reset$3$2_0.d_flip_flop_reset$1$2_1.NAND_2in_nmosx2$1$1$5_0.a gd sg13_lv_nmos ad=0.114p pd=0.98u as=0.204p ps=1.88u w=0.6u l=0.13u
X499 a_2797_3040# pdiv$3_0.div_with_reset$3$2_0.d_flip_flop_reset$1$2_4.clk a_2695_3040# gd sg13_lv_nmos ad=0.114p pd=0.98u as=0.114p ps=0.98u w=0.6u l=0.13u
X500 gd pdiv$3_0.div_with_reset$3$2_0.d_flip_flop_reset$1$2_0.NAND_2in_nmosx2$1$1$5_0.a a_2797_n2600# gd sg13_lv_nmos ad=0.114p pd=0.98u as=0.114p ps=0.98u w=0.6u l=0.13u
X501 a_4123_n2600# pdiv$3_0.count_data_check$2_0.c5 a_4021_n2600# gd sg13_lv_nmos ad=0.114p pd=0.98u as=0.114p ps=0.98u w=0.6u l=0.13u
X502 pdiv$3_0.count_data_check$2_0.XNOR$1$2_2.y pdiv$3_0.count_data_check$2_0.c1 a_7018_1798# VP sg13_lv_pmos ad=0.204p pd=1.88u as=0.114p ps=0.98u w=0.6u l=0.13u
X503 pdiv$3_0.div_with_reset$3$2_0.d_flip_flop_reset$1$2_3.NAND_2in_nmosx2$1$1$5_0.a pdiv$3_0.count_data_check$2_0.c2 VP VP sg13_lv_pmos ad=55.5f pd=0.74u as=55.5f ps=0.74u w=0.15u l=0.13u
X504 VP pdiv$3_0.div_with_reset$3$2_0.d_flip_flop_reset$1$2_3.clk pdiv$3_0.div_with_reset$3$2_0.d_flip_flop_reset$1$2_3.NAND_2in_nmosx2$1$1$5_0.b VP sg13_lv_pmos ad=55.5f pd=0.74u as=55.5f ps=0.74u w=0.15u l=0.13u
X505 MUX_8to1_0.passgate$1$2_7.in_n MUX_8to1_0.passgate$1$2_7.in_p gd gd sg13_lv_nmos ad=0.204p pd=1.88u as=0.204p ps=1.88u w=0.6u l=0.13u
X506 MUX_8to1_0.passgate$1$2_7.in_p a0 VP VP sg13_lv_pmos ad=0.1005p pd=1.34u as=55.5f ps=0.74u w=0.15u l=0.13u
X507 VP MUX_8to1_0.out pdiv$3_0.div_with_reset$3$2_0.d_flip_flop_reset$1$2_5.NAND_3in_nmosx3$1$1$3_1.a VP sg13_lv_pmos ad=55.5f pd=0.74u as=55.5f ps=0.74u w=0.15u l=0.13u
X508 pdiv$3_0.div_with_reset$3$2_0.d_flip_flop_reset$1$2_2.clk pdiv$3_0.count_data_check$2_0.c2 VP VP sg13_lv_pmos ad=57f pd=0.68u as=0.102p ps=1.28u w=0.3u l=0.13u
X509 a_n195_16# pdiv$3_0.div_with_reset$3$2_0.d_flip_flop_reset$1$2_3.NAND_2in_nmosx2$1$1$5_0.a gd gd sg13_lv_nmos ad=0.114p pd=0.98u as=0.114p ps=0.98u w=0.6u l=0.13u
X510 pdiv$3_0.passgate$3_1.B pdiv$3_0.passgate$3_1.in_p pdiv$3_0.passgate$3_1.A VP sg13_lv_pmos ad=0.102p pd=1.28u as=0.102p ps=1.28u w=0.3u l=0.15u
X511 a_n6421_n2147# 2Div$2_0.d_flip_flop$3$2_4.NAND_2in_nmosx2$3$2_0.b MUX_8to1_0.in7 gd sg13_lv_nmos ad=57f pd=0.68u as=0.102p ps=1.28u w=0.3u l=0.13u
X512 MUX_8to1_0.passgate$1$2_6.A MUX_8to1_0.in5 VP VP sg13_lv_pmos ad=0.204p pd=1.88u as=0.204p ps=1.88u w=0.6u l=0.13u
X513 2Div$2_0.d_flip_flop$3$2_5.NAND_2in_nmosx2$3$2_0.b 2Div$2_0.d_flip_flop$3$2_5.NAND_2in_nmosx2$3$2_0.y VP VP sg13_lv_pmos ad=55.5f pd=0.74u as=0.1005p ps=1.34u w=0.15u l=0.13u
X514 pdiv$3_0.div_with_reset$3$2_0.d_flip_flop_reset$1$2_1.clk pdiv$3_0.count_data_check$2_0.c3 VP VP sg13_lv_pmos ad=57f pd=0.68u as=0.102p ps=1.28u w=0.3u l=0.13u
X515 pdiv$3_0.div_with_reset$3$2_0.d_flip_flop_reset$1$2_0.clk pdiv$3_0.count_data_check$2_0.c4 VP VP sg13_lv_pmos ad=57f pd=0.68u as=0.102p ps=1.28u w=0.3u l=0.13u
X516 pdiv$3_0.d_flip_flop_reset$2$2_0.NAND_2in_nmosx2$1$2$2_0.a pdiv$3_0.d_flip_flop_reset$2$2_0.NAND_3in_nmosx3$1$2$3_1.a VP VP sg13_lv_pmos ad=0.1005p pd=1.34u as=55.5f ps=0.74u w=0.15u l=0.13u
X517 gd pdiv$3_0.d_flip_flop_reset$2$2_0.NAND_2in_nmosx2$1$2$2_0.b a_863_5656# gd sg13_lv_nmos ad=0.204p pd=1.88u as=0.114p ps=0.98u w=0.6u l=0.13u
X518 VP pdiv$3_0.div_with_reset$3$2_0.d_flip_flop_reset$1$2_2.NAND_3in_nmosx3$1$1$3_1.a pdiv$3_0.count_data_check$2_0.c3 VP sg13_lv_pmos ad=55.5f pd=0.74u as=55.5f ps=0.74u w=0.15u l=0.13u
X519 VP 2Div$2_0.d_flip_flop$3$2_5.NAND_2in_nmosx2$3$2_0.b 2Div$2_0.d_flip_flop$3$2_5.NAND_3in_nmosx3$1$2_0.y VP sg13_lv_pmos ad=55.5f pd=0.74u as=0.1005p ps=1.34u w=0.15u l=0.13u
X520 MUX_8to1_0.passgate$1$2_3.in_n MUX_8to1_0.passgate$1$2_3.in_p gd gd sg13_lv_nmos ad=0.204p pd=1.88u as=0.204p ps=1.88u w=0.6u l=0.13u
X521 pdiv$3_0.count_data_check$2_0.c0 pdiv$3_0.div_with_reset$3$2_0.d_flip_flop_reset$1$2_4.clk VP VP sg13_lv_pmos ad=0.1005p pd=1.34u as=55.5f ps=0.74u w=0.15u l=0.13u
X522 2Div$2_0.d_flip_flop$3$2_3.NAND_2in_nmosx2$3$2_0.y 2Div$2_0.d_flip_flop$3$2_3.NAND_2in_nmosx2$3$2_0.a VP VP sg13_lv_pmos ad=55.5f pd=0.74u as=0.1005p ps=1.34u w=0.15u l=0.13u
X523 VP pdiv$3_0.div_with_reset$3$2_0.d_flip_flop_reset$1$2_2.NAND_2in_nmosx2$1$1$5_0.a pdiv$3_0.div_with_reset$3$2_0.d_flip_flop_reset$1$2_2.NAND_3in_nmosx3$1$1$3_1.a VP sg13_lv_pmos ad=55.5f pd=0.74u as=55.5f ps=0.74u w=0.15u l=0.13u
X524 a_3103_n2192# pdiv$3_0.div_with_reset$3$2_0.d_flip_flop_reset$1$2_0.clk a_3001_n2192# gd sg13_lv_nmos ad=0.114p pd=0.98u as=0.114p ps=0.98u w=0.6u l=0.13u
X525 VP pdiv$3_0.passgate$3_1.A pdiv$3_0.div_with_reset$3$2_0.d_flip_flop_reset$1$2_0.NAND_2in_nmosx2$1$1$5_0.b VP sg13_lv_pmos ad=55.5f pd=0.74u as=55.5f ps=0.74u w=0.15u l=0.13u
X526 a_n501_16# pdiv$3_0.div_with_reset$3$2_0.d_flip_flop_reset$1$2_3.NAND_2in_nmosx2$1$1$5_0.b pdiv$3_0.div_with_reset$3$2_0.d_flip_flop_reset$1$2_3.NAND_3in_nmosx3$1$1$3_1.a gd sg13_lv_nmos ad=0.114p pd=0.98u as=0.204p ps=1.88u w=0.6u l=0.13u
X527 MUX_8to1_0.passgate$1$2_4.in_p MUX_8to1_0.inverter_x4_ptap_mirror_fix$2$3_5.OUT VP VP sg13_lv_pmos ad=0.1005p pd=1.34u as=55.5f ps=0.74u w=0.15u l=0.13u
X528 VP pdiv$3_0.div_with_reset$3$2_0.d_flip_flop_reset$1$2_4.NAND_3in_nmosx3$1$1$3_1.a pdiv$3_0.div_with_reset$3$2_0.d_flip_flop_reset$1$2_4.NAND_2in_nmosx2$1$1$5_0.a VP sg13_lv_pmos ad=55.5f pd=0.74u as=0.1005p ps=1.34u w=0.15u l=0.13u
X529 MUX_8to1_0.inverter_x4_ptap_mirror_fix$2$3_4.OUT MUX_8to1_0.in8 VP VP sg13_lv_pmos ad=0.204p pd=1.88u as=0.204p ps=1.88u w=0.6u l=0.13u
X530 a_4949_5263# d3 pdiv$3_0.NOR_2in$3$2_0.A gd sg13_lv_nmos ad=57f pd=0.68u as=0.102p ps=1.28u w=0.3u l=0.13u
X531 a_597_3040# pdiv$3_0.div_with_reset$3$2_0.d_flip_flop_reset$1$2_5.NAND_2in_nmosx2$1$1$5_0.b gd gd sg13_lv_nmos ad=0.114p pd=0.98u as=0.204p ps=1.88u w=0.6u l=0.13u
X532 a_5211_2632# pdiv$3_0.div_with_reset$3$2_0.d_flip_flop_reset$1$2_4.NAND_3in_nmosx3$1$1$3_1.a a_5109_2632# gd sg13_lv_nmos ad=0.114p pd=0.98u as=0.114p ps=0.98u w=0.6u l=0.13u
X533 pdiv$3_0.count_data_check$2_0.c5 pdiv$3_0.div_with_reset$3$2_0.d_flip_flop_reset$1$2_0.q a_5211_n2600# gd sg13_lv_nmos ad=0.204p pd=1.88u as=0.114p ps=0.98u w=0.6u l=0.13u
X534 pdiv$3_0.d_flip_flop_reset$2$2_0.NAND_2in_nmosx2$1$2$2_0.a pdiv$3_0.d_flip_flop_reset$2$2_0.d VP VP sg13_lv_pmos ad=55.5f pd=0.74u as=55.5f ps=0.74u w=0.15u l=0.13u
X535 MUX_8to1_0.passgate$1$2_0.in_p a1 a_n2333_n2147# gd sg13_lv_nmos ad=0.102p pd=1.28u as=57f ps=0.68u w=0.3u l=0.13u
X536 pdiv$3_0.div_with_reset$3$2_0.d_flip_flop_reset$1$2_2.NAND_3in_nmosx3$1$1$3_1.a pdiv$3_0.div_with_reset$3$2_0.d_flip_flop_reset$1$2_2.NAND_2in_nmosx2$1$1$5_0.b a_3103_16# gd sg13_lv_nmos ad=0.204p pd=1.88u as=0.114p ps=0.98u w=0.6u l=0.13u
X537 a_6346_n769# d3 gd gd sg13_lv_nmos ad=0.1005p pd=1.34u as=0.1005p ps=1.34u w=0.15u l=0.13u
X538 VP 2Div$2_0.d_flip_flop$3$2_0.NAND_3in_nmosx3$1$2_0.y 2Div$2_0.d_flip_flop$3$2_0.d VP sg13_lv_pmos ad=0.1005p pd=1.34u as=55.5f ps=0.74u w=0.15u l=0.13u
X539 a_7357_5701# pdiv$3_0.count_data_check$2_0.XNOR$1$2_2.y gd gd sg13_lv_nmos ad=57f pd=0.68u as=0.102p ps=1.28u w=0.3u l=0.13u
X540 MUX_8to1_0.passgate$1$2_6.in_p MUX_8to1_0.inverter_x4_ptap_mirror_fix$2$3_6.OUT VP VP sg13_lv_pmos ad=55.5f pd=0.74u as=0.1005p ps=1.34u w=0.15u l=0.13u
X541 VP pdiv$3_0.div_with_reset$3$2_0.d_flip_flop_reset$1$2_2.clk pdiv$3_0.div_with_reset$3$2_0.d_flip_flop_reset$1$2_2.NAND_2in_nmosx2$1$1$5_0.b VP sg13_lv_pmos ad=55.5f pd=0.74u as=55.5f ps=0.74u w=0.15u l=0.13u
X542 MUX_8to1_0.inverter_x4_ptap_mirror_fix$2$3_10.OUT MUX_8to1_0.in3 gd gd sg13_lv_nmos ad=0.204p pd=1.88u as=0.204p ps=1.88u w=0.6u l=0.13u
X543 VP pdiv$3_0.div_with_reset$3$2_0.d_flip_flop_reset$1$2_4.clk pdiv$3_0.div_with_reset$3$2_0.d_flip_flop_reset$1$2_4.NAND_3in_nmosx3$1$1$3_1.a VP sg13_lv_pmos ad=55.5f pd=0.74u as=55.5f ps=0.74u w=0.15u l=0.13u
X544 2Div$2_0.d_flip_flop$3$2_4.NAND_2in_nmosx2$3$2_0.y 2Div$2_0.d_flip_flop$3$2_4.NAND_2in_nmosx2$3$2_0.a VP VP sg13_lv_pmos ad=55.5f pd=0.74u as=0.1005p ps=1.34u w=0.15u l=0.13u
X545 MUX_8to1_0.in2 2Div$2_0.d_flip_flop$3$2_2.NAND_2in_nmosx2$3$2_0.b VP VP sg13_lv_pmos ad=55.5f pd=0.74u as=0.1005p ps=1.34u w=0.15u l=0.13u
X546 pdiv$3_0.d_flip_flop_reset$2$2_0.d out_div VP VP sg13_lv_pmos ad=0.1005p pd=1.34u as=55.5f ps=0.74u w=0.15u l=0.13u
X547 pdiv$3_0.div_with_reset$3$2_0.d_flip_flop_reset$1$2_0.NAND_3in_nmosx3$1$1$3_1.a pdiv$3_0.div_with_reset$3$2_0.d_flip_flop_reset$1$2_0.NAND_2in_nmosx2$1$1$5_0.a VP VP sg13_lv_pmos ad=55.5f pd=0.74u as=55.5f ps=0.74u w=0.15u l=0.13u
X548 VP pdiv$3_0.passgate$3_1.A pdiv$3_0.count_data_check$2_0.c5 VP sg13_lv_pmos ad=55.5f pd=0.74u as=55.5f ps=0.74u w=0.15u l=0.13u
X549 pdiv$3_0.count_data_check$2_0.XNOR$1$2_0.y pdiv$3_0.count_data_check$2_0.c4 a_7018_n1358# VP sg13_lv_pmos ad=0.204p pd=1.88u as=0.114p ps=0.98u w=0.6u l=0.13u
X550 a_7428_13# a_6346_n769# pdiv$3_0.count_data_check$2_0.XNOR$1$2_5.y gd sg13_lv_nmos ad=55.5f pd=0.74u as=0.1005p ps=1.34u w=0.15u l=0.13u
X551 gd 2Div$2_0.d_flip_flop$3$2_2.d a_n6421_5701# gd sg13_lv_nmos ad=0.102p pd=1.28u as=57f ps=0.68u w=0.3u l=0.13u
X552 a_6888_6498# pdiv$3_0.count_data_check$2_0.NAND_3in$2_1/NAND_3in_nmosx3$5$1$2_0.y pdiv$3_0.inverter_x8$3_0.IN VP sg13_lv_pmos ad=57f pd=0.68u as=0.102p ps=1.28u w=0.3u l=0.15u
X553 a_825_2632# pdiv$3_0.passgate$3_1.A gd gd sg13_lv_nmos ad=0.114p pd=0.98u as=0.114p ps=0.98u w=0.6u l=0.13u
X554 a_n5741_5701# 2Div$2_0.d_flip_flop$3$2_2.NAND_2in_nmosx2$3$2_0.a 2Div$2_0.d_flip_flop$3$2_2.NAND_2in_nmosx2$3$2_0.y gd sg13_lv_nmos ad=57f pd=0.68u as=0.102p ps=1.28u w=0.3u l=0.13u
X555 MUX_8to1_0.passgate$1$2_0.B MUX_8to1_0.passgate$1$2_5.in_n MUX_8to1_0.passgate$1$2_5.A gd sg13_lv_nmos ad=0.102p pd=1.28u as=0.102p ps=1.28u w=0.3u l=0.15u
X556 a_3103_3040# pdiv$3_0.div_with_reset$3$2_0.d_flip_flop_reset$1$2_4.clk a_3001_3040# gd sg13_lv_nmos ad=0.114p pd=0.98u as=0.114p ps=0.98u w=0.6u l=0.13u
X557 VP 2Div$2_0.d_flip_flop$3$2_3.NAND_3in_nmosx3$1$2_0.y 2Div$2_0.d_flip_flop$3$2_3.d VP sg13_lv_pmos ad=0.1005p pd=1.34u as=55.5f ps=0.74u w=0.15u l=0.13u
X558 VP pdiv$3_0.d_flip_flop_reset$2$2_0.d out_div VP sg13_lv_pmos ad=0.102p pd=1.28u as=57f ps=0.68u w=0.3u l=0.13u
X559 a_4541_3040# pdiv$3_0.count_data_check$2_0.c1 gd gd sg13_lv_nmos ad=0.114p pd=0.98u as=0.204p ps=1.88u w=0.6u l=0.13u
X560 VP pdiv$3_0.div_with_reset$3$2_0.d_flip_flop_reset$1$2_1.NAND_2in_nmosx2$1$1$5_0.b pdiv$3_0.div_with_reset$3$2_0.d_flip_flop_reset$1$2_1.NAND_3in_nmosx3$1$1$3_1.a VP sg13_lv_pmos ad=55.5f pd=0.74u as=0.1005p ps=1.34u w=0.15u l=0.13u
X561 2Div$2_0.d_flip_flop$3$2_5.d MUX_8to1_0.in6 VP VP sg13_lv_pmos ad=55.5f pd=0.74u as=0.1005p ps=1.34u w=0.15u l=0.13u
X562 VP a_6346_3133# a_7434_3874# VP sg13_lv_pmos ad=0.204p pd=1.88u as=0.114p ps=0.98u w=0.6u l=0.13u
X563 pdiv$3_0.d_flip_flop_reset$2$2_0.NAND_2in_nmosx2$1$2$2_0.a pdiv$3_0.d_flip_flop_reset$2$2_0.NAND_3in_nmosx3$1$2$3_1.a a_941_5248# gd sg13_lv_nmos ad=0.204p pd=1.88u as=0.114p ps=0.98u w=0.6u l=0.13u
X564 pdiv$3_0.div_with_reset$3$2_0.d_flip_flop_reset$1$2_5.NAND_2in_nmosx2$1$1$5_0.y pdiv$3_0.div_with_reset$3$2_0.d_flip_flop_reset$1$2_5.NAND_2in_nmosx2$1$1$5_0.b VP VP sg13_lv_pmos ad=57f pd=0.68u as=0.102p ps=1.28u w=0.3u l=0.13u
X565 VP pdiv$3_0.passgate$3_1.A pdiv$3_0.div_with_reset$3$2_0.d_flip_flop_reset$1$2_0.NAND_2in_nmosx2$1$1$5_0.a VP sg13_lv_pmos ad=55.5f pd=0.74u as=55.5f ps=0.74u w=0.15u l=0.13u
X566 gd pdiv$3_0.div_with_reset$3$2_0.d_flip_flop_reset$1$2_1.NAND_2in_nmosx2$1$1$5_0.a a_n399_n2600# gd sg13_lv_nmos ad=0.114p pd=0.98u as=0.114p ps=0.98u w=0.6u l=0.13u
X567 a_1607_16# pdiv$3_0.div_with_reset$3$2_0.d_flip_flop_reset$1$2_2.clk pdiv$3_0.count_data_check$2_0.c2 gd sg13_lv_nmos ad=0.114p pd=0.98u as=0.204p ps=1.88u w=0.6u l=0.13u
X568 a_6702_517# pdiv$3_0.count_data_check$2_0.c2 gd gd sg13_lv_nmos ad=0.1005p pd=1.34u as=0.1005p ps=1.34u w=0.15u l=0.13u
X569 a_n399_2632# MUX_8to1_0.out a_n501_2632# gd sg13_lv_nmos ad=0.114p pd=0.98u as=0.114p ps=0.98u w=0.6u l=0.13u
X570 gd 2Div$2_0.d_flip_flop$3$2_4.NAND_2in_nmosx2$3$2_0.a a_n5157_n2585# gd sg13_lv_nmos ad=0.102p pd=1.28u as=57f ps=0.68u w=0.3u l=0.13u
X571 MUX_8to1_0.passgate$1$2_6.in_n MUX_8to1_0.passgate$1$2_6.in_p gd gd sg13_lv_nmos ad=0.204p pd=1.88u as=0.204p ps=1.88u w=0.6u l=0.13u
X572 MUX_8to1_0.passgate$1$2_7.in_p a0 a_n2333_2647# gd sg13_lv_nmos ad=0.102p pd=1.28u as=57f ps=0.68u w=0.3u l=0.13u
X573 2Div$2_0.d_flip_flop$3$2_0.NAND_2in_nmosx2$3$2_0.a 2Div$2_0.d_flip_flop$3$2_0.NAND_3in_nmosx3$1$2_0.y VP VP sg13_lv_pmos ad=55.5f pd=0.74u as=0.1005p ps=1.34u w=0.15u l=0.13u
X574 a_n93_2632# MUX_8to1_0.out a_n195_2632# gd sg13_lv_nmos ad=0.114p pd=0.98u as=0.114p ps=0.98u w=0.6u l=0.13u
X575 a_n8801_n2147# 2Div$2_0.d_flip_flop$3$2_3.NAND_2in_nmosx2$3$2_0.b MUX_8to1_0.in8 gd sg13_lv_nmos ad=57f pd=0.68u as=0.102p ps=1.28u w=0.3u l=0.13u
X576 a_2797_16# pdiv$3_0.div_with_reset$3$2_0.d_flip_flop_reset$1$2_2.clk a_2695_16# gd sg13_lv_nmos ad=0.114p pd=0.98u as=0.114p ps=0.98u w=0.6u l=0.13u
X577 gd 2Div$2_0.d_flip_flop$3$2_2.NAND_2in_nmosx2$3$2_0.a a_n5157_5263# gd sg13_lv_nmos ad=0.102p pd=1.28u as=57f ps=0.68u w=0.3u l=0.13u
X578 MUX_8to1_0.out MUX_8to1_0.passgate$1$2_0.B gd gd sg13_lv_nmos ad=0.204p pd=1.88u as=0.204p ps=1.88u w=0.6u l=0.13u
X579 a_5109_16# pdiv$3_0.passgate$3_1.A gd gd sg13_lv_nmos ad=0.114p pd=0.98u as=0.114p ps=0.98u w=0.6u l=0.13u
X580 gd pdiv$3_0.d_flip_flop_reset$2$2_0.reset a_1655_5656# gd sg13_lv_nmos ad=0.114p pd=0.98u as=0.114p ps=0.98u w=0.6u l=0.13u
X581 gd clk a_n5129_5701# gd sg13_lv_nmos ad=0.102p pd=1.28u as=57f ps=0.68u w=0.3u l=0.13u
X582 pdiv$3_0.div_with_reset$3$2_0.d_flip_flop_reset$1$2_2.NAND_2in_nmosx2$1$1$5_0.a pdiv$3_0.div_with_reset$3$2_0.d_flip_flop_reset$1$2_2.NAND_3in_nmosx3$1$1$3_1.a a_4123_16# gd sg13_lv_nmos ad=0.204p pd=1.88u as=0.114p ps=0.98u w=0.6u l=0.13u
X583 a_1913_16# pdiv$3_0.passgate$3_1.A gd gd sg13_lv_nmos ad=0.114p pd=0.98u as=0.114p ps=0.98u w=0.6u l=0.13u
X584 VP 2Div$2_0.d_flip_flop$3$2_6.d MUX_8to1_0.in5 VP sg13_lv_pmos ad=0.1005p pd=1.34u as=55.5f ps=0.74u w=0.15u l=0.13u
X585 a_519_16# pdiv$3_0.div_with_reset$3$2_0.d_flip_flop_reset$1$2_3.NAND_3in_nmosx3$1$1$3_1.a pdiv$3_0.div_with_reset$3$2_0.d_flip_flop_reset$1$2_3.NAND_2in_nmosx2$1$1$5_0.a gd sg13_lv_nmos ad=0.114p pd=0.98u as=0.204p ps=1.88u w=0.6u l=0.13u
X586 a_n2333_5701# MUX_8to1_0.inverter_x4_ptap_mirror_fix$2$3_7.OUT a_n2435_5701# gd sg13_lv_nmos ad=57f pd=0.68u as=57f ps=0.68u w=0.3u l=0.13u
X587 gd MUX_8to1_0.in5 a_n7509_469# gd sg13_lv_nmos ad=0.102p pd=1.28u as=57f ps=0.68u w=0.3u l=0.13u
X588 VP MUX_8to1_0.out pdiv$3_0.div_with_reset$3$2_0.d_flip_flop_reset$1$2_5.NAND_2in_nmosx2$1$1$5_0.b VP sg13_lv_pmos ad=55.5f pd=0.74u as=55.5f ps=0.74u w=0.15u l=0.13u
X589 a_7020_n2603# a_6702_n3385# gd gd sg13_lv_nmos ad=55.5f pd=0.74u as=0.1005p ps=1.34u w=0.15u l=0.13u
X590 VP 2Div$2_0.d_flip_flop$3$2_4.NAND_3in_nmosx3$1$2_0.y 2Div$2_0.d_flip_flop$3$2_4.d VP sg13_lv_pmos ad=0.1005p pd=1.34u as=55.5f ps=0.74u w=0.15u l=0.13u
X591 2Div$2_0.d_flip_flop$3$2_2.d MUX_8to1_0.in2 VP VP sg13_lv_pmos ad=55.5f pd=0.74u as=0.1005p ps=1.34u w=0.15u l=0.13u
X592 VP 2Div$2_0.d_flip_flop$3$2_1.NAND_2in_nmosx2$3$2_0.a 2Div$2_0.d_flip_flop$3$2_1.NAND_3in_nmosx3$1$2_0.y VP sg13_lv_pmos ad=0.1005p pd=1.34u as=55.5f ps=0.74u w=0.15u l=0.13u
X593 MUX_8to1_0.passgate$1$2_0.in_p a1 VP VP sg13_lv_pmos ad=0.1005p pd=1.34u as=55.5f ps=0.74u w=0.15u l=0.13u
X594 pdiv$3_0.passgate$3_1.in_n pdiv$3_0.passgate$3_1.in_p gd gd sg13_lv_nmos ad=0.204p pd=1.88u as=0.204p ps=1.88u w=0.6u l=0.13u
X595 pdiv$3_0.div_with_reset$3$2_0.d_flip_flop_reset$1$2_4.clk pdiv$3_0.count_data_check$2_0.c0 VP VP sg13_lv_pmos ad=57f pd=0.68u as=0.102p ps=1.28u w=0.3u l=0.13u
X596 VP pdiv$3_0.count_data_check$2_0.c1 pdiv$3_0.div_with_reset$3$2_0.d_flip_flop_reset$1$2_4.NAND_2in_nmosx2$1$1$5_0.a VP sg13_lv_pmos ad=55.5f pd=0.74u as=55.5f ps=0.74u w=0.15u l=0.13u
X597 VP pdiv$3_0.div_with_reset$3$2_0.d_flip_flop_reset$1$2_2.NAND_2in_nmosx2$1$1$5_0.a pdiv$3_0.div_with_reset$3$2_0.d_flip_flop_reset$1$2_2.NAND_2in_nmosx2$1$1$5_0.y VP sg13_lv_pmos ad=0.102p pd=1.28u as=57f ps=0.68u w=0.3u l=0.13u
X598 pdiv$3_0.count_data_check$2_0.c3 pdiv$3_0.div_with_reset$3$2_0.d_flip_flop_reset$1$2_2.NAND_3in_nmosx3$1$1$3_1.a VP VP sg13_lv_pmos ad=55.5f pd=0.74u as=55.5f ps=0.74u w=0.15u l=0.13u
X599 pdiv$3_0.div_with_reset$3$2_0.d_flip_flop_reset$1$2_1.NAND_2in_nmosx2$1$1$5_0.y pdiv$3_0.div_with_reset$3$2_0.d_flip_flop_reset$1$2_1.NAND_2in_nmosx2$1$1$5_0.b VP VP sg13_lv_pmos ad=57f pd=0.68u as=0.102p ps=1.28u w=0.3u l=0.13u
X600 MUX_8to1_0.passgate$1$2_6.in_p MUX_8to1_0.inverter_x4_ptap_mirror_fix$2$3_5.OUT a_n2333_469# gd sg13_lv_nmos ad=0.102p pd=1.28u as=57f ps=0.68u w=0.3u l=0.13u
X601 2Div$2_0.d_flip_flop$3$2_0.NAND_2in_nmosx2$3$2_0.b 2Div$2_0.d_flip_flop$3$2_0.NAND_2in_nmosx2$3$2_0.y VP VP sg13_lv_pmos ad=55.5f pd=0.74u as=0.1005p ps=1.34u w=0.15u l=0.13u
X602 pdiv$3_0.div_with_reset$3$2_0.d_flip_flop_reset$1$2_3.clk pdiv$3_0.count_data_check$2_0.c1 VP VP sg13_lv_pmos ad=57f pd=0.68u as=0.102p ps=1.28u w=0.3u l=0.13u
X603 a_3715_n2600# pdiv$3_0.div_with_reset$3$2_0.d_flip_flop_reset$1$2_0.NAND_3in_nmosx3$1$1$3_1.a pdiv$3_0.div_with_reset$3$2_0.d_flip_flop_reset$1$2_0.NAND_2in_nmosx2$1$1$5_0.a gd sg13_lv_nmos ad=0.114p pd=0.98u as=0.204p ps=1.88u w=0.6u l=0.13u
X604 VP pdiv$3_0.div_with_reset$3$2_0.d_flip_flop_reset$1$2_0.q pdiv$3_0.count_data_check$2_0.c5 VP sg13_lv_pmos ad=55.5f pd=0.74u as=0.1005p ps=1.34u w=0.15u l=0.13u
X605 a_825_16# pdiv$3_0.passgate$3_1.A gd gd sg13_lv_nmos ad=0.114p pd=0.98u as=0.114p ps=0.98u w=0.6u l=0.13u
X606 VP 2Div$2_0.d_flip_flop$3$2_2.NAND_2in_nmosx2$3$2_0.b 2Div$2_0.d_flip_flop$3$2_2.NAND_2in_nmosx2$3$2_0.y VP sg13_lv_pmos ad=0.1005p pd=1.34u as=55.5f ps=0.74u w=0.15u l=0.13u
X607 a_7428_3133# a_6346_3133# pdiv$3_0.count_data_check$2_0.XNOR$1$2_1.y gd sg13_lv_nmos ad=55.5f pd=0.74u as=0.1005p ps=1.34u w=0.15u l=0.13u
X608 pdiv$3_0.div_with_reset$3$2_0.d_flip_flop_reset$1$2_1.NAND_3in_nmosx3$1$1$3_1.a pdiv$3_0.div_with_reset$3$2_0.d_flip_flop_reset$1$2_1.NAND_2in_nmosx2$1$1$5_0.b VP VP sg13_lv_pmos ad=0.1005p pd=1.34u as=55.5f ps=0.74u w=0.15u l=0.13u
X609 VP pdiv$3_0.passgate$3_1.A pdiv$3_0.div_with_reset$3$2_0.d_flip_flop_reset$1$2_3.NAND_2in_nmosx2$1$1$5_0.b VP sg13_lv_pmos ad=55.5f pd=0.74u as=55.5f ps=0.74u w=0.15u l=0.13u
X610 MUX_8to1_0.passgate$1$2_1.in_n MUX_8to1_0.passgate$1$2_1.in_p gd gd sg13_lv_nmos ad=0.204p pd=1.88u as=0.204p ps=1.88u w=0.6u l=0.13u
X611 VP pdiv$3_0.div_with_reset$3$2_0.d_flip_flop_reset$1$2_5.NAND_3in_nmosx3$1$1$3_1.a pdiv$3_0.div_with_reset$3$2_0.d_flip_flop_reset$1$2_5.NAND_2in_nmosx2$1$1$5_0.a VP sg13_lv_pmos ad=55.5f pd=0.74u as=0.1005p ps=1.34u w=0.15u l=0.13u
X612 MUX_8to1_0.passgate$1$2_6.A MUX_8to1_0.in5 gd gd sg13_lv_nmos ad=0.204p pd=1.88u as=0.204p ps=1.88u w=0.6u l=0.13u
X613 MUX_8to1_0.passgate$1$2_7.in_p a1 VP VP sg13_lv_pmos ad=55.5f pd=0.74u as=0.1005p ps=1.34u w=0.15u l=0.13u
X614 VP pdiv$3_0.div_with_reset$3$2_0.d_flip_flop_reset$1$2_5.NAND_2in_nmosx2$1$1$5_0.a pdiv$3_0.div_with_reset$3$2_0.d_flip_flop_reset$1$2_5.NAND_3in_nmosx3$1$1$3_1.a VP sg13_lv_pmos ad=55.5f pd=0.74u as=55.5f ps=0.74u w=0.15u l=0.13u
X615 VP MUX_8to1_0.in4 2Div$2_0.d_flip_flop$3$2_6.NAND_2in_nmosx2$3$2_0.b VP sg13_lv_pmos ad=0.1005p pd=1.34u as=55.5f ps=0.74u w=0.15u l=0.13u
X616 VP pdiv$3_0.d_flip_flop_reset$2$2_0.NAND_2in_nmosx2$1$2$2_0.b pdiv$3_0.d_flip_flop_reset$2$2_0.NAND_2in_nmosx2$1$2$2_0.y VP sg13_lv_pmos ad=0.102p pd=1.28u as=57f ps=0.68u w=0.3u l=0.13u
X617 VP pdiv$3_0.count_data_check$2_0.c0 pdiv$3_0.div_with_reset$3$2_0.d_flip_flop_reset$1$2_5.NAND_2in_nmosx2$1$1$5_0.a VP sg13_lv_pmos ad=55.5f pd=0.74u as=55.5f ps=0.74u w=0.15u l=0.13u
X618 2Div$2_0.d_flip_flop$3$2_4.NAND_3in_nmosx3$1$2_0.y MUX_8to1_0.in6 VP VP sg13_lv_pmos ad=55.5f pd=0.74u as=55.5f ps=0.74u w=0.15u l=0.13u
X619 VP pdiv$3_0.div_with_reset$3$2_0.d_flip_flop_reset$1$2_1.clk pdiv$3_0.div_with_reset$3$2_0.d_flip_flop_reset$1$2_1.NAND_2in_nmosx2$1$1$5_0.b VP sg13_lv_pmos ad=55.5f pd=0.74u as=55.5f ps=0.74u w=0.15u l=0.13u
X620 MUX_8to1_0.passgate$1$2_0.B MUX_8to1_0.passgate$1$2_2.in_n MUX_8to1_0.inverter_x4_ptap_mirror_fix$2$3_4.OUT gd sg13_lv_nmos ad=0.102p pd=1.28u as=0.102p ps=1.28u w=0.3u l=0.15u
X621 2Div$2_0.d_flip_flop$3$2_6.NAND_3in_nmosx3$1$2_0.y MUX_8to1_0.in4 VP VP sg13_lv_pmos ad=55.5f pd=0.74u as=55.5f ps=0.74u w=0.15u l=0.13u
X622 MUX_8to1_0.passgate$1$2_0.B MUX_8to1_0.passgate$1$2_4.in_n MUX_8to1_0.inverter_x4_ptap_mirror_fix$2$3_10.OUT gd sg13_lv_nmos ad=0.102p pd=1.28u as=0.102p ps=1.28u w=0.3u l=0.15u
X623 a_2695_n2192# pdiv$3_0.div_with_reset$3$2_0.d_flip_flop_reset$1$2_0.NAND_2in_nmosx2$1$1$5_0.y pdiv$3_0.div_with_reset$3$2_0.d_flip_flop_reset$1$2_0.NAND_2in_nmosx2$1$1$5_0.b gd sg13_lv_nmos ad=0.114p pd=0.98u as=0.204p ps=1.88u w=0.6u l=0.13u
X624 gd 2Div$2_0.d_flip_flop$3$2_0.NAND_3in_nmosx3$1$2_0.y a_n9141_2647# gd sg13_lv_nmos ad=0.102p pd=1.28u as=57f ps=0.68u w=0.3u l=0.13u
X625 a_3817_16# pdiv$3_0.count_data_check$2_0.c3 a_3715_16# gd sg13_lv_nmos ad=0.114p pd=0.98u as=0.114p ps=0.98u w=0.6u l=0.13u
X626 pdiv$3_0.div_with_reset$3$2_0.d_flip_flop_reset$1$2_2.NAND_2in_nmosx2$1$1$5_0.b pdiv$3_0.div_with_reset$3$2_0.d_flip_flop_reset$1$2_2.clk VP VP sg13_lv_pmos ad=55.5f pd=0.74u as=55.5f ps=0.74u w=0.15u l=0.13u
X627 MUX_8to1_0.passgate$1$2_5.A MUX_8to1_0.in2 gd gd sg13_lv_nmos ad=0.204p pd=1.88u as=0.204p ps=1.88u w=0.6u l=0.13u
X628 VP a_6346_n769# a_7434_n818# VP sg13_lv_pmos ad=0.204p pd=1.88u as=0.114p ps=0.98u w=0.6u l=0.13u
X629 pdiv$3_0.div_with_reset$3$2_0.d_flip_flop_reset$1$2_4.NAND_3in_nmosx3$1$1$3_1.a pdiv$3_0.div_with_reset$3$2_0.d_flip_flop_reset$1$2_4.clk VP VP sg13_lv_pmos ad=55.5f pd=0.74u as=55.5f ps=0.74u w=0.15u l=0.13u
X630 MUX_8to1_0.passgate$1$2_4.in_p a1 VP VP sg13_lv_pmos ad=55.5f pd=0.74u as=0.1005p ps=1.34u w=0.15u l=0.13u
X631 VP pdiv$3_0.div_with_reset$3$2_0.d_flip_flop_reset$1$2_4.clk pdiv$3_0.div_with_reset$3$2_0.d_flip_flop_reset$1$2_4.NAND_2in_nmosx2$1$1$5_0.b VP sg13_lv_pmos ad=55.5f pd=0.74u as=55.5f ps=0.74u w=0.15u l=0.13u
X632 MUX_8to1_0.passgate$1$2_4.in_n MUX_8to1_0.passgate$1$2_4.in_p gd gd sg13_lv_nmos ad=0.204p pd=1.88u as=0.204p ps=1.88u w=0.6u l=0.13u
X633 a_n501_3040# pdiv$3_0.div_with_reset$3$2_0.d_flip_flop_reset$1$2_5.NAND_2in_nmosx2$1$1$5_0.y pdiv$3_0.div_with_reset$3$2_0.d_flip_flop_reset$1$2_5.NAND_2in_nmosx2$1$1$5_0.b gd sg13_lv_nmos ad=0.114p pd=0.98u as=0.204p ps=1.88u w=0.6u l=0.13u
X634 gd 2Div$2_0.d_flip_flop$3$2_3.NAND_2in_nmosx2$3$2_0.a a_n7537_n2585# gd sg13_lv_nmos ad=0.102p pd=1.28u as=57f ps=0.68u w=0.3u l=0.13u
X635 gd pdiv$3_0.passgate$3_1.A a_4905_16# gd sg13_lv_nmos ad=0.114p pd=0.98u as=0.114p ps=0.98u w=0.6u l=0.13u
X636 pdiv$3_0.count_data_check$2_0.XNOR$1$2_2.y d1 a_7020_2629# gd sg13_lv_nmos ad=0.1005p pd=1.34u as=55.5f ps=0.74u w=0.15u l=0.13u
X637 VP pdiv$3_0.passgate$3_1.A pdiv$3_0.div_with_reset$3$2_0.d_flip_flop_reset$1$2_4.NAND_2in_nmosx2$1$1$5_0.a VP sg13_lv_pmos ad=55.5f pd=0.74u as=55.5f ps=0.74u w=0.15u l=0.13u
X638 a_4905_n2600# pdiv$3_0.div_with_reset$3$2_0.d_flip_flop_reset$1$2_0.NAND_3in_nmosx3$1$1$3_1.a a_4803_n2600# gd sg13_lv_nmos ad=0.114p pd=0.98u as=0.114p ps=0.98u w=0.6u l=0.13u
X639 gd 2Div$2_0.d_flip_flop$3$2_5.NAND_2in_nmosx2$3$2_0.b a_n8121_469# gd sg13_lv_nmos ad=0.102p pd=1.28u as=57f ps=0.68u w=0.3u l=0.13u
X640 a_n7509_469# 2Div$2_0.d_flip_flop$3$2_5.NAND_2in_nmosx2$3$2_0.y 2Div$2_0.d_flip_flop$3$2_5.NAND_2in_nmosx2$3$2_0.b gd sg13_lv_nmos ad=57f pd=0.68u as=0.102p ps=1.28u w=0.3u l=0.13u
X641 MUX_8to1_0.passgate$1$2_5.in_p a0 VP VP sg13_lv_pmos ad=0.1005p pd=1.34u as=55.5f ps=0.74u w=0.15u l=0.13u
X642 pdiv$3_0.count_data_check$2_0.c5 pdiv$3_0.passgate$3_1.A VP VP sg13_lv_pmos ad=55.5f pd=0.74u as=55.5f ps=0.74u w=0.15u l=0.13u
X643 pdiv$3_0.d_flip_flop_reset$2$2_0.NAND_2in_nmosx2$1$2$2_0.b pdiv$3_0.d_flip_flop_reset$2$2_0.NAND_2in_nmosx2$1$2$2_0.y a_1961_5656# gd sg13_lv_nmos ad=0.204p pd=1.88u as=0.114p ps=0.98u w=0.6u l=0.13u
X644 a_2797_2632# pdiv$3_0.div_with_reset$3$2_0.d_flip_flop_reset$1$2_4.clk a_2695_2632# gd sg13_lv_nmos ad=0.114p pd=0.98u as=0.114p ps=0.98u w=0.6u l=0.13u
X645 VP pdiv$3_0.div_with_reset$3$2_0.d_flip_flop_reset$1$2_0.clk pdiv$3_0.count_data_check$2_0.c4 VP sg13_lv_pmos ad=55.5f pd=0.74u as=0.1005p ps=1.34u w=0.15u l=0.13u
X646 gd pdiv$3_0.d_flip_flop_reset$2$2_0.reset a_n453_5248# gd sg13_lv_nmos ad=0.114p pd=0.98u as=0.114p ps=0.98u w=0.6u l=0.13u
X647 a_n2333_469# a2 a_n2435_469# gd sg13_lv_nmos ad=57f pd=0.68u as=57f ps=0.68u w=0.3u l=0.13u
X648 a_3817_n2600# pdiv$3_0.count_data_check$2_0.c5 a_3715_n2600# gd sg13_lv_nmos ad=0.114p pd=0.98u as=0.114p ps=0.98u w=0.6u l=0.13u
X649 a_n5157_2647# MUX_8to1_0.in2 a_n5259_2647# gd sg13_lv_nmos ad=57f pd=0.68u as=57f ps=0.68u w=0.3u l=0.13u
X650 MUX_8to1_0.passgate$1$2_3.in_p MUX_8to1_0.inverter_x4_ptap_mirror_fix$2$3_5.OUT VP VP sg13_lv_pmos ad=0.1005p pd=1.34u as=55.5f ps=0.74u w=0.15u l=0.13u
X651 a_1913_2632# pdiv$3_0.passgate$3_1.A gd gd sg13_lv_nmos ad=0.114p pd=0.98u as=0.114p ps=0.98u w=0.6u l=0.13u
X652 VP pdiv$3_0.div_with_reset$3$2_0.d_flip_flop_reset$1$2_3.clk pdiv$3_0.div_with_reset$3$2_0.d_flip_flop_reset$1$2_3.NAND_3in_nmosx3$1$1$3_1.a VP sg13_lv_pmos ad=55.5f pd=0.74u as=55.5f ps=0.74u w=0.15u l=0.13u
X653 a_6346_517# d2 gd gd sg13_lv_nmos ad=0.1005p pd=1.34u as=0.1005p ps=1.34u w=0.15u l=0.13u
X654 a_7018_1258# d2 VP VP sg13_lv_pmos ad=0.114p pd=0.98u as=0.204p ps=1.88u w=0.6u l=0.13u
X655 MUX_8to1_0.passgate$1$2_2.in_n MUX_8to1_0.passgate$1$2_2.in_p VP VP sg13_lv_pmos ad=0.204p pd=1.88u as=0.204p ps=1.88u w=0.6u l=0.13u
X656 pdiv$3_0.count_data_check$2_0.c5 pdiv$3_0.div_with_reset$3$2_0.d_flip_flop_reset$1$2_0.q VP VP sg13_lv_pmos ad=0.1005p pd=1.34u as=55.5f ps=0.74u w=0.15u l=0.13u
X657 a_n2435_469# MUX_8to1_0.inverter_x4_ptap_mirror_fix$2$3_6.OUT gd gd sg13_lv_nmos ad=57f pd=0.68u as=0.102p ps=1.28u w=0.3u l=0.13u
X658 pdiv$3_0.count_data_check$2_0.c2 pdiv$3_0.div_with_reset$3$2_0.d_flip_flop_reset$1$2_2.clk VP VP sg13_lv_pmos ad=0.1005p pd=1.34u as=55.5f ps=0.74u w=0.15u l=0.13u
X659 gd 2Div$2_0.d_flip_flop$3$2_1.d a_n6421_3085# gd sg13_lv_nmos ad=0.102p pd=1.28u as=57f ps=0.68u w=0.3u l=0.13u
X660 pdiv$3_0.div_with_reset$3$2_0.d_flip_flop_reset$1$2_1.NAND_2in_nmosx2$1$1$5_0.b pdiv$3_0.div_with_reset$3$2_0.d_flip_flop_reset$1$2_1.NAND_2in_nmosx2$1$1$5_0.y a_n93_n2192# gd sg13_lv_nmos ad=0.204p pd=1.88u as=0.114p ps=0.98u w=0.6u l=0.13u
X661 MUX_8to1_0.passgate$1$2_3.in_n MUX_8to1_0.passgate$1$2_3.in_p VP VP sg13_lv_pmos ad=0.204p pd=1.88u as=0.204p ps=1.88u w=0.6u l=0.13u
X662 gd pdiv$3_0.passgate$3_1.A a_4905_2632# gd sg13_lv_nmos ad=0.114p pd=0.98u as=0.114p ps=0.98u w=0.6u l=0.13u
X663 VP a_6346_1847# a_7434_1798# VP sg13_lv_pmos ad=0.204p pd=1.88u as=0.114p ps=0.98u w=0.6u l=0.13u
X664 a_4541_424# pdiv$3_0.count_data_check$2_0.c3 gd gd sg13_lv_nmos ad=0.114p pd=0.98u as=0.204p ps=1.88u w=0.6u l=0.13u
X665 a_2797_n2192# pdiv$3_0.div_with_reset$3$2_0.d_flip_flop_reset$1$2_0.clk a_2695_n2192# gd sg13_lv_nmos ad=0.114p pd=0.98u as=0.114p ps=0.98u w=0.6u l=0.13u
X666 VP pdiv$3_0.div_with_reset$3$2_0.d_flip_flop_reset$1$2_2.NAND_3in_nmosx3$1$1$3_1.a pdiv$3_0.div_with_reset$3$2_0.d_flip_flop_reset$1$2_2.NAND_2in_nmosx2$1$1$5_0.a VP sg13_lv_pmos ad=55.5f pd=0.74u as=0.1005p ps=1.34u w=0.15u l=0.13u
X667 VP 2Div$2_0.d_flip_flop$3$2_1.d MUX_8to1_0.in3 VP sg13_lv_pmos ad=0.1005p pd=1.34u as=55.5f ps=0.74u w=0.15u l=0.13u
X668 a_n5741_3085# 2Div$2_0.d_flip_flop$3$2_1.NAND_2in_nmosx2$3$2_0.a 2Div$2_0.d_flip_flop$3$2_1.NAND_2in_nmosx2$3$2_0.y gd sg13_lv_nmos ad=57f pd=0.68u as=0.102p ps=1.28u w=0.3u l=0.13u
X669 VP pdiv$3_0.passgate$3_1.A pdiv$3_0.div_with_reset$3$2_0.d_flip_flop_reset$1$2_1.NAND_2in_nmosx2$1$1$5_0.a VP sg13_lv_pmos ad=55.5f pd=0.74u as=55.5f ps=0.74u w=0.15u l=0.13u
X670 a_n2333_n2585# a2 a_n2435_n2585# gd sg13_lv_nmos ad=57f pd=0.68u as=57f ps=0.68u w=0.3u l=0.13u
X671 a_6346_1847# d1 gd gd sg13_lv_nmos ad=0.1005p pd=1.34u as=0.1005p ps=1.34u w=0.15u l=0.13u
X672 MUX_8to1_0.inverter_x4_ptap_mirror_fix$2$3_4.OUT MUX_8to1_0.in8 gd gd sg13_lv_nmos ad=0.204p pd=1.88u as=0.204p ps=1.88u w=0.6u l=0.13u
X673 gd pdiv$3_0.d_flip_flop_reset$2$2_0.d a_115_5656# gd sg13_lv_nmos ad=0.204p pd=1.88u as=0.114p ps=0.98u w=0.6u l=0.13u
X674 pdiv$3_0.div_with_reset$3$2_0.d_flip_flop_reset$1$2_0.q pdiv$3_0.count_data_check$2_0.c5 VP VP sg13_lv_pmos ad=57f pd=0.68u as=0.102p ps=1.28u w=0.3u l=0.13u
X675 2Div$2_0.d_flip_flop$3$2_3.NAND_3in_nmosx3$1$2_0.y MUX_8to1_0.in7 VP VP sg13_lv_pmos ad=55.5f pd=0.74u as=55.5f ps=0.74u w=0.15u l=0.13u
X676 a_n8121_469# 2Div$2_0.d_flip_flop$3$2_5.NAND_2in_nmosx2$3$2_0.a 2Div$2_0.d_flip_flop$3$2_5.NAND_2in_nmosx2$3$2_0.y gd sg13_lv_nmos ad=57f pd=0.68u as=0.102p ps=1.28u w=0.3u l=0.13u
X677 VP pdiv$3_0.div_with_reset$3$2_0.d_flip_flop_reset$1$2_3.NAND_2in_nmosx2$1$1$5_0.a pdiv$3_0.div_with_reset$3$2_0.d_flip_flop_reset$1$2_3.NAND_2in_nmosx2$1$1$5_0.y VP sg13_lv_pmos ad=0.102p pd=1.28u as=57f ps=0.68u w=0.3u l=0.13u
X678 gd pdiv$3_0.passgate$3_1.A a_4905_n2600# gd sg13_lv_nmos ad=0.114p pd=0.98u as=0.114p ps=0.98u w=0.6u l=0.13u
X679 a_n501_n2192# pdiv$3_0.div_with_reset$3$2_0.d_flip_flop_reset$1$2_1.NAND_2in_nmosx2$1$1$5_0.y pdiv$3_0.div_with_reset$3$2_0.d_flip_flop_reset$1$2_1.NAND_2in_nmosx2$1$1$5_0.b gd sg13_lv_nmos ad=0.114p pd=0.98u as=0.204p ps=1.88u w=0.6u l=0.13u
X680 VP pdiv$3_0.div_with_reset$3$2_0.d_flip_flop_reset$1$2_4.NAND_2in_nmosx2$1$1$5_0.a pdiv$3_0.div_with_reset$3$2_0.d_flip_flop_reset$1$2_4.NAND_2in_nmosx2$1$1$5_0.y VP sg13_lv_pmos ad=0.102p pd=1.28u as=57f ps=0.68u w=0.3u l=0.13u
X681 VP MUX_8to1_0.in6 2Div$2_0.d_flip_flop$3$2_4.NAND_2in_nmosx2$3$2_0.b VP sg13_lv_pmos ad=0.1005p pd=1.34u as=55.5f ps=0.74u w=0.15u l=0.13u
X682 a_6346_3133# d0 VP VP sg13_lv_pmos ad=0.1005p pd=1.34u as=0.1005p ps=1.34u w=0.15u l=0.13u
X683 a_n93_n2192# pdiv$3_0.div_with_reset$3$2_0.d_flip_flop_reset$1$2_1.clk a_n195_n2192# gd sg13_lv_nmos ad=0.114p pd=0.98u as=0.114p ps=0.98u w=0.6u l=0.13u
X684 pdiv$3_0.d_flip_flop_reset$2$2_0.d pdiv$3_0.d_flip_flop_reset$2$2_0.NAND_3in_nmosx3$1$2$3_1.a VP VP sg13_lv_pmos ad=55.5f pd=0.74u as=55.5f ps=0.74u w=0.15u l=0.13u
X685 gd MUX_8to1_0.in2 a_n5129_3085# gd sg13_lv_nmos ad=0.102p pd=1.28u as=57f ps=0.68u w=0.3u l=0.13u
X686 VP pdiv$3_0.div_with_reset$3$2_0.d_flip_flop_reset$1$2_2.clk pdiv$3_0.div_with_reset$3$2_0.d_flip_flop_reset$1$2_2.NAND_3in_nmosx3$1$1$3_1.a VP sg13_lv_pmos ad=55.5f pd=0.74u as=55.5f ps=0.74u w=0.15u l=0.13u
X687 VP pdiv$3_0.count_data_check$2_0.c4 pdiv$3_0.div_with_reset$3$2_0.d_flip_flop_reset$1$2_1.NAND_2in_nmosx2$1$1$5_0.a VP sg13_lv_pmos ad=55.5f pd=0.74u as=55.5f ps=0.74u w=0.15u l=0.13u
X688 a_5051_5701# d0 a_4949_5701# gd sg13_lv_nmos ad=57f pd=0.68u as=57f ps=0.68u w=0.3u l=0.13u
X689 VP pdiv$3_0.passgate$3_1.A pdiv$3_0.div_with_reset$3$2_0.d_flip_flop_reset$1$2_5.NAND_2in_nmosx2$1$1$5_0.b VP sg13_lv_pmos ad=55.5f pd=0.74u as=55.5f ps=0.74u w=0.15u l=0.13u
X690 a_7020_n2099# a_6702_n2099# gd gd sg13_lv_nmos ad=55.5f pd=0.74u as=0.1005p ps=1.34u w=0.15u l=0.13u
X691 VP 2Div$2_0.d_flip_flop$3$2_1.NAND_2in_nmosx2$3$2_0.b 2Div$2_0.d_flip_flop$3$2_1.NAND_3in_nmosx3$1$2_0.y VP sg13_lv_pmos ad=55.5f pd=0.74u as=0.1005p ps=1.34u w=0.15u l=0.13u
X692 MUX_8to1_0.passgate$1$2_6.in_n MUX_8to1_0.passgate$1$2_6.in_p VP VP sg13_lv_pmos ad=0.204p pd=1.88u as=0.204p ps=1.88u w=0.6u l=0.13u
X693 pdiv$3_0.count_data_check$2_0.c2 pdiv$3_0.div_with_reset$3$2_0.d_flip_flop_reset$1$2_2.clk a_2015_16# gd sg13_lv_nmos ad=0.204p pd=1.88u as=0.114p ps=0.98u w=0.6u l=0.13u
X694 a_n2333_3085# MUX_8to1_0.inverter_x4_ptap_mirror_fix$2$3_7.OUT a_n2435_3085# gd sg13_lv_nmos ad=57f pd=0.68u as=57f ps=0.68u w=0.3u l=0.13u
X695 a_n8121_n2147# 2Div$2_0.d_flip_flop$3$2_3.NAND_2in_nmosx2$3$2_0.a 2Div$2_0.d_flip_flop$3$2_3.NAND_2in_nmosx2$3$2_0.y gd sg13_lv_nmos ad=57f pd=0.68u as=0.102p ps=1.28u w=0.3u l=0.13u
X696 MUX_8to1_0.passgate$1$2_5.in_p a0 a_n2333_5263# gd sg13_lv_nmos ad=0.102p pd=1.28u as=57f ps=0.68u w=0.3u l=0.13u
X697 VP MUX_8to1_0.in2 2Div$2_0.d_flip_flop$3$2_1.NAND_2in_nmosx2$3$2_0.b VP sg13_lv_pmos ad=0.1005p pd=1.34u as=55.5f ps=0.74u w=0.15u l=0.13u
X698 MUX_8to1_0.in6 2Div$2_0.d_flip_flop$3$2_5.NAND_2in_nmosx2$3$2_0.b VP VP sg13_lv_pmos ad=55.5f pd=0.74u as=0.1005p ps=1.34u w=0.15u l=0.13u
X699 pdiv$3_0.div_with_reset$3$2_0.d_flip_flop_reset$1$2_0.NAND_2in_nmosx2$1$1$5_0.y pdiv$3_0.div_with_reset$3$2_0.d_flip_flop_reset$1$2_0.NAND_2in_nmosx2$1$1$5_0.b VP VP sg13_lv_pmos ad=57f pd=0.68u as=0.102p ps=1.28u w=0.3u l=0.13u
X700 a_3103_2632# pdiv$3_0.div_with_reset$3$2_0.d_flip_flop_reset$1$2_4.clk a_3001_2632# gd sg13_lv_nmos ad=0.114p pd=0.98u as=0.114p ps=0.98u w=0.6u l=0.13u
X701 VP pdiv$3_0.div_with_reset$3$2_0.d_flip_flop_reset$1$2_4.clk pdiv$3_0.count_data_check$2_0.c0 VP sg13_lv_pmos ad=55.5f pd=0.74u as=0.1005p ps=1.34u w=0.15u l=0.13u
X702 pdiv$3_0.count_data_check$2_0.c4 pdiv$3_0.div_with_reset$3$2_0.d_flip_flop_reset$1$2_0.clk VP VP sg13_lv_pmos ad=0.1005p pd=1.34u as=55.5f ps=0.74u w=0.15u l=0.13u
X703 VP pdiv$3_0.count_data_check$2_0.c5 pdiv$3_0.div_with_reset$3$2_0.d_flip_flop_reset$1$2_0.NAND_2in_nmosx2$1$1$5_0.a VP sg13_lv_pmos ad=55.5f pd=0.74u as=55.5f ps=0.74u w=0.15u l=0.13u
X704 gd pdiv$3_0.passgate$3_1.A a_2797_3040# gd sg13_lv_nmos ad=0.114p pd=0.98u as=0.114p ps=0.98u w=0.6u l=0.13u
X705 a_1345_424# pdiv$3_0.count_data_check$2_0.c2 gd gd sg13_lv_nmos ad=0.114p pd=0.98u as=0.204p ps=1.88u w=0.6u l=0.13u
X706 pdiv$3_0.passgate$3_1.B pdiv$3_0.passgate$3_1.in_n MUX_8to1_0.out VP sg13_lv_pmos ad=0.102p pd=1.28u as=0.102p ps=1.28u w=0.3u l=0.15u
X707 2Div$2_0.d_flip_flop$3$2_0.NAND_3in_nmosx3$1$2_0.y MUX_8to1_0.in3 VP VP sg13_lv_pmos ad=55.5f pd=0.74u as=55.5f ps=0.74u w=0.15u l=0.13u
X708 MUX_8to1_0.passgate$1$2_0.B MUX_8to1_0.passgate$1$2_3.in_n MUX_8to1_0.inverter_x4_ptap_mirror_fix$2$3_8.OUT gd sg13_lv_nmos ad=0.102p pd=1.28u as=0.102p ps=1.28u w=0.3u l=0.15u
X709 pdiv$3_0.div_with_reset$3$2_0.d_flip_flop_reset$1$2_4.NAND_2in_nmosx2$1$1$5_0.b pdiv$3_0.div_with_reset$3$2_0.d_flip_flop_reset$1$2_4.clk VP VP sg13_lv_pmos ad=55.5f pd=0.74u as=55.5f ps=0.74u w=0.15u l=0.13u
X710 VP pdiv$3_0.div_with_reset$3$2_0.d_flip_flop_reset$1$2_3.NAND_2in_nmosx2$1$1$5_0.b pdiv$3_0.div_with_reset$3$2_0.d_flip_flop_reset$1$2_2.clk VP sg13_lv_pmos ad=0.102p pd=1.28u as=57f ps=0.68u w=0.3u l=0.13u
X711 gd 2Div$2_0.d_flip_flop$3$2_5.NAND_3in_nmosx3$1$2_0.y a_n9141_31# gd sg13_lv_nmos ad=0.102p pd=1.28u as=57f ps=0.68u w=0.3u l=0.13u
X712 VP pdiv$3_0.div_with_reset$3$2_0.d_flip_flop_reset$1$2_3.NAND_2in_nmosx2$1$1$5_0.y pdiv$3_0.div_with_reset$3$2_0.d_flip_flop_reset$1$2_3.NAND_2in_nmosx2$1$1$5_0.b VP sg13_lv_pmos ad=55.5f pd=0.74u as=0.1005p ps=1.34u w=0.15u l=0.13u
X713 pdiv$3_0.d_flip_flop_reset$2$2_0.d out_div a_n147_5248# gd sg13_lv_nmos ad=0.204p pd=1.88u as=0.114p ps=0.98u w=0.6u l=0.13u
X714 VP pdiv$3_0.passgate$3_1.A pdiv$3_0.div_with_reset$3$2_0.d_flip_flop_reset$1$2_5.NAND_2in_nmosx2$1$1$5_0.a VP sg13_lv_pmos ad=55.5f pd=0.74u as=55.5f ps=0.74u w=0.15u l=0.13u
X715 VP pdiv$3_0.div_with_reset$3$2_0.d_flip_flop_reset$1$2_2.NAND_2in_nmosx2$1$1$5_0.b pdiv$3_0.div_with_reset$3$2_0.d_flip_flop_reset$1$2_1.clk VP sg13_lv_pmos ad=0.102p pd=1.28u as=57f ps=0.68u w=0.3u l=0.13u
X716 a_n2333_31# a2 a_n2435_31# gd sg13_lv_nmos ad=57f pd=0.68u as=57f ps=0.68u w=0.3u l=0.13u
X717 pdiv$3_0.div_with_reset$3$2_0.d_flip_flop_reset$1$2_1.clk pdiv$3_0.div_with_reset$3$2_0.d_flip_flop_reset$1$2_2.NAND_2in_nmosx2$1$1$5_0.b a_4541_424# gd sg13_lv_nmos ad=0.204p pd=1.88u as=0.114p ps=0.98u w=0.6u l=0.13u
X718 VP 2Div$2_0.d_flip_flop$3$2_1.NAND_3in_nmosx3$1$2_0.y 2Div$2_0.d_flip_flop$3$2_1.d VP sg13_lv_pmos ad=0.1005p pd=1.34u as=55.5f ps=0.74u w=0.15u l=0.13u
X719 pdiv$3_0.div_with_reset$3$2_0.d_flip_flop_reset$1$2_2.clk pdiv$3_0.div_with_reset$3$2_0.d_flip_flop_reset$1$2_3.NAND_2in_nmosx2$1$1$5_0.b a_1345_424# gd sg13_lv_nmos ad=0.204p pd=1.88u as=0.114p ps=0.98u w=0.6u l=0.13u
X720 VP 2Div$2_0.d_flip_flop$3$2_2.NAND_2in_nmosx2$3$2_0.a 2Div$2_0.d_flip_flop$3$2_2.NAND_3in_nmosx3$1$2_0.y VP sg13_lv_pmos ad=0.1005p pd=1.34u as=55.5f ps=0.74u w=0.15u l=0.13u
X721 VP pdiv$3_0.div_with_reset$3$2_0.d_flip_flop_reset$1$2_5.NAND_2in_nmosx2$1$1$5_0.b pdiv$3_0.div_with_reset$3$2_0.d_flip_flop_reset$1$2_5.NAND_3in_nmosx3$1$1$3_1.a VP sg13_lv_pmos ad=55.5f pd=0.74u as=0.1005p ps=1.34u w=0.15u l=0.13u
X722 a_6702_n3385# pdiv$3_0.count_data_check$2_0.c5 gd gd sg13_lv_nmos ad=0.1005p pd=1.34u as=0.1005p ps=1.34u w=0.15u l=0.13u
X723 gd pdiv$3_0.passgate$3_1.A a_1709_n2600# gd sg13_lv_nmos ad=0.114p pd=0.98u as=0.114p ps=0.98u w=0.6u l=0.13u
X724 a_n2435_n2585# a1 gd gd sg13_lv_nmos ad=57f pd=0.68u as=0.102p ps=1.28u w=0.3u l=0.13u
X725 pdiv$3_0.count_data_check$2_0.c0 pdiv$3_0.div_with_reset$3$2_0.d_flip_flop_reset$1$2_4.clk a_2015_2632# gd sg13_lv_nmos ad=0.204p pd=1.88u as=0.114p ps=0.98u w=0.6u l=0.13u
X726 pdiv$3_0.inverter_x8$3_0.IN pdiv$3_0.count_data_check$2_0.NAND_3in$2_0/NAND_3in_nmosx3$5$1$2_0.y gd gd sg13_lv_nmos ad=0.102p pd=1.28u as=57f ps=0.68u w=0.3u l=0.15u
X727 a_n5741_n2147# 2Div$2_0.d_flip_flop$3$2_4.NAND_2in_nmosx2$3$2_0.a 2Div$2_0.d_flip_flop$3$2_4.NAND_2in_nmosx2$3$2_0.y gd sg13_lv_nmos ad=57f pd=0.68u as=0.102p ps=1.28u w=0.3u l=0.13u
X728 gd MUX_8to1_0.in4 a_n5129_469# gd sg13_lv_nmos ad=0.102p pd=1.28u as=57f ps=0.68u w=0.3u l=0.13u
X729 pdiv$3_0.count_data_check$2_0.c1 pdiv$3_0.div_with_reset$3$2_0.d_flip_flop_reset$1$2_3.clk a_5211_2632# gd sg13_lv_nmos ad=0.204p pd=1.88u as=0.114p ps=0.98u w=0.6u l=0.13u
X730 pdiv$3_0.div_with_reset$3$2_0.d_flip_flop_reset$1$2_2.NAND_2in_nmosx2$1$1$5_0.b pdiv$3_0.passgate$3_1.A VP VP sg13_lv_pmos ad=55.5f pd=0.74u as=55.5f ps=0.74u w=0.15u l=0.13u
X731 MUX_8to1_0.out MUX_8to1_0.passgate$1$2_0.B VP VP sg13_lv_pmos ad=0.204p pd=1.88u as=0.204p ps=1.88u w=0.6u l=0.13u
X732 pdiv$3_0.div_with_reset$3$2_0.d_flip_flop_reset$1$2_5.NAND_2in_nmosx2$1$1$5_0.y pdiv$3_0.div_with_reset$3$2_0.d_flip_flop_reset$1$2_5.NAND_2in_nmosx2$1$1$5_0.a a_597_3040# gd sg13_lv_nmos ad=0.204p pd=1.88u as=0.114p ps=0.98u w=0.6u l=0.13u
X733 a_4803_16# pdiv$3_0.div_with_reset$3$2_0.d_flip_flop_reset$1$2_1.clk pdiv$3_0.count_data_check$2_0.c3 gd sg13_lv_nmos ad=0.114p pd=0.98u as=0.204p ps=1.88u w=0.6u l=0.13u
X734 gd 2Div$2_0.d_flip_flop$3$2_3.NAND_3in_nmosx3$1$2_0.y a_n9141_n2585# gd sg13_lv_nmos ad=0.102p pd=1.28u as=57f ps=0.68u w=0.3u l=0.13u
X735 pdiv$3_0.div_with_reset$3$2_0.d_flip_flop_reset$1$2_4.NAND_3in_nmosx3$1$1$3_1.a pdiv$3_0.div_with_reset$3$2_0.d_flip_flop_reset$1$2_4.NAND_2in_nmosx2$1$1$5_0.a VP VP sg13_lv_pmos ad=55.5f pd=0.74u as=55.5f ps=0.74u w=0.15u l=0.13u
X736 MUX_8to1_0.passgate$1$2_7.A MUX_8to1_0.in4 gd gd sg13_lv_nmos ad=0.204p pd=1.88u as=0.204p ps=1.88u w=0.6u l=0.13u
X737 pdiv$3_0.count_data_check$2_0.c1 pdiv$3_0.div_with_reset$3$2_0.d_flip_flop_reset$1$2_3.clk VP VP sg13_lv_pmos ad=0.1005p pd=1.34u as=55.5f ps=0.74u w=0.15u l=0.13u
X738 a_n195_n2192# pdiv$3_0.passgate$3_1.A gd gd sg13_lv_nmos ad=0.114p pd=0.98u as=0.114p ps=0.98u w=0.6u l=0.13u
X739 a_927_16# pdiv$3_0.count_data_check$2_0.c2 a_825_16# gd sg13_lv_nmos ad=0.114p pd=0.98u as=0.114p ps=0.98u w=0.6u l=0.13u
X740 MUX_8to1_0.passgate$1$2_5.in_p MUX_8to1_0.inverter_x4_ptap_mirror_fix$2$3_6.OUT VP VP sg13_lv_pmos ad=55.5f pd=0.74u as=0.1005p ps=1.34u w=0.15u l=0.13u
X741 VP pdiv$3_0.count_data_check$2_0.c3 pdiv$3_0.div_with_reset$3$2_0.d_flip_flop_reset$1$2_2.NAND_2in_nmosx2$1$1$5_0.a VP sg13_lv_pmos ad=55.5f pd=0.74u as=55.5f ps=0.74u w=0.15u l=0.13u
X742 a_7018_3874# d0 VP VP sg13_lv_pmos ad=0.114p pd=0.98u as=0.204p ps=1.88u w=0.6u l=0.13u
X743 2Div$2_0.d_flip_flop$3$2_3.d MUX_8to1_0.in8 VP VP sg13_lv_pmos ad=55.5f pd=0.74u as=0.1005p ps=1.34u w=0.15u l=0.13u
X744 2Div$2_0.d_flip_flop$3$2_6.d MUX_8to1_0.in5 VP VP sg13_lv_pmos ad=55.5f pd=0.74u as=0.1005p ps=1.34u w=0.15u l=0.13u
X745 pdiv$3_0.passgate$3_1.in_n pdiv$3_0.passgate$3_1.in_p VP VP sg13_lv_pmos ad=0.204p pd=1.88u as=0.204p ps=1.88u w=0.6u l=0.13u
X746 a_7459_5701# pdiv$3_0.count_data_check$2_0.XNOR$1$2_1.y a_7357_5701# gd sg13_lv_nmos ad=57f pd=0.68u as=57f ps=0.68u w=0.3u l=0.13u
X747 a_n6013_2647# 2Div$2_0.d_flip_flop$3$2_1.NAND_3in_nmosx3$1$2_0.y 2Div$2_0.d_flip_flop$3$2_1.NAND_2in_nmosx2$3$2_0.a gd sg13_lv_nmos ad=57f pd=0.68u as=0.102p ps=1.28u w=0.3u l=0.13u
X748 pdiv$3_0.div_with_reset$3$2_0.d_flip_flop_reset$1$2_1.NAND_2in_nmosx2$1$1$5_0.b pdiv$3_0.div_with_reset$3$2_0.d_flip_flop_reset$1$2_1.clk VP VP sg13_lv_pmos ad=55.5f pd=0.74u as=55.5f ps=0.74u w=0.15u l=0.13u
X749 MUX_8to1_0.passgate$1$2_0.B MUX_8to1_0.passgate$1$2_7.in_p MUX_8to1_0.passgate$1$2_7.A VP sg13_lv_pmos ad=0.102p pd=1.28u as=0.102p ps=1.28u w=0.3u l=0.15u
X750 a_n5259_31# 2Div$2_0.d_flip_flop$3$2_6.NAND_2in_nmosx2$3$2_0.b 2Div$2_0.d_flip_flop$3$2_6.NAND_3in_nmosx3$1$2_0.y gd sg13_lv_nmos ad=57f pd=0.68u as=0.102p ps=1.28u w=0.3u l=0.13u
X751 VP pdiv$3_0.d_flip_flop_reset$2$2_0.NAND_2in_nmosx2$1$2$2_0.b pdiv$3_0.d_flip_flop_reset$2$2_0.NAND_3in_nmosx3$1$2$3_1.a VP sg13_lv_pmos ad=55.5f pd=0.74u as=0.1005p ps=1.34u w=0.15u l=0.13u
X752 VP pdiv$3_0.count_data_check$2_0.XNOR$1$2_3.y pdiv$3_0.count_data_check$2_0.NAND_3in$2_0/NAND_3in_nmosx3$5$1$2_0.y VP sg13_lv_pmos ad=55.5f pd=0.74u as=55.5f ps=0.74u w=0.15u l=0.13u
X753 VP pdiv$3_0.div_with_reset$3$2_0.d_flip_flop_reset$1$2_0.NAND_2in_nmosx2$1$1$5_0.a pdiv$3_0.div_with_reset$3$2_0.d_flip_flop_reset$1$2_0.NAND_2in_nmosx2$1$1$5_0.y VP sg13_lv_pmos ad=0.102p pd=1.28u as=57f ps=0.68u w=0.3u l=0.13u
X754 VP MUX_8to1_0.in7 2Div$2_0.d_flip_flop$3$2_3.NAND_2in_nmosx2$3$2_0.b VP sg13_lv_pmos ad=0.1005p pd=1.34u as=55.5f ps=0.74u w=0.15u l=0.13u
X755 a_621_n2600# pdiv$3_0.count_data_check$2_0.c4 a_519_n2600# gd sg13_lv_nmos ad=0.114p pd=0.98u as=0.114p ps=0.98u w=0.6u l=0.13u
X756 VP pdiv$3_0.div_with_reset$3$2_0.d_flip_flop_reset$1$2_3.NAND_3in_nmosx3$1$1$3_1.a pdiv$3_0.div_with_reset$3$2_0.d_flip_flop_reset$1$2_3.NAND_2in_nmosx2$1$1$5_0.a VP sg13_lv_pmos ad=55.5f pd=0.74u as=0.1005p ps=1.34u w=0.15u l=0.13u
X757 a_n6421_5701# 2Div$2_0.d_flip_flop$3$2_2.NAND_2in_nmosx2$3$2_0.b MUX_8to1_0.in2 gd sg13_lv_nmos ad=57f pd=0.68u as=0.102p ps=1.28u w=0.3u l=0.13u
X758 a_3001_n2600# pdiv$3_0.div_with_reset$3$2_0.d_flip_flop_reset$1$2_0.NAND_2in_nmosx2$1$1$5_0.a gd gd sg13_lv_nmos ad=0.114p pd=0.98u as=0.114p ps=0.98u w=0.6u l=0.13u
X759 pdiv$3_0.div_with_reset$3$2_0.d_flip_flop_reset$1$2_0.NAND_2in_nmosx2$1$1$5_0.a pdiv$3_0.div_with_reset$3$2_0.d_flip_flop_reset$1$2_0.NAND_3in_nmosx3$1$1$3_1.a a_4123_n2600# gd sg13_lv_nmos ad=0.204p pd=1.88u as=0.114p ps=0.98u w=0.6u l=0.13u
X760 a_6702_n2099# pdiv$3_0.count_data_check$2_0.c4 VP VP sg13_lv_pmos ad=0.1005p pd=1.34u as=0.1005p ps=1.34u w=0.15u l=0.13u
X761 MUX_8to1_0.passgate$1$2_3.in_p MUX_8to1_0.inverter_x4_ptap_mirror_fix$2$3_6.OUT VP VP sg13_lv_pmos ad=55.5f pd=0.74u as=0.1005p ps=1.34u w=0.15u l=0.13u
X762 MUX_8to1_0.inverter_x4_ptap_mirror_fix$2$3_7.OUT a2 gd gd sg13_lv_nmos ad=0.204p pd=1.88u as=0.204p ps=1.88u w=0.6u l=0.13u
X763 VP pdiv$3_0.count_data_check$2_0.c2 pdiv$3_0.div_with_reset$3$2_0.d_flip_flop_reset$1$2_3.NAND_2in_nmosx2$1$1$5_0.a VP sg13_lv_pmos ad=55.5f pd=0.74u as=55.5f ps=0.74u w=0.15u l=0.13u
X764 VP pdiv$3_0.div_with_reset$3$2_0.d_flip_flop_reset$1$2_3.NAND_2in_nmosx2$1$1$5_0.a pdiv$3_0.div_with_reset$3$2_0.d_flip_flop_reset$1$2_3.NAND_3in_nmosx3$1$1$3_1.a VP sg13_lv_pmos ad=55.5f pd=0.74u as=55.5f ps=0.74u w=0.15u l=0.13u
X765 a_7020_517# a_6702_517# gd gd sg13_lv_nmos ad=55.5f pd=0.74u as=0.1005p ps=1.34u w=0.15u l=0.13u
X766 gd pdiv$3_0.d_flip_flop_reset$2$2_0.NAND_2in_nmosx2$1$2$2_0.a a_1655_5248# gd sg13_lv_nmos ad=0.114p pd=0.98u as=0.114p ps=0.98u w=0.6u l=0.13u
X767 pdiv$3_0.div_with_reset$3$2_0.d_flip_flop_reset$1$2_4.clk pdiv$3_0.div_with_reset$3$2_0.d_flip_flop_reset$1$2_5.NAND_2in_nmosx2$1$1$5_0.b a_1345_3040# gd sg13_lv_nmos ad=0.204p pd=1.88u as=0.114p ps=0.98u w=0.6u l=0.13u
X768 gd 2Div$2_0.d_flip_flop$3$2_4.NAND_3in_nmosx3$1$2_0.y a_n6761_n2585# gd sg13_lv_nmos ad=0.102p pd=1.28u as=57f ps=0.68u w=0.3u l=0.13u
X769 VP pdiv$3_0.count_data_check$2_0.XNOR$1$2_1.y pdiv$3_0.count_data_check$2_0.NAND_3in$2_1/NAND_3in_nmosx3$5$1$2_0.y VP sg13_lv_pmos ad=55.5f pd=0.74u as=55.5f ps=0.74u w=0.15u l=0.13u
X770 a_n7639_31# 2Div$2_0.d_flip_flop$3$2_5.NAND_2in_nmosx2$3$2_0.b 2Div$2_0.d_flip_flop$3$2_5.NAND_3in_nmosx3$1$2_0.y gd sg13_lv_nmos ad=57f pd=0.68u as=0.102p ps=1.28u w=0.3u l=0.13u
X771 pdiv$3_0.div_with_reset$3$2_0.d_flip_flop_reset$1$2_4.NAND_2in_nmosx2$1$1$5_0.b pdiv$3_0.div_with_reset$3$2_0.d_flip_flop_reset$1$2_4.NAND_2in_nmosx2$1$1$5_0.y a_3103_3040# gd sg13_lv_nmos ad=0.204p pd=1.88u as=0.114p ps=0.98u w=0.6u l=0.13u
X772 pdiv$3_0.div_with_reset$3$2_0.d_flip_flop_reset$1$2_3.clk pdiv$3_0.div_with_reset$3$2_0.d_flip_flop_reset$1$2_4.NAND_2in_nmosx2$1$1$5_0.b a_4541_3040# gd sg13_lv_nmos ad=0.204p pd=1.88u as=0.114p ps=0.98u w=0.6u l=0.13u
X773 VP pdiv$3_0.div_with_reset$3$2_0.d_flip_flop_reset$1$2_5.NAND_2in_nmosx2$1$1$5_0.a pdiv$3_0.div_with_reset$3$2_0.d_flip_flop_reset$1$2_5.NAND_2in_nmosx2$1$1$5_0.y VP sg13_lv_pmos ad=0.102p pd=1.28u as=57f ps=0.68u w=0.3u l=0.13u
X774 pdiv$3_0.count_data_check$2_0.XNOR$1$2_1.y d0 a_7020_3133# gd sg13_lv_nmos ad=0.1005p pd=1.34u as=55.5f ps=0.74u w=0.15u l=0.13u
X775 a_927_2632# pdiv$3_0.count_data_check$2_0.c0 a_825_2632# gd sg13_lv_nmos ad=0.114p pd=0.98u as=0.114p ps=0.98u w=0.6u l=0.13u
X776 VP pdiv$3_0.div_with_reset$3$2_0.d_flip_flop_reset$1$2_1.NAND_2in_nmosx2$1$1$5_0.b pdiv$3_0.div_with_reset$3$2_0.d_flip_flop_reset$1$2_0.clk VP sg13_lv_pmos ad=0.102p pd=1.28u as=57f ps=0.68u w=0.3u l=0.13u
X777 pdiv$3_0.d_flip_flop_reset$2$2_0.NAND_3in_nmosx3$1$2$3_1.a pdiv$3_0.d_flip_flop_reset$2$2_0.NAND_2in_nmosx2$1$2$2_0.b VP VP sg13_lv_pmos ad=0.1005p pd=1.34u as=55.5f ps=0.74u w=0.15u l=0.13u
X778 a_n501_2632# pdiv$3_0.div_with_reset$3$2_0.d_flip_flop_reset$1$2_5.NAND_2in_nmosx2$1$1$5_0.b pdiv$3_0.div_with_reset$3$2_0.d_flip_flop_reset$1$2_5.NAND_3in_nmosx3$1$1$3_1.a gd sg13_lv_nmos ad=0.114p pd=0.98u as=0.204p ps=1.88u w=0.6u l=0.13u
X779 a_7428_n2603# a_6346_n3385# pdiv$3_0.count_data_check$2_0.XNOR$1$2_3.y gd sg13_lv_nmos ad=55.5f pd=0.74u as=0.1005p ps=1.34u w=0.15u l=0.13u
X780 2Div$2_0.d_flip_flop$3$2_4.d MUX_8to1_0.in7 VP VP sg13_lv_pmos ad=55.5f pd=0.74u as=0.1005p ps=1.34u w=0.15u l=0.13u
X781 a_927_n2600# pdiv$3_0.count_data_check$2_0.c4 a_825_n2600# gd sg13_lv_nmos ad=0.114p pd=0.98u as=0.114p ps=0.98u w=0.6u l=0.13u
X782 pdiv$3_0.count_data_check$2_0.c4 pdiv$3_0.passgate$3_1.A VP VP sg13_lv_pmos ad=55.5f pd=0.74u as=55.5f ps=0.74u w=0.15u l=0.13u
X783 pdiv$3_0.div_with_reset$3$2_0.d_flip_flop_reset$1$2_2.NAND_3in_nmosx3$1$1$3_1.a pdiv$3_0.div_with_reset$3$2_0.d_flip_flop_reset$1$2_2.clk VP VP sg13_lv_pmos ad=55.5f pd=0.74u as=55.5f ps=0.74u w=0.15u l=0.13u
X784 MUX_8to1_0.passgate$1$2_5.A MUX_8to1_0.in2 VP VP sg13_lv_pmos ad=0.204p pd=1.88u as=0.204p ps=1.88u w=0.6u l=0.13u
X785 a_n2333_2647# MUX_8to1_0.inverter_x4_ptap_mirror_fix$2$3_7.OUT a_n2435_2647# gd sg13_lv_nmos ad=57f pd=0.68u as=57f ps=0.68u w=0.3u l=0.13u
X786 VP pdiv$3_0.passgate$3_1.A pdiv$3_0.div_with_reset$3$2_0.d_flip_flop_reset$1$2_2.NAND_2in_nmosx2$1$1$5_0.a VP sg13_lv_pmos ad=55.5f pd=0.74u as=55.5f ps=0.74u w=0.15u l=0.13u
X787 a_n5129_469# 2Div$2_0.d_flip_flop$3$2_6.NAND_2in_nmosx2$3$2_0.y 2Div$2_0.d_flip_flop$3$2_6.NAND_2in_nmosx2$3$2_0.b gd sg13_lv_nmos ad=57f pd=0.68u as=0.102p ps=1.28u w=0.3u l=0.13u
X788 pdiv$3_0.div_with_reset$3$2_0.d_flip_flop_reset$1$2_0.NAND_2in_nmosx2$1$1$5_0.b pdiv$3_0.div_with_reset$3$2_0.d_flip_flop_reset$1$2_0.NAND_2in_nmosx2$1$1$5_0.y a_3103_n2192# gd sg13_lv_nmos ad=0.204p pd=1.88u as=0.114p ps=0.98u w=0.6u l=0.13u
X789 a_n5157_5263# clk a_n5259_5263# gd sg13_lv_nmos ad=57f pd=0.68u as=57f ps=0.68u w=0.3u l=0.13u
X790 a_519_2632# pdiv$3_0.div_with_reset$3$2_0.d_flip_flop_reset$1$2_5.NAND_3in_nmosx3$1$1$3_1.a pdiv$3_0.div_with_reset$3$2_0.d_flip_flop_reset$1$2_5.NAND_2in_nmosx2$1$1$5_0.a gd sg13_lv_nmos ad=0.114p pd=0.98u as=0.204p ps=1.88u w=0.6u l=0.13u
X791 VP pdiv$3_0.div_with_reset$3$2_0.d_flip_flop_reset$1$2_0.NAND_2in_nmosx2$1$1$5_0.y pdiv$3_0.div_with_reset$3$2_0.d_flip_flop_reset$1$2_0.NAND_2in_nmosx2$1$1$5_0.b VP sg13_lv_pmos ad=55.5f pd=0.74u as=0.1005p ps=1.34u w=0.15u l=0.13u
C0 a_7434_n1358# VP 0.09529f
C1 pdiv$3_0.div_with_reset$3$2_0.d_flip_flop_reset$1$2_5.NAND_2in_nmosx2$1$1$5_0.b a_n501_3040# 0.09919f
C2 pdiv$3_0.count_data_check$2_0.c2 a_1607_16# 0.09933f
C3 2Div$2_0.d_flip_flop$3$2_2.NAND_2in_nmosx2$3$2_0.a VP 0.13958f
C4 pdiv$3_0.div_with_reset$3$2_0.d_flip_flop_reset$1$2_3.NAND_3in_nmosx3$1$1$3_1.a a_n399_16# 0.01716f
C5 VP d0 0.07396f
C6 a_6702_3133# VP 0.54572f
C7 pdiv$3_0.div_with_reset$3$2_0.d_flip_flop_reset$1$2_1.NAND_2in_nmosx2$1$1$5_0.y a_597_n2192# 0.1016f
C8 pdiv$3_0.div_with_reset$3$2_0.d_flip_flop_reset$1$2_3.NAND_2in_nmosx2$1$1$5_0.b pdiv$3_0.div_with_reset$3$2_0.d_flip_flop_reset$1$2_2.clk 0.13764f
C9 MUX_8to1_0.passgate$1$2_1.in_n MUX_8to1_0.passgate$1$2_0.in_n 0.01252f
C10 MUX_8to1_0.inverter_x4_ptap_mirror_fix$2$3_10.OUT MUX_8to1_0.passgate$1$2_5.in_p 0.41079f
C11 pdiv$3_0.count_data_check$2_0.c0 pdiv$3_0.div_with_reset$3$2_0.d_flip_flop_reset$1$2_5.NAND_2in_nmosx2$1$1$5_0.b 1.22588f
C12 pdiv$3_0.div_with_reset$3$2_0.d_flip_flop_reset$1$2_0.NAND_2in_nmosx2$1$1$5_0.b pdiv$3_0.div_with_reset$3$2_0.d_flip_flop_reset$1$2_0.NAND_2in_nmosx2$1$1$5_0.y 1.24916f
C13 MUX_8to1_0.passgate$1$2_0.B pdiv$3_0.div_with_reset$3$2_0.d_flip_flop_reset$1$2_3.clk 0.3f
C14 pdiv$3_0.div_with_reset$3$2_0.d_flip_flop_reset$1$2_2.NAND_3in_nmosx3$1$1$3_1.a a_2797_16# 0.01716f
C15 pdiv$3_0.d_flip_flop_reset$2$2_0.reset pdiv$3_0.d_flip_flop_reset$2$2_0.NAND_3in_nmosx3$1$2$3_1.a 1.92187f
C16 pdiv$3_0.count_data_check$2_0.NAND_3in$2_1/NAND_3in_nmosx3$5$1$2_0.y VP 0.67814f
C17 pdiv$3_0.passgate$3_1.A pdiv$3_0.div_with_reset$3$2_0.d_flip_flop_reset$1$2_4.clk 2.87567f
C18 pdiv$3_0.count_data_check$2_0.XNOR$1$2_3.y VP 0.1648f
C19 MUX_8to1_0.passgate$1$2_0.B MUX_8to1_0.passgate$1$2_0.in_p 0.05707f
C20 pdiv$3_0.div_with_reset$3$2_0.d_flip_flop_reset$1$2_1.NAND_3in_nmosx3$1$1$3_1.a a_n501_n2600# 0.09877f
C21 MUX_8to1_0.in8 VP 0.14165f
C22 pdiv$3_0.d_flip_flop_reset$2$2_0.NAND_2in_nmosx2$1$2$2_0.b MUX_8to1_0.out 0.43012f
C23 pdiv$3_0.div_with_reset$3$2_0.d_flip_flop_reset$1$2_5.NAND_2in_nmosx2$1$1$5_0.b pdiv$3_0.div_with_reset$3$2_0.d_flip_flop_reset$1$2_5.NAND_3in_nmosx3$1$1$3_1.a 0.80223f
C24 pdiv$3_0.div_with_reset$3$2_0.d_flip_flop_reset$1$2_4.NAND_2in_nmosx2$1$1$5_0.y pdiv$3_0.div_with_reset$3$2_0.d_flip_flop_reset$1$2_3.clk 0.05584f
C25 pdiv$3_0.count_data_check$2_0.c0 a_6702_3133# 1.14927f
C26 MUX_8to1_0.in7 VP 1.61624f
C27 pdiv$3_0.count_data_check$2_0.XNOR$1$2_0.y d4 0.09351f
C28 a_6346_517# a_7434_1258# 0.01178f
C29 2Div$2_0.d_flip_flop$3$2_3.d 2Div$2_0.d_flip_flop$3$2_3.NAND_2in_nmosx2$3$2_0.y 0.12448f
C30 MUX_8to1_0.in5 2Div$2_0.d_flip_flop$3$2_5.NAND_2in_nmosx2$3$2_0.y 0.59561f
C31 pdiv$3_0.div_with_reset$3$2_0.d_flip_flop_reset$1$2_0.NAND_3in_nmosx3$1$1$3_1.a a_2695_n2600# 0.09877f
C32 MUX_8to1_0.passgate$1$2_5.in_n VP 0.22257f
C33 MUX_8to1_0.inverter_x4_ptap_mirror_fix$2$3_7.OUT VP 0.3065f
C34 MUX_8to1_0.inverter_x4_ptap_mirror_fix$2$3_5.OUT MUX_8to1_0.passgate$1$2_4.in_p 0.24665f
C35 MUX_8to1_0.passgate$1$2_0.in_p a1 0.24582f
C36 MUX_8to1_0.in5 VP 1.62093f
C37 pdiv$3_0.NOR_2in$3$2_0.A d3 0.15136f
C38 pdiv$3_0.div_with_reset$3$2_0.d_flip_flop_reset$1$2_5.NAND_2in_nmosx2$1$1$5_0.a pdiv$3_0.div_with_reset$3$2_0.d_flip_flop_reset$1$2_4.clk 0.02043f
C39 a_1913_n2600# a_2015_n2600# 0.09808f
C40 pdiv$3_0.count_data_check$2_0.XNOR$1$2_1.y VP 0.16507f
C41 2Div$2_0.d_flip_flop$3$2_3.NAND_2in_nmosx2$3$2_0.a a_n8393_n2585# 0.09722f
C42 2Div$2_0.d_flip_flop$3$2_1.NAND_3in_nmosx3$1$2_0.y MUX_8to1_0.in2 0.17688f
C43 pdiv$3_0.count_data_check$2_0.c5 a_6346_n3385# 1.05365f
C44 pdiv$3_0.count_data_check$2_0.XNOR$1$2_3.y pdiv$3_0.count_data_check$2_0.c5 0.369f
C45 pdiv$3_0.div_with_reset$3$2_0.d_flip_flop_reset$1$2_0.NAND_2in_nmosx2$1$1$5_0.a a_4123_n2600# 0.10914f
C46 pdiv$3_0.count_data_check$2_0.XNOR$1$2_2.y a_6346_3133# 0.05885f
C47 pdiv$3_0.div_with_reset$3$2_0.d_flip_flop_reset$1$2_3.NAND_2in_nmosx2$1$1$5_0.y VP 0.58789f
C48 2Div$2_0.d_flip_flop$3$2_1.NAND_2in_nmosx2$3$2_0.y MUX_8to1_0.in2 0.60963f
C49 MUX_8to1_0.passgate$1$2_5.in_n a0 0.01619f
C50 MUX_8to1_0.passgate$1$2_0.in_p MUX_8to1_0.passgate$1$2_2.in_p 0.03022f
C51 pdiv$3_0.count_data_check$2_0.XNOR$1$2_0.y a_6702_n769# 0.01901f
C52 pdiv$3_0.div_with_reset$3$2_0.d_flip_flop_reset$1$2_1.clk a_4541_424# 0.10178f
C53 2Div$2_0.d_flip_flop$3$2_1.NAND_2in_nmosx2$3$2_0.b MUX_8to1_0.in2 1.51059f
C54 MUX_8to1_0.inverter_x4_ptap_mirror_fix$2$3_8.OUT clk 0.1842f
C55 pdiv$3_0.d_flip_flop_reset$2$2_0.d VP 1.11404f
C56 pdiv$3_0.passgate$3_1.A pdiv$3_0.count_data_check$2_0.c2 2.54524f
C57 2Div$2_0.d_flip_flop$3$2_3.d 2Div$2_0.d_flip_flop$3$2_3.NAND_3in_nmosx3$1$2_0.y 1.35806f
C58 MUX_8to1_0.inverter_x4_ptap_mirror_fix$2$3_5.OUT VP 0.1634f
C59 MUX_8to1_0.passgate$1$2_1.A MUX_8to1_0.passgate$1$2_6.in_n 0.13718f
C60 2Div$2_0.d_flip_flop$3$2_4.d VP 0.57169f
C61 MUX_8to1_0.inverter_x4_ptap_mirror_fix$2$3_5.OUT MUX_8to1_0.in6 0.08964f
C62 MUX_8to1_0.in4 2Div$2_0.d_flip_flop$3$2_0.NAND_2in_nmosx2$3$2_0.a 0.14593f
C63 2Div$2_0.d_flip_flop$3$2_1.NAND_2in_nmosx2$3$2_0.a 2Div$2_0.d_flip_flop$3$2_1.NAND_3in_nmosx3$1$2_0.y 1.19863f
C64 a_1913_16# a_2015_16# 0.09808f
C65 pdiv$3_0.d_flip_flop_reset$2$2_0.NAND_2in_nmosx2$1$2$2_0.b VP 1.26575f
C66 MUX_8to1_0.passgate$1$2_0.B MUX_8to1_0.passgate$1$2_2.in_p 0.04515f
C67 2Div$2_0.d_flip_flop$3$2_1.NAND_2in_nmosx2$3$2_0.a 2Div$2_0.d_flip_flop$3$2_1.NAND_2in_nmosx2$3$2_0.y 0.44392f
C68 MUX_8to1_0.passgate$1$2_5.in_p a_n2333_5263# 0.09585f
C69 MUX_8to1_0.inverter_x4_ptap_mirror_fix$2$3_10.OUT clk 0.01027f
C70 pdiv$3_0.count_data_check$2_0.c1 pdiv$3_0.div_with_reset$3$2_0.d_flip_flop_reset$1$2_4.NAND_3in_nmosx3$1$1$3_1.a 2.59918f
C71 pdiv$3_0.passgate$3_1.A pdiv$3_0.div_with_reset$3$2_0.d_flip_flop_reset$1$2_3.NAND_3in_nmosx3$1$1$3_1.a 2.0547f
C72 a_6346_517# VP 0.3732f
C73 a_7020_517# d2 0.01014f
C74 a_n7639_2647# a_n7537_2647# 0.09425f
C75 a_6346_n3385# a_6702_n3385# 0.23649f
C76 pdiv$3_0.count_data_check$2_0.XNOR$1$2_3.y a_6702_n3385# 0.2621f
C77 MUX_8to1_0.in7 2Div$2_0.d_flip_flop$3$2_4.NAND_3in_nmosx3$1$2_0.y 0.60213f
C78 pdiv$3_0.d_flip_flop_reset$2$2_0.NAND_2in_nmosx2$1$2$2_0.a a_839_5248# 0.02156f
C79 MUX_8to1_0.inverter_x4_ptap_mirror_fix$2$3_5.OUT a0 0.75875f
C80 MUX_8to1_0.passgate$1$2_2.in_p a1 0.09066f
C81 pdiv$3_0.count_data_check$2_0.c4 d3 0.03785f
C82 pdiv$3_0.div_with_reset$3$2_0.d_flip_flop_reset$1$2_2.NAND_2in_nmosx2$1$1$5_0.b pdiv$3_0.div_with_reset$3$2_0.d_flip_flop_reset$1$2_2.NAND_2in_nmosx2$1$1$5_0.y 1.24916f
C83 MUX_8to1_0.passgate$1$2_7.A MUX_8to1_0.passgate$1$2_4.in_p 0.09972f
C84 MUX_8to1_0.inverter_x4_ptap_mirror_fix$2$3_5.OUT MUX_8to1_0.passgate$1$2_1.A 0.19297f
C85 2Div$2_0.d_flip_flop$3$2_1.NAND_2in_nmosx2$3$2_0.b 2Div$2_0.d_flip_flop$3$2_1.NAND_2in_nmosx2$3$2_0.a 0.79459f
C86 pdiv$3_0.div_with_reset$3$2_0.d_flip_flop_reset$1$2_0.NAND_2in_nmosx2$1$1$5_0.y pdiv$3_0.count_data_check$2_0.c5 0.10471f
C87 pdiv$3_0.count_data_check$2_0.XNOR$1$2_1.y d0 0.0865f
C88 2Div$2_0.d_flip_flop$3$2_1.d MUX_8to1_0.in5 0.18355f
C89 pdiv$3_0.passgate$3_1.in_p pdiv$3_0.NOR_2in$3$2_0.A 0.42322f
C90 MUX_8to1_0.inverter_x4_ptap_mirror_fix$2$3_4.OUT VP 0.18889f
C91 MUX_8to1_0.out MUX_8to1_0.passgate$1$2_4.in_n 0.0268f
C92 MUX_8to1_0.in4 VP 0.52112f
C93 pdiv$3_0.count_data_check$2_0.c3 a_6346_n769# 1.05377f
C94 MUX_8to1_0.in4 MUX_8to1_0.in6 0.38484f
C95 pdiv$3_0.div_with_reset$3$2_0.d_flip_flop_reset$1$2_2.NAND_2in_nmosx2$1$1$5_0.a a_4123_16# 0.10914f
C96 pdiv$3_0.div_with_reset$3$2_0.d_flip_flop_reset$1$2_2.NAND_2in_nmosx2$1$1$5_0.b VP 0.27618f
C97 pdiv$3_0.d_flip_flop_reset$2$2_0.NAND_2in_nmosx2$1$2$2_0.b a_1961_5656# 0.09919f
C98 pdiv$3_0.passgate$3_1.A MUX_8to1_0.out 2.67281f
C99 2Div$2_0.d_flip_flop$3$2_0.NAND_2in_nmosx2$3$2_0.a a_n8393_2647# 0.09722f
C100 MUX_8to1_0.passgate$1$2_6.in_p MUX_8to1_0.passgate$1$2_1.in_p 0.03022f
C101 2Div$2_0.d_flip_flop$3$2_5.d 2Div$2_0.d_flip_flop$3$2_5.NAND_2in_nmosx2$3$2_0.y 0.12448f
C102 VP d2 0.57911f
C103 pdiv$3_0.count_data_check$2_0.c4 pdiv$3_0.div_with_reset$3$2_0.d_flip_flop_reset$1$2_0.NAND_2in_nmosx2$1$1$5_0.b 0.46048f
C104 2Div$2_0.d_flip_flop$3$2_5.d VP 0.20277f
C105 pdiv$3_0.count_data_check$2_0.XNOR$1$2_2.y VP 0.15118f
C106 2Div$2_0.d_flip_flop$3$2_5.NAND_2in_nmosx2$3$2_0.a a_n8121_469# 0.01293f
C107 pdiv$3_0.NOR_2in$3$2_0.A VP 0.61817f
C108 pdiv$3_0.div_with_reset$3$2_0.d_flip_flop_reset$1$2_4.NAND_2in_nmosx2$1$1$5_0.b VP 0.27618f
C109 pdiv$3_0.div_with_reset$3$2_0.d_flip_flop_reset$1$2_3.clk pdiv$3_0.div_with_reset$3$2_0.d_flip_flop_reset$1$2_4.NAND_3in_nmosx3$1$1$3_1.a 1.88819f
C110 MUX_8to1_0.passgate$1$2_0.in_p a_n2333_n2147# 0.09585f
C111 a_6346_n769# a_6702_n769# 0.23654f
C112 MUX_8to1_0.passgate$1$2_7.A MUX_8to1_0.passgate$1$2_7.in_p 0.20391f
C113 MUX_8to1_0.inverter_x4_ptap_mirror_fix$2$3_5.OUT MUX_8to1_0.passgate$1$2_0.A 0.14797f
C114 MUX_8to1_0.passgate$1$2_1.in_n VP 0.21497f
C115 MUX_8to1_0.in4 a0 0.03571f
C116 MUX_8to1_0.passgate$1$2_7.A VP 0.18891f
C117 MUX_8to1_0.in4 MUX_8to1_0.passgate$1$2_1.A 0.05201f
C118 MUX_8to1_0.out pdiv$3_0.div_with_reset$3$2_0.d_flip_flop_reset$1$2_5.NAND_2in_nmosx2$1$1$5_0.a 1.2824f
C119 pdiv$3_0.div_with_reset$3$2_0.d_flip_flop_reset$1$2_0.NAND_2in_nmosx2$1$1$5_0.y pdiv$3_0.div_with_reset$3$2_0.d_flip_flop_reset$1$2_0.q 0.05581f
C120 MUX_8to1_0.inverter_x4_ptap_mirror_fix$2$3_7.OUT MUX_8to1_0.passgate$1$2_6.in_p 0.16919f
C121 a_2695_2632# a_2797_2632# 0.07813f
C122 MUX_8to1_0.passgate$1$2_7.in_n VP 0.21486f
C123 2Div$2_0.d_flip_flop$3$2_2.NAND_2in_nmosx2$3$2_0.y a_n5741_5701# 0.09372f
C124 pdiv$3_0.div_with_reset$3$2_0.d_flip_flop_reset$1$2_1.clk pdiv$3_0.div_with_reset$3$2_0.d_flip_flop_reset$1$2_1.NAND_2in_nmosx2$1$1$5_0.a 1.28449f
C125 pdiv$3_0.d_flip_flop_reset$2$2_0.d pdiv$3_0.d_flip_flop_reset$2$2_0.reset 2.35571f
C126 pdiv$3_0.div_with_reset$3$2_0.d_flip_flop_reset$1$2_2.NAND_2in_nmosx2$1$1$5_0.y VP 0.58944f
C127 d1 d3 0.07292f
C128 d0 d5 0.15212f
C129 d2 d4 0.07359f
C130 pdiv$3_0.count_data_check$2_0.XNOR$1$2_5.y pdiv$3_0.count_data_check$2_0.c3 0.37334f
C131 pdiv$3_0.count_data_check$2_0.XNOR$1$2_4.y a_7428_517# 0.04319f
C132 pdiv$3_0.div_with_reset$3$2_0.d_flip_flop_reset$1$2_1.NAND_2in_nmosx2$1$1$5_0.b VP 0.26725f
C133 pdiv$3_0.passgate$3_1.B MUX_8to1_0.out 1.31786f
C134 MUX_8to1_0.passgate$1$2_7.A a0 0.636f
C135 2Div$2_0.d_flip_flop$3$2_2.NAND_3in_nmosx3$1$2_0.y 2Div$2_0.d_flip_flop$3$2_2.NAND_2in_nmosx2$3$2_0.b 0.24214f
C136 MUX_8to1_0.passgate$1$2_6.A MUX_8to1_0.passgate$1$2_7.in_p 0.41079f
C137 pdiv$3_0.count_data_check$2_0.XNOR$1$2_0.y a_6702_3133# 0.01803f
C138 pdiv$3_0.count_data_check$2_0.c3 d2 0.04279f
C139 MUX_8to1_0.passgate$1$2_3.in_p MUX_8to1_0.inverter_x4_ptap_mirror_fix$2$3_5.OUT 0.24639f
C140 pdiv$3_0.count_data_check$2_0.XNOR$1$2_5.y a_6702_n769# 0.26211f
C141 MUX_8to1_0.inverter_x4_ptap_mirror_fix$2$3_7.OUT MUX_8to1_0.passgate$1$2_1.in_p 0.16806f
C142 pdiv$3_0.passgate$3_1.A VP 0.29994f
C143 pdiv$3_0.count_data_check$2_0.XNOR$1$2_0.y a_6346_n2099# 0.24959f
C144 2Div$2_0.d_flip_flop$3$2_0.NAND_2in_nmosx2$3$2_0.b MUX_8to1_0.in4 0.41307f
C145 pdiv$3_0.count_data_check$2_0.XNOR$1$2_4.y a_6702_517# 0.28776f
C146 pdiv$3_0.count_data_check$2_0.c1 a_5109_2632# 0.02299f
C147 2Div$2_0.d_flip_flop$3$2_2.NAND_2in_nmosx2$3$2_0.y 2Div$2_0.d_flip_flop$3$2_2.d 0.12448f
C148 pdiv$3_0.div_with_reset$3$2_0.d_flip_flop_reset$1$2_4.NAND_2in_nmosx2$1$1$5_0.a a_3817_2632# 0.02156f
C149 pdiv$3_0.count_data_check$2_0.XNOR$1$2_0.y pdiv$3_0.count_data_check$2_0.XNOR$1$2_3.y 8.16235f
C150 2Div$2_0.d_flip_flop$3$2_2.NAND_2in_nmosx2$3$2_0.a clk 0.72412f
C151 a_n2435_n2585# a_n2333_n2585# 0.09425f
C152 pdiv$3_0.passgate$3_1.A pdiv$3_0.div_with_reset$3$2_0.d_flip_flop_reset$1$2_1.NAND_2in_nmosx2$1$1$5_0.b 0.63815f
C153 pdiv$3_0.div_with_reset$3$2_0.d_flip_flop_reset$1$2_4.NAND_2in_nmosx2$1$1$5_0.a pdiv$3_0.count_data_check$2_0.c1 0.82297f
C154 MUX_8to1_0.passgate$1$2_0.B out_div 0.07779f
C155 a_1553_5656# a_1655_5656# 0.09808f
C156 2Div$2_0.d_flip_flop$3$2_5.NAND_2in_nmosx2$3$2_0.b 2Div$2_0.d_flip_flop$3$2_5.NAND_2in_nmosx2$3$2_0.a 0.79459f
C157 MUX_8to1_0.passgate$1$2_6.A a0 0.42665f
C158 VP d4 0.57348f
C159 pdiv$3_0.div_with_reset$3$2_0.d_flip_flop_reset$1$2_2.NAND_2in_nmosx2$1$1$5_0.y pdiv$3_0.count_data_check$2_0.c3 0.10471f
C160 MUX_8to1_0.passgate$1$2_6.A MUX_8to1_0.passgate$1$2_1.A 0.07544f
C161 a_6346_1847# a_7434_1798# 0.01178f
C162 2Div$2_0.d_flip_flop$3$2_6.NAND_2in_nmosx2$3$2_0.a a_n5741_469# 0.01293f
C163 pdiv$3_0.div_with_reset$3$2_0.d_flip_flop_reset$1$2_3.NAND_3in_nmosx3$1$1$3_1.a MUX_8to1_0.passgate$1$2_1.in_p 0.01211f
C164 pdiv$3_0.div_with_reset$3$2_0.d_flip_flop_reset$1$2_0.NAND_2in_nmosx2$1$1$5_0.b a_3001_n2192# 0.02373f
C165 2Div$2_0.d_flip_flop$3$2_6.NAND_3in_nmosx3$1$2_0.y MUX_8to1_0.in7 0.12134f
C166 VP d0 0.01565f
C167 pdiv$3_0.div_with_reset$3$2_0.d_flip_flop_reset$1$2_1.NAND_2in_nmosx2$1$1$5_0.y pdiv$3_0.div_with_reset$3$2_0.d_flip_flop_reset$1$2_1.NAND_2in_nmosx2$1$1$5_0.a 0.32406f
C168 pdiv$3_0.div_with_reset$3$2_0.d_flip_flop_reset$1$2_1.clk pdiv$3_0.div_with_reset$3$2_0.d_flip_flop_reset$1$2_0.clk 0.16868f
C169 pdiv$3_0.div_with_reset$3$2_0.d_flip_flop_reset$1$2_5.NAND_2in_nmosx2$1$1$5_0.b pdiv$3_0.div_with_reset$3$2_0.d_flip_flop_reset$1$2_3.NAND_2in_nmosx2$1$1$5_0.y 0.01266f
C170 2Div$2_0.d_flip_flop$3$2_0.NAND_2in_nmosx2$3$2_0.a 2Div$2_0.d_flip_flop$3$2_0.NAND_3in_nmosx3$1$2_0.y 1.19863f
C171 pdiv$3_0.div_with_reset$3$2_0.d_flip_flop_reset$1$2_2.NAND_2in_nmosx2$1$1$5_0.b pdiv$3_0.div_with_reset$3$2_0.d_flip_flop_reset$1$2_2.NAND_3in_nmosx3$1$1$3_1.a 0.80223f
C172 pdiv$3_0.d_flip_flop_reset$2$2_0.NAND_2in_nmosx2$1$2$2_0.y pdiv$3_0.d_flip_flop_reset$2$2_0.reset 0.22696f
C173 pdiv$3_0.div_with_reset$3$2_0.d_flip_flop_reset$1$2_2.NAND_2in_nmosx2$1$1$5_0.b a_3103_424# 0.10948f
C174 pdiv$3_0.div_with_reset$3$2_0.d_flip_flop_reset$1$2_3.NAND_2in_nmosx2$1$1$5_0.a a_597_424# 0.01596f
C175 2Div$2_0.d_flip_flop$3$2_3.NAND_2in_nmosx2$3$2_0.b 2Div$2_0.d_flip_flop$3$2_3.NAND_2in_nmosx2$3$2_0.y 0.8991f
C176 pdiv$3_0.count_data_check$2_0.c3 VP 1.66107f
C177 pdiv$3_0.div_with_reset$3$2_0.d_flip_flop_reset$1$2_1.NAND_2in_nmosx2$1$1$5_0.b a_n501_n2192# 0.09919f
C178 VP 2Div$2_0.d_flip_flop$3$2_2.d 0.19678f
C179 pdiv$3_0.passgate$3_1.B VP 0.31905f
C180 VP MUX_8to1_0.in2 0.42773f
C181 pdiv$3_0.count_data_check$2_0.c4 pdiv$3_0.count_data_check$2_0.c5 0.58136f
C182 a_7020_n2603# d5 0.01014f
C183 a_n2435_31# a_n2333_31# 0.09425f
C184 pdiv$3_0.div_with_reset$3$2_0.d_flip_flop_reset$1$2_3.NAND_2in_nmosx2$1$1$5_0.b a_n399_424# 0.01781f
C185 MUX_8to1_0.in8 2Div$2_0.d_flip_flop$3$2_4.d 0.19612f
C186 2Div$2_0.d_flip_flop$3$2_4.NAND_2in_nmosx2$3$2_0.a VP 0.1411f
C187 MUX_8to1_0.in7 VP 0.31793f
C188 pdiv$3_0.count_data_check$2_0.c2 pdiv$3_0.div_with_reset$3$2_0.d_flip_flop_reset$1$2_3.NAND_3in_nmosx3$1$1$3_1.a 3.09614f
C189 pdiv$3_0.d_flip_flop_reset$2$2_0.NAND_2in_nmosx2$1$2$2_0.a pdiv$3_0.d_flip_flop_reset$2$2_0.NAND_3in_nmosx3$1$2$3_1.a 1.93929f
C190 a_6702_n769# VP 0.53334f
C191 a_7434_3874# VP 0.09529f
C192 pdiv$3_0.div_with_reset$3$2_0.d_flip_flop_reset$1$2_4.NAND_2in_nmosx2$1$1$5_0.a pdiv$3_0.div_with_reset$3$2_0.d_flip_flop_reset$1$2_3.clk 0.31928f
C193 pdiv$3_0.passgate$3_1.A d0 0.20428f
C194 pdiv$3_0.div_with_reset$3$2_0.d_flip_flop_reset$1$2_2.NAND_2in_nmosx2$1$1$5_0.y pdiv$3_0.div_with_reset$3$2_0.d_flip_flop_reset$1$2_1.clk 0.05584f
C195 a_533_5248# a_635_5248# 0.09808f
C196 pdiv$3_0.count_data_check$2_0.c4 a_2015_n2600# 0.1084f
C197 pdiv$3_0.div_with_reset$3$2_0.d_flip_flop_reset$1$2_1.NAND_2in_nmosx2$1$1$5_0.b pdiv$3_0.div_with_reset$3$2_0.d_flip_flop_reset$1$2_1.NAND_3in_nmosx3$1$1$3_1.a 0.80223f
C198 a0 MUX_8to1_0.in2 0.02829f
C199 a_6702_1847# VP 0.53334f
C200 VP d1 0.0198f
C201 a_n2435_3085# a_n2333_3085# 0.09425f
C202 2Div$2_0.d_flip_flop$3$2_0.NAND_3in_nmosx3$1$2_0.y MUX_8to1_0.in6 0.01541f
C203 MUX_8to1_0.passgate$1$2_7.in_p a_n2333_2647# 0.09585f
C204 a_6346_n769# a_6346_n2099# 0.03535f
C205 2Div$2_0.d_flip_flop$3$2_1.NAND_2in_nmosx2$3$2_0.a VP 0.1411f
C206 MUX_8to1_0.in4 2Div$2_0.d_flip_flop$3$2_6.NAND_2in_nmosx2$3$2_0.a 0.71722f
C207 pdiv$3_0.div_with_reset$3$2_0.d_flip_flop_reset$1$2_1.clk VP 2.10122f
C208 pdiv$3_0.count_data_check$2_0.c1 d3 0.03109f
C209 2Div$2_0.d_flip_flop$3$2_3.NAND_2in_nmosx2$3$2_0.b 2Div$2_0.d_flip_flop$3$2_3.NAND_3in_nmosx3$1$2_0.y 0.24214f
C210 pdiv$3_0.div_with_reset$3$2_0.d_flip_flop_reset$1$2_3.clk pdiv$3_0.div_with_reset$3$2_0.d_flip_flop_reset$1$2_3.NAND_2in_nmosx2$1$1$5_0.b 2.28313f
C211 MUX_8to1_0.inverter_x4_ptap_mirror_fix$2$3_8.OUT 2Div$2_0.d_flip_flop$3$2_2.NAND_2in_nmosx2$3$2_0.b 0.03417f
C212 pdiv$3_0.div_with_reset$3$2_0.d_flip_flop_reset$1$2_1.NAND_2in_nmosx2$1$1$5_0.y pdiv$3_0.div_with_reset$3$2_0.d_flip_flop_reset$1$2_0.clk 0.05581f
C213 pdiv$3_0.div_with_reset$3$2_0.d_flip_flop_reset$1$2_4.NAND_2in_nmosx2$1$1$5_0.b a_2695_3040# 0.09919f
C214 pdiv$3_0.count_data_check$2_0.c4 pdiv$3_0.div_with_reset$3$2_0.d_flip_flop_reset$1$2_0.q 0.23252f
C215 pdiv$3_0.count_data_check$2_0.NAND_3in$2_0/NAND_3in_nmosx3$5$1$2_0.y VP 0.43584f
C216 pdiv$3_0.count_data_check$2_0.c0 d1 0.03198f
C217 2Div$2_0.d_flip_flop$3$2_3.NAND_2in_nmosx2$3$2_0.y 2Div$2_0.d_flip_flop$3$2_4.NAND_2in_nmosx2$3$2_0.b 0.0115f
C218 a_n6761_5263# 2Div$2_0.d_flip_flop$3$2_2.d 0.09386f
C219 MUX_8to1_0.in6 2Div$2_0.d_flip_flop$3$2_4.NAND_2in_nmosx2$3$2_0.y 0.60918f
C220 MUX_8to1_0.in8 a_n9141_n2585# 0.01677f
C221 pdiv$3_0.count_data_check$2_0.c5 d1 0.03501f
C222 MUX_8to1_0.passgate$1$2_3.in_n MUX_8to1_0.passgate$1$2_0.B 0.1476f
C223 pdiv$3_0.div_with_reset$3$2_0.d_flip_flop_reset$1$2_4.NAND_2in_nmosx2$1$1$5_0.y pdiv$3_0.div_with_reset$3$2_0.d_flip_flop_reset$1$2_4.NAND_2in_nmosx2$1$1$5_0.a 0.32406f
C224 2Div$2_0.d_flip_flop$3$2_1.NAND_3in_nmosx3$1$2_0.y a_n5259_2647# 0.09585f
C225 a_n195_n2192# a_n93_n2192# 0.09808f
C226 2Div$2_0.d_flip_flop$3$2_5.d a_n9141_31# 0.09386f
C227 MUX_8to1_0.in6 2Div$2_0.d_flip_flop$3$2_4.NAND_2in_nmosx2$3$2_0.b 1.49168f
C228 MUX_8to1_0.passgate$1$2_0.B pdiv$3_0.div_with_reset$3$2_0.d_flip_flop_reset$1$2_3.NAND_2in_nmosx2$1$1$5_0.b 0.04409f
C229 pdiv$3_0.count_data_check$2_0.XNOR$1$2_3.y pdiv$3_0.count_data_check$2_0.XNOR$1$2_5.y 0.63381f
C230 2Div$2_0.d_flip_flop$3$2_4.NAND_2in_nmosx2$3$2_0.a 2Div$2_0.d_flip_flop$3$2_4.NAND_3in_nmosx3$1$2_0.y 1.19863f
C231 a_n195_n2600# a_n93_n2600# 0.09808f
C232 pdiv$3_0.div_with_reset$3$2_0.d_flip_flop_reset$1$2_3.NAND_2in_nmosx2$1$1$5_0.y pdiv$3_0.div_with_reset$3$2_0.d_flip_flop_reset$1$2_3.NAND_2in_nmosx2$1$1$5_0.a 0.32406f
C233 2Div$2_0.d_flip_flop$3$2_4.NAND_2in_nmosx2$3$2_0.b a_n5129_n2147# 0.09898f
C234 pdiv$3_0.count_data_check$2_0.c3 pdiv$3_0.div_with_reset$3$2_0.d_flip_flop_reset$1$2_2.NAND_3in_nmosx3$1$1$3_1.a 2.59918f
C235 MUX_8to1_0.inverter_x4_ptap_mirror_fix$2$3_7.OUT VP 0.18643f
C236 2Div$2_0.d_flip_flop$3$2_0.NAND_2in_nmosx2$3$2_0.b 2Div$2_0.d_flip_flop$3$2_0.NAND_3in_nmosx3$1$2_0.y 0.24214f
C237 pdiv$3_0.div_with_reset$3$2_0.d_flip_flop_reset$1$2_1.NAND_2in_nmosx2$1$1$5_0.y VP 0.58789f
C238 pdiv$3_0.count_data_check$2_0.XNOR$1$2_2.y a_7018_1798# 0.07813f
C239 pdiv$3_0.div_with_reset$3$2_0.d_flip_flop_reset$1$2_0.NAND_2in_nmosx2$1$1$5_0.a a_3793_n2192# 0.01596f
C240 2Div$2_0.d_flip_flop$3$2_0.NAND_2in_nmosx2$3$2_0.a a_n8121_3085# 0.01293f
C241 MUX_8to1_0.inverter_x4_ptap_mirror_fix$2$3_4.OUT VP 0.06611f
C242 MUX_8to1_0.inverter_x4_ptap_mirror_fix$2$3_6.OUT VP 0.15712f
C243 MUX_8to1_0.inverter_x4_ptap_mirror_fix$2$3_6.OUT MUX_8to1_0.in6 0.04142f
C244 VP d5 0.12885f
C245 MUX_8to1_0.in4 MUX_8to1_0.in5 0.33226f
C246 VP a2 0.02193f
C247 pdiv$3_0.count_data_check$2_0.c5 a_5109_n2600# 0.02299f
C248 pdiv$3_0.div_with_reset$3$2_0.d_flip_flop_reset$1$2_0.NAND_2in_nmosx2$1$1$5_0.a a_3817_n2600# 0.02156f
C249 a_n195_16# a_n93_16# 0.09808f
C250 pdiv$3_0.div_with_reset$3$2_0.d_flip_flop_reset$1$2_5.NAND_2in_nmosx2$1$1$5_0.y VP 0.60469f
C251 a_n5259_31# a_n5157_31# 0.09425f
C252 MUX_8to1_0.inverter_x4_ptap_mirror_fix$2$3_6.OUT a0 0.52616f
C253 pdiv$3_0.div_with_reset$3$2_0.d_flip_flop_reset$1$2_5.NAND_2in_nmosx2$1$1$5_0.a a_927_2632# 0.10914f
C254 MUX_8to1_0.inverter_x4_ptap_mirror_fix$2$3_6.OUT MUX_8to1_0.passgate$1$2_1.A 0.03899f
C255 2Div$2_0.d_flip_flop$3$2_5.d 2Div$2_0.d_flip_flop$3$2_3.d 0.02274f
C256 pdiv$3_0.div_with_reset$3$2_0.d_flip_flop_reset$1$2_3.NAND_3in_nmosx3$1$1$3_1.a pdiv$3_0.div_with_reset$3$2_0.d_flip_flop_reset$1$2_1.NAND_2in_nmosx2$1$1$5_0.b 0.0287f
C257 pdiv$3_0.count_data_check$2_0.c0 a_1913_2632# 0.02299f
C258 pdiv$3_0.div_with_reset$3$2_0.d_flip_flop_reset$1$2_1.clk pdiv$3_0.div_with_reset$3$2_0.d_flip_flop_reset$1$2_2.NAND_3in_nmosx3$1$1$3_1.a 1.88819f
C259 pdiv$3_0.count_data_check$2_0.c1 VP 0.19093f
C260 a0 a2 1.39741f
C261 d5 d4 12.4943f
C262 a_6346_n2099# VP 0.3732f
C263 pdiv$3_0.div_with_reset$3$2_0.d_flip_flop_reset$1$2_5.NAND_3in_nmosx3$1$1$3_1.a a_n93_2632# 0.10805f
C264 pdiv$3_0.passgate$3_1.A pdiv$3_0.div_with_reset$3$2_0.d_flip_flop_reset$1$2_2.NAND_2in_nmosx2$1$1$5_0.b 0.63805f
C265 a_3715_n2600# a_3817_n2600# 0.07813f
C266 MUX_8to1_0.passgate$1$2_1.A a2 0.05544f
C267 2Div$2_0.d_flip_flop$3$2_6.NAND_2in_nmosx2$3$2_0.y VP 0.42167f
C268 pdiv$3_0.count_data_check$2_0.XNOR$1$2_0.y pdiv$3_0.count_data_check$2_0.c4 0.3615f
C269 MUX_8to1_0.inverter_x4_ptap_mirror_fix$2$3_8.OUT MUX_8to1_0.inverter_x4_ptap_mirror_fix$2$3_5.OUT 0.04453f
C270 pdiv$3_0.count_data_check$2_0.XNOR$1$2_2.y VP 0.17859f
C271 pdiv$3_0.div_with_reset$3$2_0.d_flip_flop_reset$1$2_3.NAND_2in_nmosx2$1$1$5_0.y pdiv$3_0.div_with_reset$3$2_0.d_flip_flop_reset$1$2_2.clk 0.05581f
C272 MUX_8to1_0.out VP 0.09379f
C273 MUX_8to1_0.in3 clk 0.07571f
C274 pdiv$3_0.count_data_check$2_0.c0 pdiv$3_0.div_with_reset$3$2_0.d_flip_flop_reset$1$2_5.NAND_2in_nmosx2$1$1$5_0.y 0.22729f
C275 pdiv$3_0.div_with_reset$3$2_0.d_flip_flop_reset$1$2_0.clk pdiv$3_0.div_with_reset$3$2_0.d_flip_flop_reset$1$2_0.NAND_2in_nmosx2$1$1$5_0.y 1.27386f
C276 2Div$2_0.d_flip_flop$3$2_5.NAND_2in_nmosx2$3$2_0.y 2Div$2_0.d_flip_flop$3$2_6.NAND_2in_nmosx2$3$2_0.b 0.01151f
C277 pdiv$3_0.div_with_reset$3$2_0.d_flip_flop_reset$1$2_4.NAND_3in_nmosx3$1$1$3_1.a a_3103_2632# 0.10805f
C278 2Div$2_0.d_flip_flop$3$2_5.NAND_3in_nmosx3$1$2_0.y 2Div$2_0.d_flip_flop$3$2_3.NAND_2in_nmosx2$3$2_0.b 0.02754f
C279 pdiv$3_0.d_flip_flop_reset$2$2_0.d pdiv$3_0.d_flip_flop_reset$2$2_0.NAND_2in_nmosx2$1$2$2_0.a 0.84218f
C280 pdiv$3_0.count_data_check$2_0.c3 d5 0.05592f
C281 MUX_8to1_0.passgate$1$2_7.in_n MUX_8to1_0.passgate$1$2_6.in_n 0.01252f
C282 2Div$2_0.d_flip_flop$3$2_6.NAND_2in_nmosx2$3$2_0.b VP 0.64743f
C283 MUX_8to1_0.inverter_x4_ptap_mirror_fix$2$3_5.OUT MUX_8to1_0.inverter_x4_ptap_mirror_fix$2$3_10.OUT 0.06281f
C284 pdiv$3_0.count_data_check$2_0.c0 pdiv$3_0.count_data_check$2_0.c1 0.58142f
C285 pdiv$3_0.count_data_check$2_0.c2 d0 0.14256f
C286 2Div$2_0.d_flip_flop$3$2_0.d 2Div$2_0.d_flip_flop$3$2_0.NAND_2in_nmosx2$3$2_0.a 0.60818f
C287 2Div$2_0.d_flip_flop$3$2_2.NAND_2in_nmosx2$3$2_0.a 2Div$2_0.d_flip_flop$3$2_2.NAND_2in_nmosx2$3$2_0.b 0.79459f
C288 MUX_8to1_0.inverter_x4_ptap_mirror_fix$2$3_6.OUT MUX_8to1_0.passgate$1$2_0.A 0.03766f
C289 MUX_8to1_0.in7 MUX_8to1_0.in8 0.26882f
C290 MUX_8to1_0.in5 MUX_8to1_0.passgate$1$2_6.A 0.51699f
C291 2Div$2_0.d_flip_flop$3$2_2.NAND_2in_nmosx2$3$2_0.y VP 0.42368f
C292 2Div$2_0.d_flip_flop$3$2_3.NAND_2in_nmosx2$3$2_0.a 2Div$2_0.d_flip_flop$3$2_3.NAND_2in_nmosx2$3$2_0.y 0.44392f
C293 pdiv$3_0.d_flip_flop_reset$2$2_0.NAND_2in_nmosx2$1$2$2_0.a a_533_5248# 0.10914f
C294 2Div$2_0.d_flip_flop$3$2_1.NAND_2in_nmosx2$3$2_0.a a_n5741_3085# 0.01293f
C295 2Div$2_0.d_flip_flop$3$2_3.d VP 0.20277f
C296 MUX_8to1_0.passgate$1$2_0.B MUX_8to1_0.passgate$1$2_4.in_p 0.10479f
C297 MUX_8to1_0.passgate$1$2_0.A a2 0.19054f
C298 pdiv$3_0.d_flip_flop_reset$2$2_0.NAND_3in_nmosx3$1$2$3_1.a a_1859_5248# 0.01716f
C299 pdiv$3_0.div_with_reset$3$2_0.d_flip_flop_reset$1$2_4.NAND_2in_nmosx2$1$1$5_0.a pdiv$3_0.div_with_reset$3$2_0.d_flip_flop_reset$1$2_4.NAND_3in_nmosx3$1$1$3_1.a 1.93885f
C300 a_3715_16# a_3817_16# 0.07813f
C301 pdiv$3_0.div_with_reset$3$2_0.d_flip_flop_reset$1$2_3.clk VP 0.35036f
C302 MUX_8to1_0.in3 VP 0.32664f
C303 MUX_8to1_0.passgate$1$2_5.A MUX_8to1_0.inverter_x4_ptap_mirror_fix$2$3_7.OUT 0.05303f
C304 pdiv$3_0.count_data_check$2_0.c3 a_5109_16# 0.02299f
C305 a_6346_3133# d0 0.94934f
C306 pdiv$3_0.div_with_reset$3$2_0.d_flip_flop_reset$1$2_2.NAND_2in_nmosx2$1$1$5_0.a a_3817_16# 0.02156f
C307 pdiv$3_0.count_data_check$2_0.XNOR$1$2_4.y a_7018_1258# 0.07813f
C308 pdiv$3_0.d_flip_flop_reset$2$2_0.NAND_2in_nmosx2$1$2$2_0.b a_1655_5656# 0.02373f
C309 pdiv$3_0.div_with_reset$3$2_0.d_flip_flop_reset$1$2_0.NAND_2in_nmosx2$1$1$5_0.y pdiv$3_0.div_with_reset$3$2_0.d_flip_flop_reset$1$2_0.NAND_2in_nmosx2$1$1$5_0.a 0.32406f
C310 MUX_8to1_0.passgate$1$2_4.in_p a1 0.08787f
C311 a_519_2632# a_621_2632# 0.07813f
C312 pdiv$3_0.passgate$3_1.A VP 1.47159f
C313 2Div$2_0.d_flip_flop$3$2_2.NAND_3in_nmosx3$1$2_0.y MUX_8to1_0.in2 0.80782f
C314 pdiv$3_0.div_with_reset$3$2_0.d_flip_flop_reset$1$2_2.NAND_2in_nmosx2$1$1$5_0.y a_3793_424# 0.1016f
C315 pdiv$3_0.div_with_reset$3$2_0.d_flip_flop_reset$1$2_0.NAND_2in_nmosx2$1$1$5_0.y VP 0.58944f
C316 MUX_8to1_0.passgate$1$2_0.B MUX_8to1_0.passgate$1$2_2.in_n 0.06681f
C317 clk 2Div$2_0.d_flip_flop$3$2_2.d 0.0136f
C318 2Div$2_0.d_flip_flop$3$2_0.d VP 0.19678f
C319 pdiv$3_0.count_data_check$2_0.c0 pdiv$3_0.div_with_reset$3$2_0.d_flip_flop_reset$1$2_3.clk 0.57522f
C320 MUX_8to1_0.inverter_x4_ptap_mirror_fix$2$3_5.OUT VP 0.19318f
C321 MUX_8to1_0.inverter_x4_ptap_mirror_fix$2$3_6.OUT MUX_8to1_0.passgate$1$2_3.in_p 0.09014f
C322 2Div$2_0.d_flip_flop$3$2_0.d MUX_8to1_0.in6 0.03218f
C323 MUX_8to1_0.inverter_x4_ptap_mirror_fix$2$3_7.OUT MUX_8to1_0.passgate$1$2_5.in_p 0.30854f
C324 pdiv$3_0.d_flip_flop_reset$2$2_0.NAND_2in_nmosx2$1$2$2_0.b pdiv$3_0.d_flip_flop_reset$2$2_0.NAND_3in_nmosx3$1$2$3_1.a 0.80399f
C325 pdiv$3_0.div_with_reset$3$2_0.d_flip_flop_reset$1$2_3.NAND_2in_nmosx2$1$1$5_0.a VP 1.04477f
C326 a_6702_3133# a_6702_1847# 0.01157f
C327 pdiv$3_0.count_data_check$2_0.XNOR$1$2_1.y a_7428_3133# 0.04319f
C328 MUX_8to1_0.passgate$1$2_0.B MUX_8to1_0.passgate$1$2_7.in_p 0.0652f
C329 2Div$2_0.d_flip_flop$3$2_6.NAND_2in_nmosx2$3$2_0.a a_n6013_31# 0.09722f
C330 pdiv$3_0.d_flip_flop_reset$2$2_0.NAND_2in_nmosx2$1$2$2_0.a pdiv$3_0.d_flip_flop_reset$2$2_0.NAND_2in_nmosx2$1$2$2_0.y 0.32406f
C331 pdiv$3_0.div_with_reset$3$2_0.d_flip_flop_reset$1$2_2.clk pdiv$3_0.div_with_reset$3$2_0.d_flip_flop_reset$1$2_0.clk 0.03081f
C332 pdiv$3_0.count_data_check$2_0.c4 pdiv$3_0.div_with_reset$3$2_0.d_flip_flop_reset$1$2_1.NAND_2in_nmosx2$1$1$5_0.a 1.22533f
C333 MUX_8to1_0.passgate$1$2_0.B VP 0.45728f
C334 pdiv$3_0.div_with_reset$3$2_0.d_flip_flop_reset$1$2_5.NAND_2in_nmosx2$1$1$5_0.a VP 1.04477f
C335 2Div$2_0.d_flip_flop$3$2_3.NAND_2in_nmosx2$3$2_0.a 2Div$2_0.d_flip_flop$3$2_3.NAND_3in_nmosx3$1$2_0.y 1.19863f
C336 pdiv$3_0.div_with_reset$3$2_0.d_flip_flop_reset$1$2_3.clk pdiv$3_0.div_with_reset$3$2_0.d_flip_flop_reset$1$2_5.NAND_3in_nmosx3$1$1$3_1.a 0.28891f
C337 MUX_8to1_0.in5 MUX_8to1_0.in2 0.06471f
C338 2Div$2_0.d_flip_flop$3$2_4.NAND_2in_nmosx2$3$2_0.a VP 0.50042f
C339 pdiv$3_0.NOR_2in$3$2_0.B pdiv$3_0.NOR_2in$3$2_0.A 0.81354f
C340 pdiv$3_0.count_data_check$2_0.NAND_3in$2_0/NAND_3in_nmosx3$5$1$2_0.y pdiv$3_0.count_data_check$2_0.XNOR$1$2_0.y 0.43441f
C341 MUX_8to1_0.in7 2Div$2_0.d_flip_flop$3$2_4.d 1.09889f
C342 pdiv$3_0.passgate$3_1.A d4 0.03285f
C343 MUX_8to1_0.passgate$1$2_7.in_p a1 0.08793f
C344 MUX_8to1_0.inverter_x4_ptap_mirror_fix$2$3_10.OUT MUX_8to1_0.passgate$1$2_7.A 0.06939f
C345 pdiv$3_0.div_with_reset$3$2_0.d_flip_flop_reset$1$2_4.NAND_2in_nmosx2$1$1$5_0.y VP 0.58861f
C346 a_6702_n2099# d4 0.45324f
C347 VP a1 0.16151f
C348 MUX_8to1_0.in6 a1 0.01203f
C349 pdiv$3_0.count_data_check$2_0.XNOR$1$2_1.y a_6702_3133# 0.30134f
C350 MUX_8to1_0.passgate$1$2_2.in_p MUX_8to1_0.passgate$1$2_2.in_n 0.44557f
C351 MUX_8to1_0.passgate$1$2_3.in_p a_n2333_5701# 0.09585f
C352 MUX_8to1_0.passgate$1$2_0.B a0 0.01773f
C353 pdiv$3_0.passgate$3_1.A pdiv$3_0.count_data_check$2_0.c3 2.42805f
C354 MUX_8to1_0.passgate$1$2_0.B MUX_8to1_0.passgate$1$2_1.A 0.87709f
C355 MUX_8to1_0.in4 VP 0.16671f
C356 pdiv$3_0.div_with_reset$3$2_0.d_flip_flop_reset$1$2_2.clk pdiv$3_0.div_with_reset$3$2_0.d_flip_flop_reset$1$2_2.NAND_2in_nmosx2$1$1$5_0.y 1.27386f
C357 a_4021_2632# a_4123_2632# 0.09808f
C358 pdiv$3_0.count_data_check$2_0.c0 pdiv$3_0.div_with_reset$3$2_0.d_flip_flop_reset$1$2_4.NAND_2in_nmosx2$1$1$5_0.y 0.12259f
C359 MUX_8to1_0.passgate$1$2_0.A MUX_8to1_0.passgate$1$2_0.in_p 0.55648f
C360 MUX_8to1_0.passgate$1$2_7.A MUX_8to1_0.passgate$1$2_7.in_n 0.55121f
C361 pdiv$3_0.count_data_check$2_0.XNOR$1$2_4.y pdiv$3_0.count_data_check$2_0.XNOR$1$2_0.y 0.02989f
C362 pdiv$3_0.count_data_check$2_0.XNOR$1$2_1.y pdiv$3_0.count_data_check$2_0.XNOR$1$2_3.y 0.05142f
C363 pdiv$3_0.div_with_reset$3$2_0.d_flip_flop_reset$1$2_1.clk VP 0.29148f
C364 MUX_8to1_0.in4 2Div$2_0.d_flip_flop$3$2_0.NAND_2in_nmosx2$3$2_0.y 0.19573f
C365 2Div$2_0.d_flip_flop$3$2_1.NAND_2in_nmosx2$3$2_0.a MUX_8to1_0.in5 0.12949f
C366 a0 a1 9.93688f
C367 MUX_8to1_0.in3 2Div$2_0.d_flip_flop$3$2_1.d 1.09889f
C368 2Div$2_0.d_flip_flop$3$2_0.NAND_3in_nmosx3$1$2_0.y a_n7639_2647# 0.09585f
C369 pdiv$3_0.count_data_check$2_0.c1 a_4803_2632# 0.09933f
C370 MUX_8to1_0.in8 MUX_8to1_0.inverter_x4_ptap_mirror_fix$2$3_4.OUT 0.50663f
C371 MUX_8to1_0.passgate$1$2_1.A a1 0.03447f
C372 pdiv$3_0.div_with_reset$3$2_0.d_flip_flop_reset$1$2_2.clk VP 0.56374f
C373 a_6702_n769# a_6702_n2099# 0.10824f
C374 2Div$2_0.d_flip_flop$3$2_0.NAND_2in_nmosx2$3$2_0.b 2Div$2_0.d_flip_flop$3$2_0.d 0.81289f
C375 2Div$2_0.d_flip_flop$3$2_1.NAND_2in_nmosx2$3$2_0.b 2Div$2_0.d_flip_flop$3$2_1.NAND_3in_nmosx3$1$2_0.y 0.24214f
C376 2Div$2_0.d_flip_flop$3$2_5.NAND_2in_nmosx2$3$2_0.a 2Div$2_0.d_flip_flop$3$2_5.NAND_2in_nmosx2$3$2_0.y 0.44392f
C377 VP d0 0.18186f
C378 pdiv$3_0.count_data_check$2_0.c4 pdiv$3_0.div_with_reset$3$2_0.d_flip_flop_reset$1$2_0.clk 1.7297f
C379 MUX_8to1_0.inverter_x4_ptap_mirror_fix$2$3_7.OUT MUX_8to1_0.inverter_x4_ptap_mirror_fix$2$3_4.OUT 0.06571f
C380 MUX_8to1_0.passgate$1$2_1.in_p MUX_8to1_0.passgate$1$2_1.in_n 0.44557f
C381 pdiv$3_0.d_flip_flop_reset$2$2_0.NAND_2in_nmosx2$1$2$2_0.y reset 0.05337f
C382 MUX_8to1_0.passgate$1$2_6.in_p VP 1.06664f
C383 2Div$2_0.d_flip_flop$3$2_5.NAND_2in_nmosx2$3$2_0.a VP 0.14115f
C384 MUX_8to1_0.passgate$1$2_0.B MUX_8to1_0.passgate$1$2_0.A 0.88418f
C385 d1 pdiv$3_0.inverter_x8$3_0.IN 0.0251f
C386 MUX_8to1_0.passgate$1$2_2.in_p a0 0.24927f
C387 pdiv$3_0.count_data_check$2_0.c4 d2 0.03192f
C388 pdiv$3_0.div_with_reset$3$2_0.d_flip_flop_reset$1$2_0.NAND_2in_nmosx2$1$1$5_0.b a_2695_n2192# 0.09919f
C389 pdiv$3_0.div_with_reset$3$2_0.d_flip_flop_reset$1$2_4.clk VP 0.56374f
C390 2Div$2_0.d_flip_flop$3$2_1.NAND_2in_nmosx2$3$2_0.b 2Div$2_0.d_flip_flop$3$2_1.NAND_2in_nmosx2$3$2_0.y 0.8991f
C391 MUX_8to1_0.inverter_x4_ptap_mirror_fix$2$3_5.OUT 2Div$2_0.d_flip_flop$3$2_4.NAND_3in_nmosx3$1$2_0.y 0.032f
C392 a_n195_424# a_n93_424# 0.09808f
C393 pdiv$3_0.count_data_check$2_0.c2 pdiv$3_0.div_with_reset$3$2_0.d_flip_flop_reset$1$2_2.NAND_2in_nmosx2$1$1$5_0.b 0.46054f
C394 pdiv$3_0.passgate$3_1.A pdiv$3_0.div_with_reset$3$2_0.d_flip_flop_reset$1$2_1.clk 2.99721f
C395 pdiv$3_0.div_with_reset$3$2_0.d_flip_flop_reset$1$2_2.NAND_2in_nmosx2$1$1$5_0.b a_2797_424# 0.01781f
C396 pdiv$3_0.div_with_reset$3$2_0.d_flip_flop_reset$1$2_2.NAND_2in_nmosx2$1$1$5_0.y pdiv$3_0.div_with_reset$3$2_0.d_flip_flop_reset$1$2_2.NAND_2in_nmosx2$1$1$5_0.a 0.32406f
C397 MUX_8to1_0.passgate$1$2_0.A a1 0.07398f
C398 pdiv$3_0.d_flip_flop_reset$2$2_0.NAND_2in_nmosx2$1$2$2_0.a a_863_5656# 0.01596f
C399 MUX_8to1_0.inverter_x4_ptap_mirror_fix$2$3_8.OUT MUX_8to1_0.in2 0.23582f
C400 a_7357_5701# a_7459_5701# 0.09425f
C401 pdiv$3_0.count_data_check$2_0.NAND_3in$2_0/NAND_3in_nmosx3$5$1$2_0.y pdiv$3_0.inverter_x8$3_0.IN 0.3968f
C402 a_6346_n3385# d5 0.95859f
C403 pdiv$3_0.div_with_reset$3$2_0.d_flip_flop_reset$1$2_3.clk a_4803_2632# 0.01009f
C404 MUX_8to1_0.passgate$1$2_5.A VP 0.1965f
C405 pdiv$3_0.count_data_check$2_0.XNOR$1$2_3.y d5 0.09301f
C406 pdiv$3_0.d_flip_flop_reset$2$2_0.d a_n147_5248# 0.09933f
C407 pdiv$3_0.passgate$3_1.A pdiv$3_0.d_flip_flop_reset$2$2_0.NAND_3in_nmosx3$1$2$3_1.a 0.31801f
C408 pdiv$3_0.div_with_reset$3$2_0.d_flip_flop_reset$1$2_2.NAND_2in_nmosx2$1$1$5_0.a VP 1.03888f
C409 2Div$2_0.d_flip_flop$3$2_5.NAND_2in_nmosx2$3$2_0.y a_n8121_469# 0.09372f
C410 pdiv$3_0.count_data_check$2_0.c4 pdiv$3_0.div_with_reset$3$2_0.d_flip_flop_reset$1$2_0.NAND_3in_nmosx3$1$1$3_1.a 0.52317f
C411 MUX_8to1_0.inverter_x4_ptap_mirror_fix$2$3_10.OUT MUX_8to1_0.in2 0.03258f
C412 MUX_8to1_0.passgate$1$2_3.in_p MUX_8to1_0.passgate$1$2_0.B 0.0459f
C413 pdiv$3_0.count_data_check$2_0.c4 pdiv$3_0.div_with_reset$3$2_0.d_flip_flop_reset$1$2_0.NAND_2in_nmosx2$1$1$5_0.a 0.3883f
C414 pdiv$3_0.div_with_reset$3$2_0.d_flip_flop_reset$1$2_3.NAND_3in_nmosx3$1$1$3_1.a MUX_8to1_0.passgate$1$2_1.in_n 0.01754f
C415 pdiv$3_0.count_data_check$2_0.c4 a_1709_n2600# 0.01875f
C416 pdiv$3_0.count_data_check$2_0.c4 VP 0.73507f
C417 2Div$2_0.d_flip_flop$3$2_5.d 2Div$2_0.d_flip_flop$3$2_3.NAND_2in_nmosx2$3$2_0.b 0.02151f
C418 MUX_8to1_0.inverter_x4_ptap_mirror_fix$2$3_7.OUT VP 0.24079f
C419 d2 d1 11.7735f
C420 pdiv$3_0.count_data_check$2_0.c2 VP 0.73186f
C421 pdiv$3_0.div_with_reset$3$2_0.d_flip_flop_reset$1$2_1.clk pdiv$3_0.div_with_reset$3$2_0.d_flip_flop_reset$1$2_1.NAND_3in_nmosx3$1$1$3_1.a 0.55611f
C422 pdiv$3_0.count_data_check$2_0.NAND_3in$2_0/NAND_3in_nmosx3$5$1$2_0.y pdiv$3_0.count_data_check$2_0.XNOR$1$2_5.y 0.14845f
C423 pdiv$3_0.count_data_check$2_0.XNOR$1$2_2.y pdiv$3_0.count_data_check$2_0.XNOR$1$2_3.y 0.03273f
C424 pdiv$3_0.NOR_2in$3$2_0.B d1 0.07761f
C425 pdiv$3_0.passgate$3_1.A pdiv$3_0.div_with_reset$3$2_0.d_flip_flop_reset$1$2_1.NAND_2in_nmosx2$1$1$5_0.y 0.22238f
C426 a_7357_5263# a_7459_5263# 0.09425f
C427 pdiv$3_0.d_flip_flop_reset$2$2_0.NAND_2in_nmosx2$1$2$2_0.b pdiv$3_0.d_flip_flop_reset$2$2_0.d 0.77346f
C428 a_1859_5248# a_1961_5248# 0.07813f
C429 pdiv$3_0.passgate$3_1.B pdiv$3_0.d_flip_flop_reset$2$2_0.NAND_3in_nmosx3$1$2$3_1.a 0.58248f
C430 pdiv$3_0.passgate$3_1.A pdiv$3_0.div_with_reset$3$2_0.d_flip_flop_reset$1$2_5.NAND_2in_nmosx2$1$1$5_0.b 1.02447f
C431 pdiv$3_0.count_data_check$2_0.XNOR$1$2_4.y a_6346_517# 0.26283f
C432 a_6346_n3385# VP 0.36508f
C433 pdiv$3_0.count_data_check$2_0.XNOR$1$2_3.y VP 0.17406f
C434 pdiv$3_0.div_with_reset$3$2_0.d_flip_flop_reset$1$2_2.clk pdiv$3_0.div_with_reset$3$2_0.d_flip_flop_reset$1$2_2.NAND_3in_nmosx3$1$1$3_1.a 0.55635f
C435 pdiv$3_0.count_data_check$2_0.c0 pdiv$3_0.div_with_reset$3$2_0.d_flip_flop_reset$1$2_4.NAND_3in_nmosx3$1$1$3_1.a 0.52317f
C436 2Div$2_0.d_flip_flop$3$2_3.NAND_2in_nmosx2$3$2_0.b VP 0.67837f
C437 2Div$2_0.d_flip_flop$3$2_2.NAND_2in_nmosx2$3$2_0.y clk 0.59403f
C438 pdiv$3_0.count_data_check$2_0.c2 d4 0.02957f
C439 pdiv$3_0.count_data_check$2_0.NAND_3in$2_0/NAND_3in_nmosx3$5$1$2_0.y a_7459_5263# 0.10535f
C440 pdiv$3_0.count_data_check$2_0.XNOR$1$2_4.y pdiv$3_0.count_data_check$2_0.XNOR$1$2_5.y 5.12991f
C441 VP out_div 0.28848f
C442 pdiv$3_0.div_with_reset$3$2_0.d_flip_flop_reset$1$2_5.NAND_2in_nmosx2$1$1$5_0.b a_n93_3040# 0.10948f
C443 2Div$2_0.d_flip_flop$3$2_5.NAND_2in_nmosx2$3$2_0.b 2Div$2_0.d_flip_flop$3$2_5.NAND_2in_nmosx2$3$2_0.y 0.8991f
C444 pdiv$3_0.count_data_check$2_0.c2 a_2015_16# 0.1084f
C445 MUX_8to1_0.in8 2Div$2_0.d_flip_flop$3$2_4.NAND_2in_nmosx2$3$2_0.a 0.13086f
C446 pdiv$3_0.div_with_reset$3$2_0.d_flip_flop_reset$1$2_5.NAND_2in_nmosx2$1$1$5_0.b pdiv$3_0.div_with_reset$3$2_0.d_flip_flop_reset$1$2_5.NAND_2in_nmosx2$1$1$5_0.a 0.99113f
C447 VP d1 0.02811f
C448 2Div$2_0.d_flip_flop$3$2_6.NAND_2in_nmosx2$3$2_0.y a_n5741_469# 0.09372f
C449 2Div$2_0.d_flip_flop$3$2_5.NAND_2in_nmosx2$3$2_0.b VP 0.67837f
C450 MUX_8to1_0.out VP 0.27257f
C451 pdiv$3_0.count_data_check$2_0.XNOR$1$2_4.y d2 0.08641f
C452 pdiv$3_0.count_data_check$2_0.c2 pdiv$3_0.count_data_check$2_0.c3 0.58143f
C453 2Div$2_0.d_flip_flop$3$2_3.d VP 0.55625f
C454 MUX_8to1_0.in6 2Div$2_0.d_flip_flop$3$2_6.d 0.19612f
C455 a_6702_n2099# a_6346_n2099# 0.2366f
C456 pdiv$3_0.d_flip_flop_reset$2$2_0.NAND_3in_nmosx3$1$2$3_1.a pdiv$3_0.div_with_reset$3$2_0.d_flip_flop_reset$1$2_4.clk 0.01269f
C457 a_3001_n2192# a_3103_n2192# 0.09808f
C458 pdiv$3_0.count_data_check$2_0.XNOR$1$2_2.y a_7020_2629# 0.04296f
C459 2Div$2_0.d_flip_flop$3$2_2.d 2Div$2_0.d_flip_flop$3$2_2.NAND_2in_nmosx2$3$2_0.b 0.81289f
C460 MUX_8to1_0.inverter_x4_ptap_mirror_fix$2$3_8.OUT MUX_8to1_0.inverter_x4_ptap_mirror_fix$2$3_6.OUT 0.01961f
C461 pdiv$3_0.div_with_reset$3$2_0.d_flip_flop_reset$1$2_1.NAND_3in_nmosx3$1$1$3_1.a a_n93_n2600# 0.10805f
C462 MUX_8to1_0.passgate$1$2_5.in_n MUX_8to1_0.passgate$1$2_4.in_n 0.01252f
C463 pdiv$3_0.div_with_reset$3$2_0.d_flip_flop_reset$1$2_2.NAND_2in_nmosx2$1$1$5_0.a pdiv$3_0.div_with_reset$3$2_0.d_flip_flop_reset$1$2_2.NAND_3in_nmosx3$1$1$3_1.a 1.93885f
C464 MUX_8to1_0.passgate$1$2_0.in_p MUX_8to1_0.passgate$1$2_0.in_n 0.44409f
C465 VP clk 0.42623f
C466 pdiv$3_0.d_flip_flop_reset$2$2_0.NAND_2in_nmosx2$1$2$2_0.b pdiv$3_0.d_flip_flop_reset$2$2_0.NAND_2in_nmosx2$1$2$2_0.y 1.24916f
C467 2Div$2_0.d_flip_flop$3$2_4.NAND_2in_nmosx2$3$2_0.y VP 0.42167f
C468 a_1607_n2600# a_1709_n2600# 0.07813f
C469 MUX_8to1_0.passgate$1$2_5.A MUX_8to1_0.passgate$1$2_5.in_p 0.20391f
C470 MUX_8to1_0.inverter_x4_ptap_mirror_fix$2$3_6.OUT MUX_8to1_0.inverter_x4_ptap_mirror_fix$2$3_10.OUT 0.05288f
C471 pdiv$3_0.div_with_reset$3$2_0.d_flip_flop_reset$1$2_0.NAND_3in_nmosx3$1$1$3_1.a a_3103_n2600# 0.10805f
C472 pdiv$3_0.div_with_reset$3$2_0.d_flip_flop_reset$1$2_3.clk pdiv$3_0.div_with_reset$3$2_0.d_flip_flop_reset$1$2_3.NAND_2in_nmosx2$1$1$5_0.y 1.30841f
C473 2Div$2_0.d_flip_flop$3$2_2.NAND_2in_nmosx2$3$2_0.a MUX_8to1_0.in2 0.15445f
C474 a_6346_1847# a_6346_517# 0.03535f
C475 MUX_8to1_0.inverter_x4_ptap_mirror_fix$2$3_5.OUT VP 0.36894f
C476 a_6888_6498# pdiv$3_0.inverter_x8$3_0.IN 0.05335f
C477 pdiv$3_0.count_data_check$2_0.c5 a_4803_n2600# 0.09933f
C478 MUX_8to1_0.in4 a_n9141_2647# 0.01677f
C479 pdiv$3_0.NOR_2in$3$2_0.A d5 0.13692f
C480 MUX_8to1_0.inverter_x4_ptap_mirror_fix$2$3_10.OUT a2 0.03383f
C481 2Div$2_0.d_flip_flop$3$2_4.NAND_2in_nmosx2$3$2_0.b VP 0.64743f
C482 pdiv$3_0.div_with_reset$3$2_0.d_flip_flop_reset$1$2_5.NAND_2in_nmosx2$1$1$5_0.a a_621_2632# 0.02156f
C483 MUX_8to1_0.in6 a_n8801_469# 0.09893f
C484 MUX_8to1_0.in4 2Div$2_0.d_flip_flop$3$2_6.NAND_3in_nmosx3$1$2_0.y 0.17688f
C485 pdiv$3_0.count_data_check$2_0.c2 pdiv$3_0.div_with_reset$3$2_0.d_flip_flop_reset$1$2_1.clk 0.5749f
C486 MUX_8to1_0.passgate$1$2_0.B MUX_8to1_0.passgate$1$2_0.in_n 0.14829f
C487 pdiv$3_0.count_data_check$2_0.c0 a_1607_2632# 0.09933f
C488 MUX_8to1_0.in3 a_n6421_3085# 0.09596f
C489 2Div$2_0.d_flip_flop$3$2_4.d 2Div$2_0.d_flip_flop$3$2_4.NAND_2in_nmosx2$3$2_0.a 0.60818f
C490 pdiv$3_0.div_with_reset$3$2_0.d_flip_flop_reset$1$2_5.NAND_3in_nmosx3$1$1$3_1.a a_n399_2632# 0.01716f
C491 2Div$2_0.d_flip_flop$3$2_1.NAND_2in_nmosx2$3$2_0.y VP 0.42167f
C492 pdiv$3_0.div_with_reset$3$2_0.d_flip_flop_reset$1$2_5.NAND_2in_nmosx2$1$1$5_0.b pdiv$3_0.div_with_reset$3$2_0.d_flip_flop_reset$1$2_4.clk 0.13764f
C493 MUX_8to1_0.in4 2Div$2_0.d_flip_flop$3$2_6.NAND_2in_nmosx2$3$2_0.y 0.60941f
C494 pdiv$3_0.count_data_check$2_0.c1 d2 0.03291f
C495 pdiv$3_0.passgate$3_1.A pdiv$3_0.div_with_reset$3$2_0.d_flip_flop_reset$1$2_0.NAND_2in_nmosx2$1$1$5_0.y 0.22234f
C496 MUX_8to1_0.inverter_x4_ptap_mirror_fix$2$3_5.OUT MUX_8to1_0.passgate$1$2_4.in_n 0.0168f
C497 pdiv$3_0.div_with_reset$3$2_0.d_flip_flop_reset$1$2_1.clk pdiv$3_0.div_with_reset$3$2_0.d_flip_flop_reset$1$2_3.NAND_3in_nmosx3$1$1$3_1.a 0.28891f
C498 MUX_8to1_0.passgate$1$2_0.in_n a1 0.01628f
C499 a_1607_16# a_1709_16# 0.07813f
C500 pdiv$3_0.div_with_reset$3$2_0.d_flip_flop_reset$1$2_4.NAND_2in_nmosx2$1$1$5_0.a VP 0.13171f
C501 pdiv$3_0.div_with_reset$3$2_0.d_flip_flop_reset$1$2_4.NAND_3in_nmosx3$1$1$3_1.a a_2797_2632# 0.01716f
C502 pdiv$3_0.d_flip_flop_reset$2$2_0.d pdiv$3_0.passgate$3_1.A 0.32774f
C503 pdiv$3_0.div_with_reset$3$2_0.d_flip_flop_reset$1$2_4.NAND_2in_nmosx2$1$1$5_0.b pdiv$3_0.count_data_check$2_0.c1 0.77342f
C504 MUX_8to1_0.in5 a1 0.05046f
C505 MUX_8to1_0.passgate$1$2_0.B pdiv$3_0.div_with_reset$3$2_0.d_flip_flop_reset$1$2_3.NAND_2in_nmosx2$1$1$5_0.y 0.04257f
C506 pdiv$3_0.d_flip_flop_reset$2$2_0.reset out_div 0.1594f
C507 pdiv$3_0.passgate$3_1.A pdiv$3_0.div_with_reset$3$2_0.d_flip_flop_reset$1$2_3.NAND_2in_nmosx2$1$1$5_0.a 1.34887f
C508 2Div$2_0.d_flip_flop$3$2_1.NAND_2in_nmosx2$3$2_0.b VP 0.64743f
C509 MUX_8to1_0.in4 2Div$2_0.d_flip_flop$3$2_6.NAND_2in_nmosx2$3$2_0.b 1.49749f
C510 MUX_8to1_0.inverter_x4_ptap_mirror_fix$2$3_6.OUT VP 0.15581f
C511 a_6702_1847# d1 0.45016f
C512 a_5109_n2600# a_5211_n2600# 0.09808f
C513 VP a2 0.33183f
C514 a_7020_13# d3 0.01014f
C515 pdiv$3_0.count_data_check$2_0.c0 pdiv$3_0.div_with_reset$3$2_0.d_flip_flop_reset$1$2_4.NAND_2in_nmosx2$1$1$5_0.a 0.3883f
C516 pdiv$3_0.d_flip_flop_reset$2$2_0.NAND_3in_nmosx3$1$2$3_1.a a_1553_5248# 0.10805f
C517 a_n7639_n2585# a_n7537_n2585# 0.09425f
C518 pdiv$3_0.count_data_check$2_0.XNOR$1$2_1.y a_7434_3874# 0.07966f
C519 pdiv$3_0.count_data_check$2_0.XNOR$1$2_3.y a_7018_n3434# 0.07813f
C520 pdiv$3_0.count_data_check$2_0.NAND_3in$2_1/NAND_3in_nmosx3$5$1$2_0.y pdiv$3_0.count_data_check$2_0.NAND_3in$2_0/NAND_3in_nmosx3$5$1$2_0.y 0.74773f
C521 pdiv$3_0.count_data_check$2_0.c4 d5 0.058f
C522 MUX_8to1_0.in3 MUX_8to1_0.in4 0.28882f
C523 pdiv$3_0.count_data_check$2_0.c3 a_4803_16# 0.09933f
C524 pdiv$3_0.passgate$3_1.in_p d3 0.01436f
C525 pdiv$3_0.div_with_reset$3$2_0.d_flip_flop_reset$1$2_4.NAND_2in_nmosx2$1$1$5_0.b pdiv$3_0.div_with_reset$3$2_0.d_flip_flop_reset$1$2_3.clk 0.12896f
C526 pdiv$3_0.d_flip_flop_reset$2$2_0.d pdiv$3_0.passgate$3_1.B 0.01301f
C527 MUX_8to1_0.out pdiv$3_0.d_flip_flop_reset$2$2_0.NAND_3in_nmosx3$1$2$3_1.a 0.42817f
C528 2Div$2_0.d_flip_flop$3$2_0.NAND_2in_nmosx2$3$2_0.y a_n8121_3085# 0.09372f
C529 2Div$2_0.d_flip_flop$3$2_4.NAND_2in_nmosx2$3$2_0.b 2Div$2_0.d_flip_flop$3$2_4.NAND_3in_nmosx3$1$2_0.y 0.24214f
C530 a_n2435_5263# a_n2333_5263# 0.09425f
C531 MUX_8to1_0.passgate$1$2_6.in_p MUX_8to1_0.passgate$1$2_6.in_n 0.44409f
C532 a_5109_16# a_5211_16# 0.09808f
C533 VP d0 0.07396f
C534 pdiv$3_0.passgate$3_1.A pdiv$3_0.NOR_2in$3$2_0.A 0.15214f
C535 MUX_8to1_0.inverter_x4_ptap_mirror_fix$2$3_8.OUT MUX_8to1_0.passgate$1$2_0.B 0.66555f
C536 pdiv$3_0.count_data_check$2_0.NAND_3in$2_1/NAND_3in_nmosx3$5$1$2_0.y pdiv$3_0.count_data_check$2_0.XNOR$1$2_4.y 0.16897f
C537 pdiv$3_0.count_data_check$2_0.NAND_3in$2_0/NAND_3in_nmosx3$5$1$2_0.y pdiv$3_0.count_data_check$2_0.XNOR$1$2_1.y 0.55425f
C538 pdiv$3_0.passgate$3_1.A pdiv$3_0.div_with_reset$3$2_0.d_flip_flop_reset$1$2_2.clk 2.69937f
C539 pdiv$3_0.count_data_check$2_0.XNOR$1$2_4.y a_6702_1847# 0.02564f
C540 2Div$2_0.d_flip_flop$3$2_0.d 2Div$2_0.d_flip_flop$3$2_5.d 0.02274f
C541 MUX_8to1_0.passgate$1$2_7.A MUX_8to1_0.passgate$1$2_4.in_n 0.13718f
C542 VP d3 0.15829f
C543 pdiv$3_0.div_with_reset$3$2_0.d_flip_flop_reset$1$2_5.NAND_3in_nmosx3$1$1$3_1.a pdiv$3_0.div_with_reset$3$2_0.d_flip_flop_reset$1$2_3.NAND_2in_nmosx2$1$1$5_0.b 0.0287f
C544 pdiv$3_0.div_with_reset$3$2_0.d_flip_flop_reset$1$2_3.clk pdiv$3_0.div_with_reset$3$2_0.d_flip_flop_reset$1$2_2.NAND_2in_nmosx2$1$1$5_0.y 0.04133f
C545 a_1913_2632# a_2015_2632# 0.09808f
C546 MUX_8to1_0.passgate$1$2_0.B MUX_8to1_0.inverter_x4_ptap_mirror_fix$2$3_10.OUT 0.91875f
C547 2Div$2_0.d_flip_flop$3$2_6.d 2Div$2_0.d_flip_flop$3$2_5.NAND_3in_nmosx3$1$2_0.y 0.0572f
C548 pdiv$3_0.div_with_reset$3$2_0.d_flip_flop_reset$1$2_1.clk a_4803_16# 0.01009f
C549 MUX_8to1_0.inverter_x4_ptap_mirror_fix$2$3_5.OUT MUX_8to1_0.passgate$1$2_6.in_p 0.24659f
C550 pdiv$3_0.count_data_check$2_0.XNOR$1$2_0.y a_7428_n2099# 0.04319f
C551 pdiv$3_0.div_with_reset$3$2_0.d_flip_flop_reset$1$2_3.clk VP 0.27209f
C552 2Div$2_0.d_flip_flop$3$2_6.d 2Div$2_0.d_flip_flop$3$2_6.NAND_2in_nmosx2$3$2_0.a 0.60818f
C553 pdiv$3_0.count_data_check$2_0.c4 VP 1.09302f
C554 pdiv$3_0.count_data_check$2_0.c0 d3 0.02956f
C555 d0 d4 0.07712f
C556 pdiv$3_0.count_data_check$2_0.XNOR$1$2_1.y pdiv$3_0.count_data_check$2_0.XNOR$1$2_4.y 0.64078f
C557 d1 d5 0.13977f
C558 pdiv$3_0.div_with_reset$3$2_0.d_flip_flop_reset$1$2_4.NAND_2in_nmosx2$1$1$5_0.b pdiv$3_0.div_with_reset$3$2_0.d_flip_flop_reset$1$2_4.NAND_2in_nmosx2$1$1$5_0.y 1.24916f
C559 MUX_8to1_0.inverter_x4_ptap_mirror_fix$2$3_10.OUT a1 0.08543f
C560 MUX_8to1_0.passgate$1$2_0.in_p VP 1.06664f
C561 MUX_8to1_0.in8 2Div$2_0.d_flip_flop$3$2_3.d 1.01958f
C562 a_6702_3133# a_6346_3133# 0.2366f
C563 MUX_8to1_0.out pdiv$3_0.div_with_reset$3$2_0.d_flip_flop_reset$1$2_5.NAND_2in_nmosx2$1$1$5_0.b 1.91329f
C564 2Div$2_0.d_flip_flop$3$2_3.NAND_2in_nmosx2$3$2_0.a VP 0.14115f
C565 MUX_8to1_0.passgate$1$2_0.B MUX_8to1_0.passgate$1$2_7.in_n 0.11915f
C566 pdiv$3_0.count_data_check$2_0.c5 d3 0.03198f
C567 pdiv$3_0.div_with_reset$3$2_0.d_flip_flop_reset$1$2_1.clk pdiv$3_0.div_with_reset$3$2_0.d_flip_flop_reset$1$2_1.NAND_2in_nmosx2$1$1$5_0.b 2.28313f
C568 pdiv$3_0.d_flip_flop_reset$2$2_0.NAND_2in_nmosx2$1$2$2_0.y pdiv$3_0.passgate$3_1.B 1.26981f
C569 pdiv$3_0.passgate$3_1.B pdiv$3_0.NOR_2in$3$2_0.A 0.0233f
C570 pdiv$3_0.passgate$3_1.A pdiv$3_0.div_with_reset$3$2_0.d_flip_flop_reset$1$2_2.NAND_2in_nmosx2$1$1$5_0.a 1.34936f
C571 pdiv$3_0.count_data_check$2_0.c3 d0 0.57419f
C572 MUX_8to1_0.passgate$1$2_3.in_p MUX_8to1_0.passgate$1$2_3.in_n 0.44409f
C573 pdiv$3_0.count_data_check$2_0.XNOR$1$2_5.y a_7018_n818# 0.07813f
C574 pdiv$3_0.count_data_check$2_0.XNOR$1$2_3.y a_6346_3133# 0.01368f
C575 MUX_8to1_0.passgate$1$2_4.in_p MUX_8to1_0.passgate$1$2_7.in_p 0.03022f
C576 2Div$2_0.d_flip_flop$3$2_0.d 2Div$2_0.d_flip_flop$3$2_0.NAND_2in_nmosx2$3$2_0.y 0.12448f
C577 2Div$2_0.d_flip_flop$3$2_2.NAND_2in_nmosx2$3$2_0.y 2Div$2_0.d_flip_flop$3$2_2.NAND_2in_nmosx2$3$2_0.b 0.8991f
C578 MUX_8to1_0.passgate$1$2_0.B VP 0.14706f
C579 pdiv$3_0.count_data_check$2_0.c1 a_6702_1847# 1.17512f
C580 MUX_8to1_0.passgate$1$2_4.in_p VP 1.11264f
C581 pdiv$3_0.passgate$3_1.A pdiv$3_0.count_data_check$2_0.c4 2.94844f
C582 2Div$2_0.d_flip_flop$3$2_1.NAND_2in_nmosx2$3$2_0.y a_n5741_3085# 0.09372f
C583 2Div$2_0.d_flip_flop$3$2_0.NAND_2in_nmosx2$3$2_0.a VP 0.13956f
C584 a_6346_1847# a_6702_1847# 0.23656f
C585 a_7020_n2099# d4 0.01014f
C586 pdiv$3_0.count_data_check$2_0.c4 a_6702_n2099# 1.14929f
C587 pdiv$3_0.count_data_check$2_0.XNOR$1$2_2.y d1 0.08647f
C588 pdiv$3_0.div_with_reset$3$2_0.d_flip_flop_reset$1$2_0.NAND_2in_nmosx2$1$1$5_0.b pdiv$3_0.count_data_check$2_0.c5 0.77342f
C589 2Div$2_0.d_flip_flop$3$2_3.NAND_2in_nmosx2$3$2_0.b VP 0.14406f
C590 VP a1 0.16432f
C591 MUX_8to1_0.inverter_x4_ptap_mirror_fix$2$3_7.OUT MUX_8to1_0.inverter_x4_ptap_mirror_fix$2$3_5.OUT 1.75644f
C592 pdiv$3_0.passgate$3_1.in_p VP 0.48417f
C593 MUX_8to1_0.in7 2Div$2_0.d_flip_flop$3$2_4.NAND_2in_nmosx2$3$2_0.a 0.01756f
C594 pdiv$3_0.div_with_reset$3$2_0.d_flip_flop_reset$1$2_4.clk pdiv$3_0.div_with_reset$3$2_0.d_flip_flop_reset$1$2_2.clk 0.03081f
C595 MUX_8to1_0.in3 MUX_8to1_0.in2 0.25703f
C596 pdiv$3_0.count_data_check$2_0.c2 pdiv$3_0.div_with_reset$3$2_0.d_flip_flop_reset$1$2_3.NAND_2in_nmosx2$1$1$5_0.a 1.22533f
C597 pdiv$3_0.div_with_reset$3$2_0.d_flip_flop_reset$1$2_1.NAND_2in_nmosx2$1$1$5_0.a a_825_n2600# 0.02388f
C598 pdiv$3_0.count_data_check$2_0.NAND_3in$2_0/NAND_3in_nmosx3$5$1$2_0.y pdiv$3_0.count_data_check$2_0.XNOR$1$2_2.y 0.13907f
C599 pdiv$3_0.count_data_check$2_0.NAND_3in$2_1/NAND_3in_nmosx3$5$1$2_0.y a_6888_6498# 0.01602f
C600 pdiv$3_0.div_with_reset$3$2_0.d_flip_flop_reset$1$2_1.clk d0 0.07928f
C601 pdiv$3_0.d_flip_flop_reset$2$2_0.d a_n453_5248# 0.02299f
C602 VP 2Div$2_0.d_flip_flop$3$2_2.NAND_2in_nmosx2$3$2_0.b 0.66892f
C603 MUX_8to1_0.in5 2Div$2_0.d_flip_flop$3$2_6.d 1.09888f
C604 pdiv$3_0.div_with_reset$3$2_0.d_flip_flop_reset$1$2_1.NAND_2in_nmosx2$1$1$5_0.b a_n93_n2192# 0.10948f
C605 a_3001_424# a_3103_424# 0.09808f
C606 2Div$2_0.d_flip_flop$3$2_6.NAND_3in_nmosx3$1$2_0.y 2Div$2_0.d_flip_flop$3$2_4.NAND_2in_nmosx2$3$2_0.b 0.01092f
C607 pdiv$3_0.div_with_reset$3$2_0.d_flip_flop_reset$1$2_1.NAND_2in_nmosx2$1$1$5_0.b pdiv$3_0.div_with_reset$3$2_0.d_flip_flop_reset$1$2_1.NAND_2in_nmosx2$1$1$5_0.y 1.24916f
C608 a_7434_1258# VP 0.09529f
C609 pdiv$3_0.div_with_reset$3$2_0.d_flip_flop_reset$1$2_3.NAND_2in_nmosx2$1$1$5_0.a pdiv$3_0.div_with_reset$3$2_0.d_flip_flop_reset$1$2_3.NAND_3in_nmosx3$1$1$3_1.a 1.93937f
C610 pdiv$3_0.NOR_2in$3$2_0.B a_4949_5701# 0.09585f
C611 MUX_8to1_0.passgate$1$2_2.in_n a0 0.0194f
C612 a_n249_5248# a_n147_5248# 0.07813f
C613 MUX_8to1_0.in4 a_n8801_3085# 0.09893f
C614 a_7018_n818# VP 0.09529f
C615 MUX_8to1_0.in3 2Div$2_0.d_flip_flop$3$2_0.NAND_3in_nmosx3$1$2_0.y 0.17792f
C616 pdiv$3_0.div_with_reset$3$2_0.d_flip_flop_reset$1$2_0.NAND_2in_nmosx2$1$1$5_0.b pdiv$3_0.div_with_reset$3$2_0.d_flip_flop_reset$1$2_0.q 0.12861f
C617 a_n5259_5263# a_n5157_5263# 0.09425f
C618 pdiv$3_0.count_data_check$2_0.c4 pdiv$3_0.div_with_reset$3$2_0.d_flip_flop_reset$1$2_1.NAND_3in_nmosx3$1$1$3_1.a 3.09614f
C619 pdiv$3_0.passgate$3_1.A d1 0.03879f
C620 MUX_8to1_0.passgate$1$2_7.in_p a0 0.24566f
C621 pdiv$3_0.div_with_reset$3$2_0.d_flip_flop_reset$1$2_2.NAND_2in_nmosx2$1$1$5_0.b VP 1.20581f
C622 pdiv$3_0.count_data_check$2_0.XNOR$1$2_2.y pdiv$3_0.count_data_check$2_0.XNOR$1$2_4.y 4.39672f
C623 MUX_8to1_0.in3 2Div$2_0.d_flip_flop$3$2_1.NAND_2in_nmosx2$3$2_0.a 0.01756f
C624 MUX_8to1_0.passgate$1$2_6.A MUX_8to1_0.passgate$1$2_6.in_p 0.55648f
C625 pdiv$3_0.count_data_check$2_0.c0 VP 0.73617f
C626 a_7018_1798# VP 0.09529f
C627 VP a0 0.19835f
C628 MUX_8to1_0.in6 a0 0.4141f
C629 2Div$2_0.d_flip_flop$3$2_4.NAND_2in_nmosx2$3$2_0.b VP 0.14417f
C630 pdiv$3_0.d_flip_flop_reset$2$2_0.d MUX_8to1_0.out 1.55931f
C631 2Div$2_0.d_flip_flop$3$2_0.NAND_2in_nmosx2$3$2_0.b 2Div$2_0.d_flip_flop$3$2_0.NAND_2in_nmosx2$3$2_0.a 0.79459f
C632 MUX_8to1_0.in6 MUX_8to1_0.passgate$1$2_1.A 0.49701f
C633 pdiv$3_0.div_with_reset$3$2_0.d_flip_flop_reset$1$2_5.NAND_3in_nmosx3$1$1$3_1.a MUX_8to1_0.passgate$1$2_7.in_p 0.01211f
C634 2Div$2_0.d_flip_flop$3$2_2.NAND_3in_nmosx3$1$2_0.y 2Div$2_0.d_flip_flop$3$2_1.NAND_2in_nmosx2$3$2_0.b 0.01092f
C635 2Div$2_0.d_flip_flop$3$2_1.NAND_3in_nmosx3$1$2_0.y MUX_8to1_0.in5 0.12128f
C636 2Div$2_0.d_flip_flop$3$2_2.d MUX_8to1_0.in2 1.01959f
C637 pdiv$3_0.count_data_check$2_0.c1 d5 0.05592f
C638 pdiv$3_0.passgate$3_1.A pdiv$3_0.count_data_check$2_0.NAND_3in$2_0/NAND_3in_nmosx3$5$1$2_0.y 0.09953f
C639 2Div$2_0.d_flip_flop$3$2_3.d a_n9141_n2585# 0.09386f
C640 pdiv$3_0.div_with_reset$3$2_0.d_flip_flop_reset$1$2_4.NAND_2in_nmosx2$1$1$5_0.b pdiv$3_0.div_with_reset$3$2_0.d_flip_flop_reset$1$2_4.NAND_3in_nmosx3$1$1$3_1.a 0.80223f
C641 pdiv$3_0.count_data_check$2_0.c2 pdiv$3_0.div_with_reset$3$2_0.d_flip_flop_reset$1$2_2.clk 1.7297f
C642 pdiv$3_0.div_with_reset$3$2_0.d_flip_flop_reset$1$2_4.NAND_2in_nmosx2$1$1$5_0.b a_3103_3040# 0.10948f
C643 MUX_8to1_0.inverter_x4_ptap_mirror_fix$2$3_7.OUT MUX_8to1_0.passgate$1$2_7.A 0.05308f
C644 pdiv$3_0.div_with_reset$3$2_0.d_flip_flop_reset$1$2_5.NAND_2in_nmosx2$1$1$5_0.a a_597_3040# 0.01596f
C645 a_n501_n2192# a_n399_n2192# 0.07813f
C646 MUX_8to1_0.passgate$1$2_1.A a0 0.636f
C647 a_7434_n3434# VP 0.09529f
C648 pdiv$3_0.div_with_reset$3$2_0.d_flip_flop_reset$1$2_3.NAND_2in_nmosx2$1$1$5_0.a a_825_16# 0.02388f
C649 MUX_8to1_0.inverter_x4_ptap_mirror_fix$2$3_6.OUT VP 0.57067f
C650 a_n2435_2647# a_n2333_2647# 0.09425f
C651 pdiv$3_0.div_with_reset$3$2_0.d_flip_flop_reset$1$2_5.NAND_2in_nmosx2$1$1$5_0.b a_n399_3040# 0.01781f
C652 pdiv$3_0.div_with_reset$3$2_0.d_flip_flop_reset$1$2_2.clk pdiv$3_0.div_with_reset$3$2_0.d_flip_flop_reset$1$2_3.NAND_3in_nmosx3$1$1$3_1.a 1.43515f
C653 pdiv$3_0.count_data_check$2_0.c2 a_1709_16# 0.01875f
C654 MUX_8to1_0.in6 MUX_8to1_0.passgate$1$2_0.A 0.07535f
C655 pdiv$3_0.count_data_check$2_0.c0 pdiv$3_0.div_with_reset$3$2_0.d_flip_flop_reset$1$2_5.NAND_3in_nmosx3$1$1$3_1.a 3.09614f
C656 pdiv$3_0.d_flip_flop_reset$2$2_0.NAND_2in_nmosx2$1$2$2_0.a out_div 0.02037f
C657 pdiv$3_0.div_with_reset$3$2_0.d_flip_flop_reset$1$2_3.NAND_3in_nmosx3$1$1$3_1.a a_n195_16# 0.02003f
C658 2Div$2_0.d_flip_flop$3$2_5.NAND_2in_nmosx2$3$2_0.y VP 0.42832f
C659 pdiv$3_0.div_with_reset$3$2_0.d_flip_flop_reset$1$2_2.NAND_2in_nmosx2$1$1$5_0.b pdiv$3_0.count_data_check$2_0.c3 0.77342f
C660 2Div$2_0.d_flip_flop$3$2_0.NAND_2in_nmosx2$3$2_0.b VP 0.66486f
C661 a_n501_n2600# a_n399_n2600# 0.07813f
C662 VP a2 0.38049f
C663 pdiv$3_0.count_data_check$2_0.XNOR$1$2_2.y pdiv$3_0.count_data_check$2_0.c1 0.37741f
C664 a_6702_3133# d0 0.45199f
C665 MUX_8to1_0.inverter_x4_ptap_mirror_fix$2$3_7.OUT MUX_8to1_0.passgate$1$2_6.A 0.12208f
C666 pdiv$3_0.div_with_reset$3$2_0.d_flip_flop_reset$1$2_2.NAND_3in_nmosx3$1$1$3_1.a a_3001_16# 0.02003f
C667 pdiv$3_0.count_data_check$2_0.XNOR$1$2_2.y a_6346_1847# 0.2941f
C668 a_6346_n2099# a_7434_n1358# 0.01178f
C669 pdiv$3_0.d_flip_flop_reset$2$2_0.reset VP 0.44899f
C670 MUX_8to1_0.inverter_x4_ptap_mirror_fix$2$3_6.OUT MUX_8to1_0.in3 0.0358f
C671 MUX_8to1_0.passgate$1$2_0.A a0 0.43511f
C672 2Div$2_0.d_flip_flop$3$2_5.NAND_2in_nmosx2$3$2_0.a 2Div$2_0.d_flip_flop$3$2_3.NAND_2in_nmosx2$3$2_0.b 0.03614f
C673 pdiv$3_0.div_with_reset$3$2_0.d_flip_flop_reset$1$2_1.NAND_3in_nmosx3$1$1$3_1.a a_n399_n2600# 0.01716f
C674 pdiv$3_0.d_flip_flop_reset$2$2_0.NAND_2in_nmosx2$1$2$2_0.y MUX_8to1_0.out 0.13232f
C675 pdiv$3_0.count_data_check$2_0.c2 pdiv$3_0.div_with_reset$3$2_0.d_flip_flop_reset$1$2_2.NAND_2in_nmosx2$1$1$5_0.a 0.3883f
C676 pdiv$3_0.d_flip_flop_reset$2$2_0.d VP 0.19253f
C677 MUX_8to1_0.passgate$1$2_1.A MUX_8to1_0.passgate$1$2_0.A 0.06769f
C678 MUX_8to1_0.inverter_x4_ptap_mirror_fix$2$3_5.OUT VP 0.14832f
C679 pdiv$3_0.div_with_reset$3$2_0.d_flip_flop_reset$1$2_3.NAND_2in_nmosx2$1$1$5_0.b pdiv$3_0.div_with_reset$3$2_0.d_flip_flop_reset$1$2_3.NAND_2in_nmosx2$1$1$5_0.y 1.24916f
C680 pdiv$3_0.div_with_reset$3$2_0.d_flip_flop_reset$1$2_0.NAND_3in_nmosx3$1$1$3_1.a a_2797_n2600# 0.01716f
C681 pdiv$3_0.div_with_reset$3$2_0.d_flip_flop_reset$1$2_1.NAND_2in_nmosx2$1$1$5_0.b pdiv$3_0.div_with_reset$3$2_0.d_flip_flop_reset$1$2_0.NAND_2in_nmosx2$1$1$5_0.y 0.04918f
C682 pdiv$3_0.d_flip_flop_reset$2$2_0.NAND_2in_nmosx2$1$2$2_0.b MUX_8to1_0.passgate$1$2_0.B 0.0231f
C683 VP d4 0.0247f
C684 a_n501_16# a_n399_16# 0.07813f
C685 pdiv$3_0.div_with_reset$3$2_0.d_flip_flop_reset$1$2_2.NAND_2in_nmosx2$1$1$5_0.b pdiv$3_0.div_with_reset$3$2_0.d_flip_flop_reset$1$2_1.clk 0.12896f
C686 pdiv$3_0.count_data_check$2_0.c5 pdiv$3_0.div_with_reset$3$2_0.d_flip_flop_reset$1$2_0.q 1.11963f
C687 pdiv$3_0.passgate$3_1.A pdiv$3_0.div_with_reset$3$2_0.d_flip_flop_reset$1$2_5.NAND_2in_nmosx2$1$1$5_0.y 0.26625f
C688 2Div$2_0.d_flip_flop$3$2_2.NAND_2in_nmosx2$3$2_0.a a_n6013_5263# 0.09722f
C689 pdiv$3_0.count_data_check$2_0.c5 a_6702_n3385# 1.18578f
C690 2Div$2_0.d_flip_flop$3$2_0.d a_n9141_2647# 0.09386f
C691 pdiv$3_0.count_data_check$2_0.c3 VP 0.18787f
C692 pdiv$3_0.div_with_reset$3$2_0.d_flip_flop_reset$1$2_3.NAND_3in_nmosx3$1$1$3_1.a pdiv$3_0.count_data_check$2_0.c4 0.01001f
C693 pdiv$3_0.div_with_reset$3$2_0.d_flip_flop_reset$1$2_0.q a_4541_n2192# 0.10178f
C694 a_3001_n2600# a_3103_n2600# 0.09808f
C695 pdiv$3_0.passgate$3_1.A pdiv$3_0.count_data_check$2_0.c1 2.45808f
C696 2Div$2_0.d_flip_flop$3$2_3.NAND_2in_nmosx2$3$2_0.b MUX_8to1_0.in8 0.41307f
C697 pdiv$3_0.passgate$3_1.in_p pdiv$3_0.passgate$3_1.in_n 0.95555f
C698 2Div$2_0.d_flip_flop$3$2_6.d VP 0.54953f
C699 pdiv$3_0.div_with_reset$3$2_0.d_flip_flop_reset$1$2_5.NAND_2in_nmosx2$1$1$5_0.y pdiv$3_0.div_with_reset$3$2_0.d_flip_flop_reset$1$2_5.NAND_2in_nmosx2$1$1$5_0.a 0.32406f
C700 MUX_8to1_0.in6 2Div$2_0.d_flip_flop$3$2_5.NAND_3in_nmosx3$1$2_0.y 0.77439f
C701 MUX_8to1_0.inverter_x4_ptap_mirror_fix$2$3_8.OUT MUX_8to1_0.passgate$1$2_3.in_n 0.26032f
C702 MUX_8to1_0.passgate$1$2_5.A MUX_8to1_0.passgate$1$2_5.in_n 0.55121f
C703 2Div$2_0.d_flip_flop$3$2_1.d VP 0.54959f
C704 2Div$2_0.d_flip_flop$3$2_3.NAND_2in_nmosx2$3$2_0.a VP 0.48882f
C705 pdiv$3_0.d_flip_flop_reset$2$2_0.NAND_2in_nmosx2$1$2$2_0.y VP 0.61121f
C706 MUX_8to1_0.in7 2Div$2_0.d_flip_flop$3$2_3.d 0.01219f
C707 MUX_8to1_0.in6 2Div$2_0.d_flip_flop$3$2_6.NAND_2in_nmosx2$3$2_0.a 0.13681f
C708 pdiv$3_0.div_with_reset$3$2_0.d_flip_flop_reset$1$2_4.NAND_2in_nmosx2$1$1$5_0.b pdiv$3_0.div_with_reset$3$2_0.d_flip_flop_reset$1$2_4.NAND_2in_nmosx2$1$1$5_0.a 0.99113f
C709 pdiv$3_0.count_data_check$2_0.c3 d4 0.03075f
C710 a_6346_n769# d3 0.94916f
C711 MUX_8to1_0.passgate$1$2_5.in_p MUX_8to1_0.passgate$1$2_5.in_n 0.44557f
C712 a_6702_517# a_6346_517# 0.2366f
C713 pdiv$3_0.count_data_check$2_0.c2 d1 0.03797f
C714 a_3001_16# a_3103_16# 0.09808f
C715 pdiv$3_0.div_with_reset$3$2_0.d_flip_flop_reset$1$2_1.clk VP 0.34453f
C716 pdiv$3_0.count_data_check$2_0.XNOR$1$2_3.y a_7020_n2603# 0.04296f
C717 MUX_8to1_0.in8 2Div$2_0.d_flip_flop$3$2_4.NAND_2in_nmosx2$3$2_0.y 0.13404f
C718 pdiv$3_0.d_flip_flop_reset$2$2_0.NAND_2in_nmosx2$1$2$2_0.a a_941_5248# 0.10117f
C719 pdiv$3_0.passgate$3_1.A pdiv$3_0.div_with_reset$3$2_0.d_flip_flop_reset$1$2_3.clk 3.05645f
C720 MUX_8to1_0.passgate$1$2_0.B VP 0.03399f
C721 MUX_8to1_0.inverter_x4_ptap_mirror_fix$2$3_6.OUT MUX_8to1_0.passgate$1$2_6.in_p 0.09046f
C722 pdiv$3_0.count_data_check$2_0.XNOR$1$2_0.y VP 0.13185f
C723 a_6346_3133# a_7434_3874# 0.01178f
C724 a_n195_2632# a_n93_2632# 0.09808f
C725 pdiv$3_0.count_data_check$2_0.XNOR$1$2_0.y a_7018_n1358# 0.07813f
C726 a_n5259_2647# a_n5157_2647# 0.09425f
C727 MUX_8to1_0.passgate$1$2_6.in_p a2 0.13932f
C728 MUX_8to1_0.in3 2Div$2_0.d_flip_flop$3$2_0.d 0.01219f
C729 MUX_8to1_0.in8 2Div$2_0.d_flip_flop$3$2_4.NAND_2in_nmosx2$3$2_0.b 0.25413f
C730 MUX_8to1_0.passgate$1$2_5.A pdiv$3_0.d_flip_flop_reset$2$2_0.d 0.01029f
C731 2Div$2_0.d_flip_flop$3$2_4.NAND_2in_nmosx2$3$2_0.a a_n6013_n2585# 0.09722f
C732 MUX_8to1_0.passgate$1$2_5.A MUX_8to1_0.inverter_x4_ptap_mirror_fix$2$3_5.OUT 0.19313f
C733 pdiv$3_0.count_data_check$2_0.c3 a_6702_n769# 1.17443f
C734 VP a1 0.35521f
C735 clk 2Div$2_0.d_flip_flop$3$2_2.NAND_2in_nmosx2$3$2_0.b 1.50526f
C736 a_6702_517# d2 0.45247f
C737 2Div$2_0.d_flip_flop$3$2_3.NAND_2in_nmosx2$3$2_0.a a_n8121_n2147# 0.01293f
C738 2Div$2_0.d_flip_flop$3$2_2.NAND_3in_nmosx3$1$2_0.y VP 0.775f
C739 pdiv$3_0.div_with_reset$3$2_0.d_flip_flop_reset$1$2_5.NAND_2in_nmosx2$1$1$5_0.a pdiv$3_0.div_with_reset$3$2_0.d_flip_flop_reset$1$2_3.clk 0.2706f
C740 pdiv$3_0.count_data_check$2_0.XNOR$1$2_5.y d3 0.08654f
C741 pdiv$3_0.div_with_reset$3$2_0.d_flip_flop_reset$1$2_5.NAND_2in_nmosx2$1$1$5_0.y pdiv$3_0.div_with_reset$3$2_0.d_flip_flop_reset$1$2_4.clk 0.05581f
C742 MUX_8to1_0.passgate$1$2_0.in_n MUX_8to1_0.passgate$1$2_2.in_n 0.06425f
C743 pdiv$3_0.d_flip_flop_reset$2$2_0.d MUX_8to1_0.passgate$1$2_5.in_p 0.01316f
C744 MUX_8to1_0.passgate$1$2_0.B MUX_8to1_0.passgate$1$2_4.in_n 0.1563f
C745 pdiv$3_0.div_with_reset$3$2_0.d_flip_flop_reset$1$2_3.NAND_2in_nmosx2$1$1$5_0.b pdiv$3_0.div_with_reset$3$2_0.d_flip_flop_reset$1$2_2.NAND_2in_nmosx2$1$1$5_0.y 0.04918f
C746 2Div$2_0.d_flip_flop$3$2_0.NAND_2in_nmosx2$3$2_0.y 2Div$2_0.d_flip_flop$3$2_1.NAND_2in_nmosx2$3$2_0.b 0.0115f
C747 2Div$2_0.d_flip_flop$3$2_0.NAND_3in_nmosx3$1$2_0.y 2Div$2_0.d_flip_flop$3$2_5.NAND_2in_nmosx2$3$2_0.b 0.02754f
C748 pdiv$3_0.passgate$3_1.A MUX_8to1_0.passgate$1$2_0.B 0.06063f
C749 2Div$2_0.d_flip_flop$3$2_2.NAND_2in_nmosx2$3$2_0.y MUX_8to1_0.in2 0.19592f
C750 MUX_8to1_0.inverter_x4_ptap_mirror_fix$2$3_6.OUT MUX_8to1_0.passgate$1$2_1.in_p 0.09047f
C751 MUX_8to1_0.passgate$1$2_2.in_p VP 1.11298f
C752 pdiv$3_0.count_data_check$2_0.NAND_3in$2_0/NAND_3in_nmosx3$5$1$2_0.y a_6346_3133# 0.01457f
C753 pdiv$3_0.div_with_reset$3$2_0.d_flip_flop_reset$1$2_4.clk pdiv$3_0.count_data_check$2_0.c1 0.01299f
C754 pdiv$3_0.count_data_check$2_0.XNOR$1$2_4.y pdiv$3_0.count_data_check$2_0.c2 0.36157f
C755 pdiv$3_0.NOR_2in$3$2_0.A d0 0.13959f
C756 d2 d3 11.6903f
C757 pdiv$3_0.count_data_check$2_0.c3 pdiv$3_0.div_with_reset$3$2_0.d_flip_flop_reset$1$2_1.clk 1.48512f
C758 pdiv$3_0.passgate$3_1.A pdiv$3_0.div_with_reset$3$2_0.d_flip_flop_reset$1$2_4.NAND_2in_nmosx2$1$1$5_0.y 0.2633f
C759 MUX_8to1_0.passgate$1$2_1.in_p a2 0.13936f
C760 pdiv$3_0.div_with_reset$3$2_0.d_flip_flop_reset$1$2_3.NAND_2in_nmosx2$1$1$5_0.b VP 0.26791f
C761 MUX_8to1_0.in4 MUX_8to1_0.in7 0.06471f
C762 MUX_8to1_0.in5 MUX_8to1_0.in6 0.27792f
C763 pdiv$3_0.NOR_2in$3$2_0.B d3 0.09f
C764 MUX_8to1_0.in8 a2 0.04974f
C765 2Div$2_0.d_flip_flop$3$2_4.d 2Div$2_0.d_flip_flop$3$2_4.NAND_2in_nmosx2$3$2_0.y 0.12448f
C766 pdiv$3_0.count_data_check$2_0.c4 pdiv$3_0.div_with_reset$3$2_0.d_flip_flop_reset$1$2_1.NAND_2in_nmosx2$1$1$5_0.b 1.22588f
C767 MUX_8to1_0.inverter_x4_ptap_mirror_fix$2$3_6.OUT MUX_8to1_0.inverter_x4_ptap_mirror_fix$2$3_7.OUT 11.6193f
C768 a_3715_2632# a_3817_2632# 0.07813f
C769 pdiv$3_0.div_with_reset$3$2_0.d_flip_flop_reset$1$2_5.NAND_2in_nmosx2$1$1$5_0.b VP 0.26791f
C770 pdiv$3_0.d_flip_flop_reset$2$2_0.reset pdiv$3_0.passgate$3_1.in_n 0.21278f
C771 pdiv$3_0.div_with_reset$3$2_0.d_flip_flop_reset$1$2_0.NAND_2in_nmosx2$1$1$5_0.b pdiv$3_0.div_with_reset$3$2_0.d_flip_flop_reset$1$2_0.clk 2.0105f
C772 MUX_8to1_0.inverter_x4_ptap_mirror_fix$2$3_7.OUT a2 0.54241f
C773 2Div$2_0.d_flip_flop$3$2_4.NAND_2in_nmosx2$3$2_0.b 2Div$2_0.d_flip_flop$3$2_4.d 0.81289f
C774 VP MUX_8to1_0.in2 0.53263f
C775 pdiv$3_0.count_data_check$2_0.XNOR$1$2_5.y a_7020_13# 0.04296f
C776 pdiv$3_0.div_with_reset$3$2_0.d_flip_flop_reset$1$2_4.NAND_2in_nmosx2$1$1$5_0.y a_3793_3040# 0.1016f
C777 pdiv$3_0.div_with_reset$3$2_0.d_flip_flop_reset$1$2_4.clk pdiv$3_0.div_with_reset$3$2_0.d_flip_flop_reset$1$2_3.clk 0.03819f
C778 pdiv$3_0.count_data_check$2_0.c1 a_5211_2632# 0.1084f
C779 pdiv$3_0.div_with_reset$3$2_0.d_flip_flop_reset$1$2_4.NAND_2in_nmosx2$1$1$5_0.a a_4021_2632# 0.02388f
C780 a_n2435_5701# a_n2333_5701# 0.09425f
C781 VP d3 0.58975f
C782 pdiv$3_0.d_flip_flop_reset$2$2_0.NAND_2in_nmosx2$1$2$2_0.b out_div 0.12861f
C783 2Div$2_0.d_flip_flop$3$2_4.NAND_2in_nmosx2$3$2_0.a a_n5741_n2147# 0.01293f
C784 2Div$2_0.d_flip_flop$3$2_1.NAND_2in_nmosx2$3$2_0.a a_n6013_2647# 0.09722f
C785 a_n501_424# a_n399_424# 0.07813f
C786 MUX_8to1_0.passgate$1$2_6.in_n MUX_8to1_0.passgate$1$2_1.in_n 0.06425f
C787 VP d1 0.13818f
C788 MUX_8to1_0.inverter_x4_ptap_mirror_fix$2$3_10.OUT MUX_8to1_0.passgate$1$2_4.in_p 0.55648f
C789 pdiv$3_0.count_data_check$2_0.c1 pdiv$3_0.count_data_check$2_0.c2 0.14217f
C790 pdiv$3_0.div_with_reset$3$2_0.d_flip_flop_reset$1$2_2.NAND_2in_nmosx2$1$1$5_0.b pdiv$3_0.div_with_reset$3$2_0.d_flip_flop_reset$1$2_0.NAND_2in_nmosx2$1$1$5_0.y 0.01266f
C791 MUX_8to1_0.inverter_x4_ptap_mirror_fix$2$3_5.OUT MUX_8to1_0.inverter_x4_ptap_mirror_fix$2$3_4.OUT 0.03627f
C792 pdiv$3_0.div_with_reset$3$2_0.d_flip_flop_reset$1$2_0.NAND_2in_nmosx2$1$1$5_0.b pdiv$3_0.div_with_reset$3$2_0.d_flip_flop_reset$1$2_0.NAND_3in_nmosx3$1$1$3_1.a 0.80223f
C793 pdiv$3_0.count_data_check$2_0.c4 d0 0.1429f
C794 pdiv$3_0.div_with_reset$3$2_0.d_flip_flop_reset$1$2_0.NAND_2in_nmosx2$1$1$5_0.b a_3103_n2192# 0.10948f
C795 pdiv$3_0.div_with_reset$3$2_0.d_flip_flop_reset$1$2_1.NAND_2in_nmosx2$1$1$5_0.a a_597_n2192# 0.01596f
C796 MUX_8to1_0.passgate$1$2_0.A MUX_8to1_0.passgate$1$2_0.in_n 0.26033f
C797 pdiv$3_0.div_with_reset$3$2_0.d_flip_flop_reset$1$2_0.NAND_2in_nmosx2$1$1$5_0.b pdiv$3_0.div_with_reset$3$2_0.d_flip_flop_reset$1$2_0.NAND_2in_nmosx2$1$1$5_0.a 0.99113f
C798 a_4949_5701# a_5051_5701# 0.09425f
C799 MUX_8to1_0.passgate$1$2_0.B MUX_8to1_0.passgate$1$2_6.in_p 0.05707f
C800 pdiv$3_0.passgate$3_1.in_p d2 0.04345f
C801 pdiv$3_0.div_with_reset$3$2_0.d_flip_flop_reset$1$2_1.NAND_2in_nmosx2$1$1$5_0.a a_519_n2600# 0.10117f
C802 pdiv$3_0.div_with_reset$3$2_0.d_flip_flop_reset$1$2_0.NAND_2in_nmosx2$1$1$5_0.b VP 1.20581f
C803 pdiv$3_0.count_data_check$2_0.NAND_3in$2_0/NAND_3in_nmosx3$5$1$2_0.y VP 0.11663f
C804 pdiv$3_0.div_with_reset$3$2_0.d_flip_flop_reset$1$2_1.NAND_2in_nmosx2$1$1$5_0.b a_n399_n2192# 0.01781f
C805 pdiv$3_0.count_data_check$2_0.XNOR$1$2_5.y VP 0.12728f
C806 pdiv$3_0.passgate$3_1.in_p pdiv$3_0.NOR_2in$3$2_0.B 0.39923f
C807 MUX_8to1_0.passgate$1$2_1.in_p MUX_8to1_0.passgate$1$2_0.in_p 0.07295f
C808 a_6346_n2099# d4 0.95024f
C809 pdiv$3_0.div_with_reset$3$2_0.d_flip_flop_reset$1$2_1.NAND_3in_nmosx3$1$1$3_1.a MUX_8to1_0.passgate$1$2_2.in_p 0.01221f
C810 a_n6761_5263# MUX_8to1_0.in2 0.01677f
C811 a_6346_3133# a_6346_1847# 0.13417f
C812 pdiv$3_0.div_with_reset$3$2_0.d_flip_flop_reset$1$2_4.clk pdiv$3_0.div_with_reset$3$2_0.d_flip_flop_reset$1$2_4.NAND_2in_nmosx2$1$1$5_0.y 1.27386f
C813 MUX_8to1_0.passgate$1$2_6.in_n VP 0.21018f
C814 pdiv$3_0.div_with_reset$3$2_0.d_flip_flop_reset$1$2_3.NAND_2in_nmosx2$1$1$5_0.b a_n195_424# 0.02373f
C815 MUX_8to1_0.in8 2Div$2_0.d_flip_flop$3$2_3.NAND_2in_nmosx2$3$2_0.a 0.14593f
C816 MUX_8to1_0.out pdiv$3_0.div_with_reset$3$2_0.d_flip_flop_reset$1$2_5.NAND_2in_nmosx2$1$1$5_0.y 1.28173f
C817 pdiv$3_0.d_flip_flop_reset$2$2_0.NAND_2in_nmosx2$1$2$2_0.a VP 1.04155f
C818 2Div$2_0.d_flip_flop$3$2_5.NAND_2in_nmosx2$3$2_0.b a_n7509_469# 0.09898f
C819 VP d2 0.01982f
C820 MUX_8to1_0.inverter_x4_ptap_mirror_fix$2$3_10.OUT VP 0.81424f
C821 pdiv$3_0.div_with_reset$3$2_0.d_flip_flop_reset$1$2_1.clk pdiv$3_0.div_with_reset$3$2_0.d_flip_flop_reset$1$2_1.NAND_2in_nmosx2$1$1$5_0.y 1.30841f
C822 pdiv$3_0.div_with_reset$3$2_0.d_flip_flop_reset$1$2_3.clk pdiv$3_0.count_data_check$2_0.c2 0.11334f
C823 MUX_8to1_0.in6 2Div$2_0.d_flip_flop$3$2_5.d 1.01958f
C824 pdiv$3_0.div_with_reset$3$2_0.d_flip_flop_reset$1$2_4.NAND_2in_nmosx2$1$1$5_0.b VP 1.20115f
C825 pdiv$3_0.NOR_2in$3$2_0.B VP 0.12177f
C826 MUX_8to1_0.inverter_x4_ptap_mirror_fix$2$3_7.OUT MUX_8to1_0.passgate$1$2_0.in_p 0.16801f
C827 2Div$2_0.d_flip_flop$3$2_6.d 2Div$2_0.d_flip_flop$3$2_6.NAND_3in_nmosx3$1$2_0.y 1.35806f
C828 a_6702_1847# a_6702_517# 0.10824f
C829 MUX_8to1_0.inverter_x4_ptap_mirror_fix$2$3_8.OUT a0 0.01069f
C830 MUX_8to1_0.passgate$1$2_0.B MUX_8to1_0.passgate$1$2_1.in_p 0.0652f
C831 pdiv$3_0.count_data_check$2_0.XNOR$1$2_4.y VP 0.12467f
C832 2Div$2_0.d_flip_flop$3$2_0.NAND_2in_nmosx2$3$2_0.a 2Div$2_0.d_flip_flop$3$2_0.NAND_2in_nmosx2$3$2_0.y 0.44392f
C833 2Div$2_0.d_flip_flop$3$2_6.d 2Div$2_0.d_flip_flop$3$2_6.NAND_2in_nmosx2$3$2_0.y 0.12448f
C834 MUX_8to1_0.passgate$1$2_7.in_p MUX_8to1_0.passgate$1$2_7.in_n 0.44557f
C835 MUX_8to1_0.inverter_x4_ptap_mirror_fix$2$3_5.OUT VP 0.16316f
C836 pdiv$3_0.passgate$3_1.A pdiv$3_0.div_with_reset$3$2_0.d_flip_flop_reset$1$2_4.NAND_3in_nmosx3$1$1$3_1.a 2.0499f
C837 a_4949_5263# a_5051_5263# 0.09425f
C838 pdiv$3_0.count_data_check$2_0.c0 d2 0.02959f
C839 pdiv$3_0.div_with_reset$3$2_0.d_flip_flop_reset$1$2_3.NAND_2in_nmosx2$1$1$5_0.a VP 0.13189f
C840 d0 d1 12.3136f
C841 pdiv$3_0.div_with_reset$3$2_0.d_flip_flop_reset$1$2_3.clk pdiv$3_0.div_with_reset$3$2_0.d_flip_flop_reset$1$2_3.NAND_3in_nmosx3$1$1$3_1.a 0.55611f
C842 a_1553_5248# a_1655_5248# 0.09808f
C843 2Div$2_0.d_flip_flop$3$2_3.NAND_2in_nmosx2$3$2_0.y VP 0.42832f
C844 MUX_8to1_0.inverter_x4_ptap_mirror_fix$2$3_10.OUT a0 0.45203f
C845 pdiv$3_0.div_with_reset$3$2_0.d_flip_flop_reset$1$2_2.NAND_2in_nmosx2$1$1$5_0.b pdiv$3_0.div_with_reset$3$2_0.d_flip_flop_reset$1$2_2.clk 2.0105f
C846 a_n195_3040# a_n93_3040# 0.09808f
C847 pdiv$3_0.count_data_check$2_0.c0 pdiv$3_0.div_with_reset$3$2_0.d_flip_flop_reset$1$2_4.NAND_2in_nmosx2$1$1$5_0.b 0.46048f
C848 pdiv$3_0.div_with_reset$3$2_0.d_flip_flop_reset$1$2_0.clk pdiv$3_0.count_data_check$2_0.c5 0.01299f
C849 MUX_8to1_0.passgate$1$2_5.A MUX_8to1_0.in2 0.49668f
C850 a_115_5656# out_div 0.10178f
C851 2Div$2_0.d_flip_flop$3$2_6.NAND_2in_nmosx2$3$2_0.b 2Div$2_0.d_flip_flop$3$2_6.d 0.81289f
C852 pdiv$3_0.div_with_reset$3$2_0.d_flip_flop_reset$1$2_4.NAND_2in_nmosx2$1$1$5_0.b a_2797_3040# 0.01781f
C853 MUX_8to1_0.in7 2Div$2_0.d_flip_flop$3$2_3.NAND_2in_nmosx2$3$2_0.b 1.55875f
C854 pdiv$3_0.count_data_check$2_0.c5 d2 0.03298f
C855 MUX_8to1_0.inverter_x4_ptap_mirror_fix$2$3_7.OUT MUX_8to1_0.passgate$1$2_0.B 0.03424f
C856 MUX_8to1_0.inverter_x4_ptap_mirror_fix$2$3_6.OUT VP 0.14129f
C857 pdiv$3_0.div_with_reset$3$2_0.d_flip_flop_reset$1$2_2.clk a_1345_424# 0.10178f
C858 pdiv$3_0.passgate$3_1.in_p reset 0.02133f
C859 pdiv$3_0.div_with_reset$3$2_0.d_flip_flop_reset$1$2_3.NAND_2in_nmosx2$1$1$5_0.a a_519_16# 0.10117f
C860 MUX_8to1_0.in6 VP 0.43095f
C861 pdiv$3_0.div_with_reset$3$2_0.d_flip_flop_reset$1$2_2.NAND_3in_nmosx3$1$1$3_1.a d3 0.0111f
C862 MUX_8to1_0.in5 2Div$2_0.d_flip_flop$3$2_5.NAND_3in_nmosx3$1$2_0.y 0.17792f
C863 a_7018_n1358# VP 0.09529f
C864 MUX_8to1_0.passgate$1$2_7.in_n a0 0.01619f
C865 MUX_8to1_0.out pdiv$3_0.div_with_reset$3$2_0.d_flip_flop_reset$1$2_3.clk 0.07561f
C866 MUX_8to1_0.inverter_x4_ptap_mirror_fix$2$3_7.OUT a1 1.68758f
C867 2Div$2_0.d_flip_flop$3$2_3.NAND_2in_nmosx2$3$2_0.a 2Div$2_0.d_flip_flop$3$2_4.d 0.01074f
C868 2Div$2_0.d_flip_flop$3$2_0.NAND_2in_nmosx2$3$2_0.y VP 0.42361f
C869 pdiv$3_0.div_with_reset$3$2_0.d_flip_flop_reset$1$2_3.NAND_3in_nmosx3$1$1$3_1.a a_n501_16# 0.09877f
C870 MUX_8to1_0.in5 2Div$2_0.d_flip_flop$3$2_6.NAND_2in_nmosx2$3$2_0.a 0.01756f
C871 2Div$2_0.d_flip_flop$3$2_4.NAND_3in_nmosx3$1$2_0.y a_n5259_n2585# 0.09585f
C872 MUX_8to1_0.in4 VP 0.43243f
C873 a_2695_n2192# a_2797_n2192# 0.07813f
C874 pdiv$3_0.div_with_reset$3$2_0.d_flip_flop_reset$1$2_5.NAND_3in_nmosx3$1$1$3_1.a MUX_8to1_0.passgate$1$2_7.in_n 0.01754f
C875 pdiv$3_0.div_with_reset$3$2_0.d_flip_flop_reset$1$2_3.NAND_2in_nmosx2$1$1$5_0.y a_597_424# 0.1016f
C876 pdiv$3_0.div_with_reset$3$2_0.d_flip_flop_reset$1$2_2.NAND_3in_nmosx3$1$1$3_1.a a_2695_16# 0.09877f
C877 pdiv$3_0.count_data_check$2_0.c5 pdiv$3_0.div_with_reset$3$2_0.d_flip_flop_reset$1$2_0.NAND_3in_nmosx3$1$1$3_1.a 2.6514f
C878 VP a0 0.19473f
C879 pdiv$3_0.div_with_reset$3$2_0.d_flip_flop_reset$1$2_2.NAND_2in_nmosx2$1$1$5_0.b pdiv$3_0.div_with_reset$3$2_0.d_flip_flop_reset$1$2_2.NAND_2in_nmosx2$1$1$5_0.a 0.99113f
C880 2Div$2_0.d_flip_flop$3$2_0.d 2Div$2_0.d_flip_flop$3$2_5.NAND_2in_nmosx2$3$2_0.b 0.02151f
C881 MUX_8to1_0.inverter_x4_ptap_mirror_fix$2$3_7.OUT MUX_8to1_0.passgate$1$2_2.in_p 0.19544f
C882 pdiv$3_0.div_with_reset$3$2_0.d_flip_flop_reset$1$2_0.NAND_2in_nmosx2$1$1$5_0.a pdiv$3_0.count_data_check$2_0.c5 0.84133f
C883 2Div$2_0.d_flip_flop$3$2_1.NAND_3in_nmosx3$1$2_0.y 2Div$2_0.d_flip_flop$3$2_6.NAND_2in_nmosx2$3$2_0.b 0.01092f
C884 MUX_8to1_0.passgate$1$2_1.A VP 0.06518f
C885 pdiv$3_0.div_with_reset$3$2_0.d_flip_flop_reset$1$2_2.NAND_3in_nmosx3$1$1$3_1.a pdiv$3_0.div_with_reset$3$2_0.d_flip_flop_reset$1$2_0.NAND_2in_nmosx2$1$1$5_0.b 0.0287f
C886 MUX_8to1_0.in7 2Div$2_0.d_flip_flop$3$2_4.NAND_2in_nmosx2$3$2_0.y 0.10275f
C887 pdiv$3_0.count_data_check$2_0.c5 VP 0.18787f
C888 pdiv$3_0.d_flip_flop_reset$2$2_0.NAND_2in_nmosx2$1$2$2_0.a pdiv$3_0.d_flip_flop_reset$2$2_0.reset 1.32749f
C889 pdiv$3_0.div_with_reset$3$2_0.d_flip_flop_reset$1$2_2.clk VP 0.64997f
C890 pdiv$3_0.count_data_check$2_0.XNOR$1$2_2.y a_7434_1798# 0.07825f
C891 a_825_n2600# a_927_n2600# 0.09808f
C892 MUX_8to1_0.inverter_x4_ptap_mirror_fix$2$3_8.OUT MUX_8to1_0.passgate$1$2_3.in_p 0.54937f
C893 MUX_8to1_0.passgate$1$2_0.B MUX_8to1_0.out 0.81456f
C894 MUX_8to1_0.passgate$1$2_7.A VP 0.06518f
C895 MUX_8to1_0.in7 2Div$2_0.d_flip_flop$3$2_4.NAND_2in_nmosx2$3$2_0.b 0.38971f
C896 a_6888_6498# VP 0.06667f
C897 MUX_8to1_0.in3 2Div$2_0.d_flip_flop$3$2_1.NAND_3in_nmosx3$1$2_0.y 0.60213f
C898 2Div$2_0.d_flip_flop$3$2_2.NAND_2in_nmosx2$3$2_0.a VP 0.47107f
C899 pdiv$3_0.div_with_reset$3$2_0.d_flip_flop_reset$1$2_4.clk pdiv$3_0.div_with_reset$3$2_0.d_flip_flop_reset$1$2_4.NAND_3in_nmosx3$1$1$3_1.a 0.55635f
C900 pdiv$3_0.count_data_check$2_0.c5 a_5211_n2600# 0.1084f
C901 pdiv$3_0.div_with_reset$3$2_0.d_flip_flop_reset$1$2_1.clk pdiv$3_0.div_with_reset$3$2_0.d_flip_flop_reset$1$2_0.NAND_2in_nmosx2$1$1$5_0.y 0.04133f
C902 pdiv$3_0.div_with_reset$3$2_0.d_flip_flop_reset$1$2_0.NAND_2in_nmosx2$1$1$5_0.a a_4021_n2600# 0.02388f
C903 MUX_8to1_0.passgate$1$2_0.A VP 0.80605f
C904 d3 d5 0.74386f
C905 pdiv$3_0.NOR_2in$3$2_0.A d4 0.07675f
C906 MUX_8to1_0.in3 2Div$2_0.d_flip_flop$3$2_1.NAND_2in_nmosx2$3$2_0.y 0.10275f
C907 pdiv$3_0.div_with_reset$3$2_0.d_flip_flop_reset$1$2_0.q pdiv$3_0.div_with_reset$3$2_0.d_flip_flop_reset$1$2_0.NAND_3in_nmosx3$1$1$3_1.a 1.41657f
C908 pdiv$3_0.div_with_reset$3$2_0.d_flip_flop_reset$1$2_3.NAND_2in_nmosx2$1$1$5_0.a pdiv$3_0.div_with_reset$3$2_0.d_flip_flop_reset$1$2_1.clk 0.2706f
C909 pdiv$3_0.count_data_check$2_0.XNOR$1$2_0.y a_6346_n769# 0.02109f
C910 pdiv$3_0.div_with_reset$3$2_0.d_flip_flop_reset$1$2_0.NAND_2in_nmosx2$1$1$5_0.a pdiv$3_0.div_with_reset$3$2_0.d_flip_flop_reset$1$2_0.q 0.02037f
C911 2Div$2_0.d_flip_flop$3$2_0.NAND_2in_nmosx2$3$2_0.b 2Div$2_0.d_flip_flop$3$2_0.NAND_2in_nmosx2$3$2_0.y 0.8991f
C912 pdiv$3_0.count_data_check$2_0.c0 a_2015_2632# 0.1084f
C913 MUX_8to1_0.in8 a_n8801_n2147# 0.09893f
C914 MUX_8to1_0.passgate$1$2_6.A VP 0.80554f
C915 MUX_8to1_0.inverter_x4_ptap_mirror_fix$2$3_6.OUT MUX_8to1_0.in7 0.03577f
C916 MUX_8to1_0.in6 2Div$2_0.d_flip_flop$3$2_4.NAND_3in_nmosx3$1$2_0.y 0.17688f
C917 a_825_16# a_927_16# 0.09808f
C918 pdiv$3_0.div_with_reset$3$2_0.d_flip_flop_reset$1$2_0.q VP 0.34453f
C919 2Div$2_0.d_flip_flop$3$2_6.d a_n6761_31# 0.09386f
C920 pdiv$3_0.div_with_reset$3$2_0.d_flip_flop_reset$1$2_2.NAND_2in_nmosx2$1$1$5_0.a VP 0.13189f
C921 MUX_8to1_0.in3 2Div$2_0.d_flip_flop$3$2_1.NAND_2in_nmosx2$3$2_0.b 0.38971f
C922 pdiv$3_0.div_with_reset$3$2_0.d_flip_flop_reset$1$2_2.clk pdiv$3_0.count_data_check$2_0.c3 0.01299f
C923 pdiv$3_0.passgate$3_1.A pdiv$3_0.div_with_reset$3$2_0.d_flip_flop_reset$1$2_4.NAND_2in_nmosx2$1$1$5_0.a 1.34607f
C924 MUX_8to1_0.passgate$1$2_5.A MUX_8to1_0.inverter_x4_ptap_mirror_fix$2$3_6.OUT 0.03909f
C925 pdiv$3_0.d_flip_flop_reset$2$2_0.d pdiv$3_0.d_flip_flop_reset$2$2_0.NAND_3in_nmosx3$1$2$3_1.a 2.68709f
C926 pdiv$3_0.count_data_check$2_0.c1 d0 0.58163f
C927 MUX_8to1_0.in4 2Div$2_0.d_flip_flop$3$2_1.d 0.19612f
C928 clk MUX_8to1_0.in2 1.16878f
C929 MUX_8to1_0.passgate$1$2_0.in_p pdiv$3_0.div_with_reset$3$2_0.d_flip_flop_reset$1$2_1.NAND_2in_nmosx2$1$1$5_0.b 0.01211f
C930 pdiv$3_0.d_flip_flop_reset$2$2_0.reset reset 0.11271f
C931 MUX_8to1_0.passgate$1$2_5.A a2 0.03281f
C932 a_4803_n2600# a_4905_n2600# 0.07813f
C933 2Div$2_0.d_flip_flop$3$2_5.d 2Div$2_0.d_flip_flop$3$2_5.NAND_3in_nmosx3$1$2_0.y 1.35806f
C934 2Div$2_0.d_flip_flop$3$2_4.NAND_3in_nmosx3$1$2_0.y a0 0.01843f
C935 MUX_8to1_0.inverter_x4_ptap_mirror_fix$2$3_6.OUT MUX_8to1_0.passgate$1$2_5.in_p 0.09047f
C936 MUX_8to1_0.passgate$1$2_0.B VP 0.03251f
C937 a_6346_n2099# a_6346_n3385# 0.13417f
C938 pdiv$3_0.count_data_check$2_0.XNOR$1$2_3.y a_6346_n2099# 0.02892f
C939 pdiv$3_0.passgate$3_1.in_n d2 0.01101f
C940 2Div$2_0.d_flip_flop$3$2_5.NAND_2in_nmosx2$3$2_0.a 2Div$2_0.d_flip_flop$3$2_6.d 0.01074f
C941 pdiv$3_0.count_data_check$2_0.XNOR$1$2_1.y VP 0.25836f
C942 pdiv$3_0.count_data_check$2_0.XNOR$1$2_3.y a_6346_n3385# 0.25592f
C943 pdiv$3_0.count_data_check$2_0.XNOR$1$2_0.y pdiv$3_0.count_data_check$2_0.XNOR$1$2_5.y 6.60003f
C944 pdiv$3_0.d_flip_flop_reset$2$2_0.NAND_2in_nmosx2$1$2$2_0.a a_635_5248# 0.02388f
C945 pdiv$3_0.passgate$3_1.A pdiv$3_0.div_with_reset$3$2_0.d_flip_flop_reset$1$2_3.NAND_2in_nmosx2$1$1$5_0.b 0.63835f
C946 pdiv$3_0.passgate$3_1.in_n pdiv$3_0.NOR_2in$3$2_0.B 0.22898f
C947 pdiv$3_0.d_flip_flop_reset$2$2_0.NAND_3in_nmosx3$1$2$3_1.a a_1961_5248# 0.09877f
C948 pdiv$3_0.div_with_reset$3$2_0.d_flip_flop_reset$1$2_4.NAND_2in_nmosx2$1$1$5_0.a a_3793_3040# 0.01596f
C949 MUX_8to1_0.passgate$1$2_0.B pdiv$3_0.div_with_reset$3$2_0.d_flip_flop_reset$1$2_1.NAND_2in_nmosx2$1$1$5_0.b 0.0431f
C950 pdiv$3_0.count_data_check$2_0.c4 d4 0.57401f
C951 pdiv$3_0.div_with_reset$3$2_0.d_flip_flop_reset$1$2_2.NAND_2in_nmosx2$1$1$5_0.a pdiv$3_0.count_data_check$2_0.c3 0.82297f
C952 pdiv$3_0.div_with_reset$3$2_0.d_flip_flop_reset$1$2_2.clk pdiv$3_0.div_with_reset$3$2_0.d_flip_flop_reset$1$2_1.clk 0.03819f
C953 pdiv$3_0.div_with_reset$3$2_0.d_flip_flop_reset$1$2_0.NAND_2in_nmosx2$1$1$5_0.y a_3793_n2192# 0.1016f
C954 VP MUX_8to1_0.in2 0.16672f
C955 pdiv$3_0.count_data_check$2_0.c3 a_5211_16# 0.1084f
C956 pdiv$3_0.div_with_reset$3$2_0.d_flip_flop_reset$1$2_3.clk d0 0.07959f
C957 pdiv$3_0.div_with_reset$3$2_0.d_flip_flop_reset$1$2_2.NAND_2in_nmosx2$1$1$5_0.a a_4021_16# 0.02388f
C958 pdiv$3_0.count_data_check$2_0.XNOR$1$2_4.y a_7434_1258# 0.07921f
C959 pdiv$3_0.div_with_reset$3$2_0.d_flip_flop_reset$1$2_2.NAND_3in_nmosx3$1$1$3_1.a pdiv$3_0.count_data_check$2_0.c5 0.01001f
C960 pdiv$3_0.count_data_check$2_0.XNOR$1$2_1.y pdiv$3_0.count_data_check$2_0.c0 0.36172f
C961 pdiv$3_0.d_flip_flop_reset$2$2_0.NAND_2in_nmosx2$1$2$2_0.b a_1859_5656# 0.01781f
C962 a_4803_16# a_4905_16# 0.07813f
C963 pdiv$3_0.d_flip_flop_reset$2$2_0.d pdiv$3_0.div_with_reset$3$2_0.d_flip_flop_reset$1$2_5.NAND_2in_nmosx2$1$1$5_0.b 0.01907f
C964 2Div$2_0.d_flip_flop$3$2_5.NAND_3in_nmosx3$1$2_0.y VP 0.80691f
C965 pdiv$3_0.count_data_check$2_0.c3 pdiv$3_0.count_data_check$2_0.c4 0.15135f
C966 2Div$2_0.d_flip_flop$3$2_0.NAND_2in_nmosx2$3$2_0.b a_n7509_3085# 0.09898f
C967 pdiv$3_0.div_with_reset$3$2_0.d_flip_flop_reset$1$2_0.NAND_2in_nmosx2$1$1$5_0.b VP 0.27556f
C968 pdiv$3_0.d_flip_flop_reset$2$2_0.NAND_2in_nmosx2$1$2$2_0.b VP 0.26863f
C969 2Div$2_0.d_flip_flop$3$2_6.NAND_2in_nmosx2$3$2_0.a VP 0.47107f
C970 a_1607_2632# a_1709_2632# 0.07813f
C971 pdiv$3_0.passgate$3_1.A d3 0.03265f
C972 VP d1 0.60498f
C973 2Div$2_0.d_flip_flop$3$2_0.NAND_3in_nmosx3$1$2_0.y VP 0.80691f
C974 pdiv$3_0.div_with_reset$3$2_0.d_flip_flop_reset$1$2_1.NAND_2in_nmosx2$1$1$5_0.b MUX_8to1_0.passgate$1$2_2.in_p 0.01093f
C975 MUX_8to1_0.passgate$1$2_6.in_p a_n2333_469# 0.09585f
C976 VP d5 0.2441f
C977 2Div$2_0.d_flip_flop$3$2_1.NAND_2in_nmosx2$3$2_0.a VP 0.47107f
C978 MUX_8to1_0.in7 2Div$2_0.d_flip_flop$3$2_3.NAND_2in_nmosx2$3$2_0.a 0.80109f
C979 pdiv$3_0.div_with_reset$3$2_0.d_flip_flop_reset$1$2_4.clk pdiv$3_0.div_with_reset$3$2_0.d_flip_flop_reset$1$2_4.NAND_2in_nmosx2$1$1$5_0.a 1.28255f
C980 pdiv$3_0.NOR_2in$3$2_0.A a_4304_4466# 0.01307f
C981 MUX_8to1_0.inverter_x4_ptap_mirror_fix$2$3_6.OUT MUX_8to1_0.inverter_x4_ptap_mirror_fix$2$3_4.OUT 0.02782f
C982 pdiv$3_0.div_with_reset$3$2_0.d_flip_flop_reset$1$2_2.NAND_2in_nmosx2$1$1$5_0.a pdiv$3_0.div_with_reset$3$2_0.d_flip_flop_reset$1$2_1.clk 0.31928f
C983 pdiv$3_0.count_data_check$2_0.XNOR$1$2_0.y VP 0.22617f
C984 pdiv$3_0.count_data_check$2_0.XNOR$1$2_4.y a_7020_517# 0.04296f
C985 MUX_8to1_0.in3 a_n6761_2647# 0.01281f
C986 a_6346_517# a_6346_n769# 0.13417f
C987 MUX_8to1_0.in5 2Div$2_0.d_flip_flop$3$2_5.d 0.01219f
C988 pdiv$3_0.passgate$3_1.A pdiv$3_0.div_with_reset$3$2_0.d_flip_flop_reset$1$2_0.NAND_2in_nmosx2$1$1$5_0.b 0.63772f
C989 MUX_8to1_0.inverter_x4_ptap_mirror_fix$2$3_4.OUT a2 0.04788f
C990 pdiv$3_0.count_data_check$2_0.c0 d5 0.05579f
C991 d1 d4 0.0758f
C992 MUX_8to1_0.in6 2Div$2_0.d_flip_flop$3$2_6.NAND_3in_nmosx3$1$2_0.y 0.20101f
C993 pdiv$3_0.div_with_reset$3$2_0.d_flip_flop_reset$1$2_1.clk pdiv$3_0.count_data_check$2_0.c4 0.11334f
C994 pdiv$3_0.d_flip_flop_reset$2$2_0.d MUX_8to1_0.passgate$1$2_5.in_n 0.01888f
C995 pdiv$3_0.count_data_check$2_0.XNOR$1$2_5.y a_6346_n769# 0.26856f
C996 MUX_8to1_0.passgate$1$2_6.in_p pdiv$3_0.div_with_reset$3$2_0.d_flip_flop_reset$1$2_3.NAND_2in_nmosx2$1$1$5_0.b 0.01211f
C997 pdiv$3_0.div_with_reset$3$2_0.d_flip_flop_reset$1$2_1.NAND_2in_nmosx2$1$1$5_0.a pdiv$3_0.div_with_reset$3$2_0.d_flip_flop_reset$1$2_0.clk 0.02043f
C998 pdiv$3_0.count_data_check$2_0.c5 d5 0.63959f
C999 MUX_8to1_0.out out_div 0.13156f
C1000 MUX_8to1_0.passgate$1$2_2.in_n VP 0.21395f
C1001 MUX_8to1_0.in6 2Div$2_0.d_flip_flop$3$2_6.NAND_2in_nmosx2$3$2_0.y 0.13403f
C1002 MUX_8to1_0.passgate$1$2_5.A MUX_8to1_0.passgate$1$2_0.B 0.87683f
C1003 pdiv$3_0.count_data_check$2_0.XNOR$1$2_2.y VP 0.01157f
C1004 pdiv$3_0.count_data_check$2_0.c1 a_4905_2632# 0.01875f
C1005 pdiv$3_0.count_data_check$2_0.c3 d1 0.03922f
C1006 MUX_8to1_0.in3 2Div$2_0.d_flip_flop$3$2_0.NAND_2in_nmosx2$3$2_0.a 0.80109f
C1007 pdiv$3_0.div_with_reset$3$2_0.d_flip_flop_reset$1$2_4.NAND_2in_nmosx2$1$1$5_0.a a_3715_2632# 0.10117f
C1008 2Div$2_0.d_flip_flop$3$2_1.d MUX_8to1_0.in2 0.01219f
C1009 pdiv$3_0.count_data_check$2_0.XNOR$1$2_4.y VP 0.24295f
C1010 MUX_8to1_0.passgate$1$2_4.in_p MUX_8to1_0.passgate$1$2_4.in_n 0.44409f
C1011 a_5109_2632# a_5211_2632# 0.09808f
C1012 MUX_8to1_0.inverter_x4_ptap_mirror_fix$2$3_5.OUT MUX_8to1_0.passgate$1$2_6.in_n 0.01683f
C1013 2Div$2_0.d_flip_flop$3$2_3.NAND_3in_nmosx3$1$2_0.y a_n7639_n2585# 0.09585f
C1014 MUX_8to1_0.in6 2Div$2_0.d_flip_flop$3$2_6.NAND_2in_nmosx2$3$2_0.b 0.25747f
C1015 MUX_8to1_0.passgate$1$2_0.B MUX_8to1_0.passgate$1$2_5.in_p 0.0652f
C1016 pdiv$3_0.count_data_check$2_0.XNOR$1$2_5.y a_6346_517# 0.0388f
C1017 MUX_8to1_0.in6 VP 0.18712f
C1018 MUX_8to1_0.passgate$1$2_5.A a1 0.03434f
C1019 MUX_8to1_0.passgate$1$2_0.in_n VP 0.21018f
C1020 MUX_8to1_0.in5 VP 0.32664f
C1021 pdiv$3_0.div_with_reset$3$2_0.d_flip_flop_reset$1$2_0.NAND_2in_nmosx2$1$1$5_0.b a_2797_n2192# 0.01781f
C1022 pdiv$3_0.passgate$3_1.in_p pdiv$3_0.passgate$3_1.A 0.51533f
C1023 pdiv$3_0.div_with_reset$3$2_0.d_flip_flop_reset$1$2_3.NAND_2in_nmosx2$1$1$5_0.b MUX_8to1_0.passgate$1$2_1.in_p 0.01092f
C1024 2Div$2_0.d_flip_flop$3$2_1.d 2Div$2_0.d_flip_flop$3$2_0.NAND_3in_nmosx3$1$2_0.y 0.0572f
C1025 pdiv$3_0.d_flip_flop_reset$2$2_0.NAND_2in_nmosx2$1$2$2_0.b pdiv$3_0.d_flip_flop_reset$2$2_0.reset 0.7164f
C1026 pdiv$3_0.div_with_reset$3$2_0.d_flip_flop_reset$1$2_2.NAND_2in_nmosx2$1$1$5_0.b a_3001_424# 0.02373f
C1027 MUX_8to1_0.inverter_x4_ptap_mirror_fix$2$3_6.OUT VP 0.1559f
C1028 a_6346_517# d2 0.94959f
C1029 2Div$2_0.d_flip_flop$3$2_1.d 2Div$2_0.d_flip_flop$3$2_1.NAND_2in_nmosx2$3$2_0.a 0.60818f
C1030 pdiv$3_0.div_with_reset$3$2_0.d_flip_flop_reset$1$2_0.q d5 0.05086f
C1031 VP a0 0.40036f
C1032 a_2695_424# a_2797_424# 0.07813f
C1033 2Div$2_0.d_flip_flop$3$2_3.NAND_2in_nmosx2$3$2_0.y a_n8121_n2147# 0.09372f
C1034 VP a2 0.1962f
C1035 MUX_8to1_0.in3 VP 1.61699f
C1036 a_6702_n3385# d5 0.45336f
C1037 2Div$2_0.d_flip_flop$3$2_3.NAND_3in_nmosx3$1$2_0.y VP 0.79555f
C1038 2Div$2_0.d_flip_flop$3$2_4.NAND_2in_nmosx2$3$2_0.a 2Div$2_0.d_flip_flop$3$2_4.NAND_2in_nmosx2$3$2_0.y 0.44392f
C1039 pdiv$3_0.div_with_reset$3$2_0.d_flip_flop_reset$1$2_1.NAND_2in_nmosx2$1$1$5_0.a VP 0.13189f
C1040 MUX_8to1_0.passgate$1$2_4.in_n VP 0.21619f
C1041 pdiv$3_0.count_data_check$2_0.c4 pdiv$3_0.div_with_reset$3$2_0.d_flip_flop_reset$1$2_1.NAND_2in_nmosx2$1$1$5_0.y 0.22729f
C1042 pdiv$3_0.div_with_reset$3$2_0.d_flip_flop_reset$1$2_3.NAND_2in_nmosx2$1$1$5_0.b a_n501_424# 0.09919f
C1043 pdiv$3_0.count_data_check$2_0.c5 VP 1.70048f
C1044 pdiv$3_0.passgate$3_1.A VP 2.43557f
C1045 a_n555_5248# a_n453_5248# 0.09808f
C1046 a_6346_n769# VP 0.37353f
C1047 pdiv$3_0.div_with_reset$3$2_0.d_flip_flop_reset$1$2_3.clk pdiv$3_0.div_with_reset$3$2_0.d_flip_flop_reset$1$2_2.NAND_2in_nmosx2$1$1$5_0.b 0.40148f
C1048 2Div$2_0.d_flip_flop$3$2_2.NAND_2in_nmosx2$3$2_0.a 2Div$2_0.d_flip_flop$3$2_2.NAND_3in_nmosx3$1$2_0.y 1.19863f
C1049 a_7018_3874# VP 0.09529f
C1050 pdiv$3_0.count_data_check$2_0.c2 pdiv$3_0.div_with_reset$3$2_0.d_flip_flop_reset$1$2_3.NAND_2in_nmosx2$1$1$5_0.b 1.22588f
C1051 MUX_8to1_0.inverter_x4_ptap_mirror_fix$2$3_4.OUT MUX_8to1_0.passgate$1$2_0.in_p 0.09972f
C1052 VP out_div 0.35252f
C1053 2Div$2_0.d_flip_flop$3$2_4.NAND_2in_nmosx2$3$2_0.b 2Div$2_0.d_flip_flop$3$2_4.NAND_2in_nmosx2$3$2_0.a 0.79459f
C1054 pdiv$3_0.count_data_check$2_0.c1 VP 1.65606f
C1055 pdiv$3_0.count_data_check$2_0.c4 a_1913_n2600# 0.02299f
C1056 a_6346_1847# VP 0.37353f
C1057 pdiv$3_0.NOR_2in$3$2_0.B d2 0.15157f
C1058 pdiv$3_0.passgate$3_1.A pdiv$3_0.count_data_check$2_0.c0 2.61931f
C1059 pdiv$3_0.passgate$3_1.B pdiv$3_0.passgate$3_1.in_p 0.74577f
C1060 pdiv$3_0.div_with_reset$3$2_0.d_flip_flop_reset$1$2_5.NAND_2in_nmosx2$1$1$5_0.a VP 0.13237f
C1061 pdiv$3_0.div_with_reset$3$2_0.d_flip_flop_reset$1$2_3.NAND_2in_nmosx2$1$1$5_0.b pdiv$3_0.div_with_reset$3$2_0.d_flip_flop_reset$1$2_3.NAND_3in_nmosx3$1$1$3_1.a 0.80223f
C1062 pdiv$3_0.count_data_check$2_0.c2 a_6702_517# 1.14927f
C1063 pdiv$3_0.count_data_check$2_0.XNOR$1$2_1.y pdiv$3_0.count_data_check$2_0.XNOR$1$2_0.y 0.03004f
C1064 pdiv$3_0.passgate$3_1.A pdiv$3_0.count_data_check$2_0.c5 2.42949f
C1065 pdiv$3_0.div_with_reset$3$2_0.d_flip_flop_reset$1$2_1.NAND_3in_nmosx3$1$1$3_1.a MUX_8to1_0.passgate$1$2_2.in_n 0.01776f
C1066 MUX_8to1_0.passgate$1$2_0.B MUX_8to1_0.inverter_x4_ptap_mirror_fix$2$3_4.OUT 0.84482f
C1067 MUX_8to1_0.in2 2Div$2_0.d_flip_flop$3$2_2.NAND_2in_nmosx2$3$2_0.b 0.41859f
C1068 pdiv$3_0.count_data_check$2_0.c4 a_6346_n2099# 1.11509f
C1069 MUX_8to1_0.in5 a_n6421_469# 0.09596f
C1070 pdiv$3_0.passgate$3_1.A pdiv$3_0.div_with_reset$3$2_0.d_flip_flop_reset$1$2_5.NAND_3in_nmosx3$1$1$3_1.a 2.05473f
C1071 pdiv$3_0.d_flip_flop_reset$2$2_0.d pdiv$3_0.d_flip_flop_reset$2$2_0.NAND_2in_nmosx2$1$2$2_0.y 0.10471f
C1072 a_n2435_n2147# a_n2333_n2147# 0.09425f
C1073 pdiv$3_0.div_with_reset$3$2_0.d_flip_flop_reset$1$2_0.clk pdiv$3_0.div_with_reset$3$2_0.d_flip_flop_reset$1$2_0.NAND_3in_nmosx3$1$1$3_1.a 0.55635f
C1074 pdiv$3_0.div_with_reset$3$2_0.d_flip_flop_reset$1$2_0.q VP 0.27562f
C1075 pdiv$3_0.count_data_check$2_0.XNOR$1$2_5.y VP 0.17859f
C1076 VP 2Div$2_0.d_flip_flop$3$2_2.d 0.54414f
C1077 pdiv$3_0.count_data_check$2_0.c1 d4 0.03035f
C1078 pdiv$3_0.div_with_reset$3$2_0.d_flip_flop_reset$1$2_3.NAND_2in_nmosx2$1$1$5_0.a pdiv$3_0.div_with_reset$3$2_0.d_flip_flop_reset$1$2_2.clk 0.02043f
C1079 pdiv$3_0.passgate$3_1.B VP 0.32058f
C1080 pdiv$3_0.count_data_check$2_0.c0 pdiv$3_0.div_with_reset$3$2_0.d_flip_flop_reset$1$2_5.NAND_2in_nmosx2$1$1$5_0.a 1.22533f
C1081 pdiv$3_0.count_data_check$2_0.c2 d3 0.03186f
C1082 a_6702_n3385# VP 0.53214f
C1083 pdiv$3_0.div_with_reset$3$2_0.d_flip_flop_reset$1$2_0.clk pdiv$3_0.div_with_reset$3$2_0.d_flip_flop_reset$1$2_0.NAND_2in_nmosx2$1$1$5_0.a 1.28255f
C1084 pdiv$3_0.div_with_reset$3$2_0.d_flip_flop_reset$1$2_4.NAND_2in_nmosx2$1$1$5_0.b pdiv$3_0.div_with_reset$3$2_0.d_flip_flop_reset$1$2_2.NAND_2in_nmosx2$1$1$5_0.y 0.01266f
C1085 MUX_8to1_0.inverter_x4_ptap_mirror_fix$2$3_5.OUT MUX_8to1_0.passgate$1$2_7.A 0.19296f
C1086 MUX_8to1_0.inverter_x4_ptap_mirror_fix$2$3_4.OUT a1 0.24785f
C1087 pdiv$3_0.div_with_reset$3$2_0.d_flip_flop_reset$1$2_0.clk VP 0.64997f
C1088 a_n5129_5701# 2Div$2_0.d_flip_flop$3$2_2.NAND_2in_nmosx2$3$2_0.b 0.09898f
C1089 pdiv$3_0.div_with_reset$3$2_0.d_flip_flop_reset$1$2_3.clk VP 2.10122f
C1090 MUX_8to1_0.in3 2Div$2_0.d_flip_flop$3$2_0.NAND_2in_nmosx2$3$2_0.b 1.55875f
C1091 MUX_8to1_0.passgate$1$2_6.A MUX_8to1_0.passgate$1$2_6.in_n 0.26033f
C1092 MUX_8to1_0.passgate$1$2_0.B MUX_8to1_0.passgate$1$2_1.in_n 0.11915f
C1093 VP d2 0.02318f
C1094 a_3001_3040# a_3103_3040# 0.09808f
C1095 2Div$2_0.d_flip_flop$3$2_5.NAND_2in_nmosx2$3$2_0.a 2Div$2_0.d_flip_flop$3$2_3.NAND_2in_nmosx2$3$2_0.y 0.01058f
C1096 2Div$2_0.d_flip_flop$3$2_4.NAND_2in_nmosx2$3$2_0.y a_n5741_n2147# 0.09372f
C1097 2Div$2_0.d_flip_flop$3$2_5.d VP 0.57225f
C1098 pdiv$3_0.div_with_reset$3$2_0.d_flip_flop_reset$1$2_5.NAND_2in_nmosx2$1$1$5_0.a pdiv$3_0.div_with_reset$3$2_0.d_flip_flop_reset$1$2_5.NAND_3in_nmosx3$1$1$3_1.a 1.93937f
C1099 MUX_8to1_0.inverter_x4_ptap_mirror_fix$2$3_4.OUT MUX_8to1_0.passgate$1$2_2.in_p 0.20391f
C1100 MUX_8to1_0.passgate$1$2_7.in_p MUX_8to1_0.passgate$1$2_6.in_p 0.07295f
C1101 pdiv$3_0.passgate$3_1.A pdiv$3_0.div_with_reset$3$2_0.d_flip_flop_reset$1$2_0.q 0.15926f
C1102 2Div$2_0.d_flip_flop$3$2_0.d VP 0.57225f
C1103 pdiv$3_0.count_data_check$2_0.NAND_3in$2_1/NAND_3in_nmosx3$5$1$2_0.y pdiv$3_0.inverter_x8$3_0.IN 0.5033f
C1104 pdiv$3_0.d_flip_flop_reset$2$2_0.reset pdiv$3_0.passgate$3_1.A 0.04195f
C1105 pdiv$3_0.div_with_reset$3$2_0.d_flip_flop_reset$1$2_4.clk VP 0.64672f
C1106 MUX_8to1_0.in6 2Div$2_0.d_flip_flop$3$2_5.NAND_2in_nmosx2$3$2_0.a 0.14593f
C1107 MUX_8to1_0.inverter_x4_ptap_mirror_fix$2$3_5.OUT MUX_8to1_0.passgate$1$2_6.A 0.06081f
C1108 2Div$2_0.d_flip_flop$3$2_6.NAND_2in_nmosx2$3$2_0.a 2Div$2_0.d_flip_flop$3$2_6.NAND_3in_nmosx3$1$2_0.y 1.19863f
C1109 pdiv$3_0.count_data_check$2_0.XNOR$1$2_2.y a_7428_2629# 0.04399f
C1110 pdiv$3_0.div_with_reset$3$2_0.d_flip_flop_reset$1$2_0.NAND_2in_nmosx2$1$1$5_0.a pdiv$3_0.div_with_reset$3$2_0.d_flip_flop_reset$1$2_0.NAND_3in_nmosx3$1$1$3_1.a 1.93937f
C1111 a_6702_n2099# a_6702_n3385# 0.01157f
C1112 2Div$2_0.d_flip_flop$3$2_6.NAND_2in_nmosx2$3$2_0.b a_n5129_469# 0.09898f
C1113 MUX_8to1_0.in4 MUX_8to1_0.passgate$1$2_7.A 0.49678f
C1114 MUX_8to1_0.passgate$1$2_0.B VP 0.14714f
C1115 2Div$2_0.d_flip_flop$3$2_6.NAND_2in_nmosx2$3$2_0.a 2Div$2_0.d_flip_flop$3$2_6.NAND_2in_nmosx2$3$2_0.y 0.44392f
C1116 MUX_8to1_0.inverter_x4_ptap_mirror_fix$2$3_7.OUT MUX_8to1_0.passgate$1$2_4.in_p 0.30847f
C1117 MUX_8to1_0.passgate$1$2_3.in_n VP 0.20495f
C1118 pdiv$3_0.div_with_reset$3$2_0.d_flip_flop_reset$1$2_2.NAND_2in_nmosx2$1$1$5_0.a a_3793_424# 0.01596f
C1119 pdiv$3_0.div_with_reset$3$2_0.d_flip_flop_reset$1$2_0.NAND_2in_nmosx2$1$1$5_0.a VP 0.13189f
C1120 pdiv$3_0.count_data_check$2_0.c4 pdiv$3_0.div_with_reset$3$2_0.d_flip_flop_reset$1$2_0.NAND_2in_nmosx2$1$1$5_0.y 0.12259f
C1121 MUX_8to1_0.in8 2Div$2_0.d_flip_flop$3$2_3.NAND_2in_nmosx2$3$2_0.y 0.19573f
C1122 a_n7639_31# a_n7537_31# 0.09425f
C1123 pdiv$3_0.count_data_check$2_0.NAND_3in$2_0/NAND_3in_nmosx3$5$1$2_0.y a_6702_3133# 0.02953f
C1124 pdiv$3_0.div_with_reset$3$2_0.d_flip_flop_reset$1$2_3.clk pdiv$3_0.count_data_check$2_0.c3 0.03067f
C1125 pdiv$3_0.count_data_check$2_0.c0 pdiv$3_0.div_with_reset$3$2_0.d_flip_flop_reset$1$2_4.clk 1.7297f
C1126 MUX_8to1_0.passgate$1$2_1.A MUX_8to1_0.passgate$1$2_6.in_p 0.09972f
C1127 pdiv$3_0.count_data_check$2_0.c5 a_4905_n2600# 0.01875f
C1128 2Div$2_0.d_flip_flop$3$2_6.NAND_2in_nmosx2$3$2_0.b 2Div$2_0.d_flip_flop$3$2_6.NAND_2in_nmosx2$3$2_0.a 0.79459f
C1129 VP a1 0.16144f
C1130 pdiv$3_0.div_with_reset$3$2_0.d_flip_flop_reset$1$2_0.NAND_2in_nmosx2$1$1$5_0.a a_3715_n2600# 0.10117f
C1131 2Div$2_0.d_flip_flop$3$2_6.d MUX_8to1_0.in7 0.18412f
C1132 a_2695_n2600# a_2797_n2600# 0.07813f
C1133 2Div$2_0.d_flip_flop$3$2_3.NAND_2in_nmosx2$3$2_0.b 2Div$2_0.d_flip_flop$3$2_3.d 0.81289f
C1134 MUX_8to1_0.passgate$1$2_5.in_p out_div 0.01143f
C1135 pdiv$3_0.div_with_reset$3$2_0.d_flip_flop_reset$1$2_5.NAND_2in_nmosx2$1$1$5_0.a a_825_2632# 0.02388f
C1136 pdiv$3_0.count_data_check$2_0.XNOR$1$2_2.y pdiv$3_0.count_data_check$2_0.XNOR$1$2_0.y 0.03475f
C1137 pdiv$3_0.count_data_check$2_0.NAND_3in$2_0/NAND_3in_nmosx3$5$1$2_0.y pdiv$3_0.count_data_check$2_0.XNOR$1$2_3.y 0.2015f
C1138 MUX_8to1_0.in6 MUX_8to1_0.in8 0.39384f
C1139 pdiv$3_0.div_with_reset$3$2_0.d_flip_flop_reset$1$2_4.clk pdiv$3_0.div_with_reset$3$2_0.d_flip_flop_reset$1$2_5.NAND_3in_nmosx3$1$1$3_1.a 1.43515f
C1140 pdiv$3_0.count_data_check$2_0.c0 a_1709_2632# 0.01875f
C1141 MUX_8to1_0.in4 MUX_8to1_0.passgate$1$2_6.A 0.04802f
C1142 pdiv$3_0.passgate$3_1.B pdiv$3_0.d_flip_flop_reset$2$2_0.reset 2.56105f
C1143 pdiv$3_0.count_data_check$2_0.NAND_3in$2_1/NAND_3in_nmosx3$5$1$2_0.y a_7459_5701# 0.09708f
C1144 pdiv$3_0.div_with_reset$3$2_0.d_flip_flop_reset$1$2_5.NAND_3in_nmosx3$1$1$3_1.a a_n195_2632# 0.02003f
C1145 MUX_8to1_0.inverter_x4_ptap_mirror_fix$2$3_7.OUT MUX_8to1_0.passgate$1$2_7.in_p 0.30736f
C1146 2Div$2_0.d_flip_flop$3$2_5.NAND_2in_nmosx2$3$2_0.a a_n8393_31# 0.09722f
C1147 MUX_8to1_0.passgate$1$2_1.in_p a0 0.24566f
C1148 MUX_8to1_0.inverter_x4_ptap_mirror_fix$2$3_7.OUT VP 0.41023f
C1149 pdiv$3_0.div_with_reset$3$2_0.d_flip_flop_reset$1$2_4.NAND_3in_nmosx3$1$1$3_1.a a_3001_2632# 0.02003f
C1150 MUX_8to1_0.passgate$1$2_1.A MUX_8to1_0.passgate$1$2_1.in_p 0.20391f
C1151 MUX_8to1_0.in8 a0 0.57381f
C1152 pdiv$3_0.div_with_reset$3$2_0.d_flip_flop_reset$1$2_2.clk pdiv$3_0.div_with_reset$3$2_0.d_flip_flop_reset$1$2_2.NAND_2in_nmosx2$1$1$5_0.a 1.28255f
C1153 2Div$2_0.d_flip_flop$3$2_0.NAND_2in_nmosx2$3$2_0.a 2Div$2_0.d_flip_flop$3$2_5.NAND_2in_nmosx2$3$2_0.b 0.03614f
C1154 pdiv$3_0.div_with_reset$3$2_0.d_flip_flop_reset$1$2_3.clk pdiv$3_0.div_with_reset$3$2_0.d_flip_flop_reset$1$2_1.clk 0.15269f
C1155 pdiv$3_0.count_data_check$2_0.XNOR$1$2_1.y pdiv$3_0.count_data_check$2_0.XNOR$1$2_5.y 0.03901f
C1156 pdiv$3_0.count_data_check$2_0.XNOR$1$2_4.y pdiv$3_0.count_data_check$2_0.XNOR$1$2_3.y 0.03349f
C1157 MUX_8to1_0.in8 2Div$2_0.d_flip_flop$3$2_3.NAND_3in_nmosx3$1$2_0.y 0.77439f
C1158 pdiv$3_0.passgate$3_1.A pdiv$3_0.passgate$3_1.in_n 0.03502f
C1159 MUX_8to1_0.passgate$1$2_7.A MUX_8to1_0.passgate$1$2_6.A 0.06769f
C1160 a_7020_2629# d1 0.01014f
C1161 MUX_8to1_0.in5 2Div$2_0.d_flip_flop$3$2_6.NAND_3in_nmosx3$1$2_0.y 0.60213f
C1162 a_2695_16# a_2797_16# 0.07813f
C1163 MUX_8to1_0.inverter_x4_ptap_mirror_fix$2$3_7.OUT a0 1.74297f
C1164 pdiv$3_0.div_with_reset$3$2_0.d_flip_flop_reset$1$2_5.NAND_2in_nmosx2$1$1$5_0.b pdiv$3_0.div_with_reset$3$2_0.d_flip_flop_reset$1$2_5.NAND_2in_nmosx2$1$1$5_0.y 1.24916f
C1165 pdiv$3_0.div_with_reset$3$2_0.d_flip_flop_reset$1$2_4.NAND_3in_nmosx3$1$1$3_1.a pdiv$3_0.div_with_reset$3$2_0.d_flip_flop_reset$1$2_2.NAND_2in_nmosx2$1$1$5_0.b 0.0287f
C1166 MUX_8to1_0.in5 2Div$2_0.d_flip_flop$3$2_6.NAND_2in_nmosx2$3$2_0.y 0.10275f
C1167 MUX_8to1_0.inverter_x4_ptap_mirror_fix$2$3_7.OUT MUX_8to1_0.passgate$1$2_1.A 0.0422f
C1168 pdiv$3_0.d_flip_flop_reset$2$2_0.NAND_3in_nmosx3$1$2$3_1.a a_1655_5248# 0.02003f
C1169 pdiv$3_0.passgate$3_1.in_p MUX_8to1_0.out 0.13587f
C1170 a_n501_2632# a_n399_2632# 0.07813f
C1171 a_6346_3133# VP 0.37134f
C1172 a_6346_n3385# a_7434_n3434# 0.01178f
C1173 pdiv$3_0.count_data_check$2_0.XNOR$1$2_3.y a_7434_n3434# 0.07825f
C1174 MUX_8to1_0.passgate$1$2_0.A MUX_8to1_0.passgate$1$2_1.in_p 0.41079f
C1175 pdiv$3_0.count_data_check$2_0.XNOR$1$2_0.y a_6702_n2099# 0.28111f
C1176 MUX_8to1_0.in4 MUX_8to1_0.in2 0.3524f
C1177 pdiv$3_0.count_data_check$2_0.c3 a_4905_16# 0.01875f
C1178 pdiv$3_0.d_flip_flop_reset$2$2_0.NAND_2in_nmosx2$1$2$2_0.y a_863_5656# 0.1016f
C1179 MUX_8to1_0.in5 2Div$2_0.d_flip_flop$3$2_6.NAND_2in_nmosx2$3$2_0.b 0.38924f
C1180 pdiv$3_0.div_with_reset$3$2_0.d_flip_flop_reset$1$2_2.NAND_2in_nmosx2$1$1$5_0.a a_3715_16# 0.10117f
C1181 pdiv$3_0.d_flip_flop_reset$2$2_0.NAND_2in_nmosx2$1$2$2_0.b a_1553_5656# 0.10948f
C1182 MUX_8to1_0.in6 2Div$2_0.d_flip_flop$3$2_4.d 0.01219f
C1183 a_n5259_n2585# a_n5157_n2585# 0.09425f
C1184 2Div$2_0.d_flip_flop$3$2_2.NAND_3in_nmosx3$1$2_0.y MUX_8to1_0.in3 0.12126f
C1185 pdiv$3_0.div_with_reset$3$2_0.d_flip_flop_reset$1$2_5.NAND_3in_nmosx3$1$1$3_1.a pdiv$3_0.count_data_check$2_0.c2 0.01001f
C1186 MUX_8to1_0.passgate$1$2_0.B pdiv$3_0.div_with_reset$3$2_0.d_flip_flop_reset$1$2_1.clk 0.25488f
C1187 2Div$2_0.d_flip_flop$3$2_5.NAND_2in_nmosx2$3$2_0.b MUX_8to1_0.in6 0.41307f
C1188 MUX_8to1_0.out VP 0.63129f
C1189 MUX_8to1_0.passgate$1$2_5.A MUX_8to1_0.passgate$1$2_3.in_n 0.13718f
C1190 pdiv$3_0.count_data_check$2_0.c0 a_6346_3133# 1.11627f
C1191 2Div$2_0.d_flip_flop$3$2_2.NAND_3in_nmosx3$1$2_0.y a_n5259_5263# 0.09585f
C1192 pdiv$3_0.count_data_check$2_0.XNOR$1$2_1.y a_7020_3133# 0.04296f
C1193 pdiv$3_0.passgate$3_1.B pdiv$3_0.passgate$3_1.in_n 0.2779f
C1194 MUX_8to1_0.inverter_x4_ptap_mirror_fix$2$3_7.OUT MUX_8to1_0.passgate$1$2_0.A 0.04459f
C1195 pdiv$3_0.count_data_check$2_0.XNOR$1$2_2.y pdiv$3_0.inverter_x8$3_0.IN 0.03309f
C1196 pdiv$3_0.div_with_reset$3$2_0.d_flip_flop_reset$1$2_2.NAND_3in_nmosx3$1$1$3_1.a VP 1.3722f
C1197 MUX_8to1_0.in4 2Div$2_0.d_flip_flop$3$2_0.NAND_3in_nmosx3$1$2_0.y 0.77439f
C1198 pdiv$3_0.d_flip_flop_reset$2$2_0.NAND_2in_nmosx2$1$2$2_0.b pdiv$3_0.d_flip_flop_reset$2$2_0.NAND_2in_nmosx2$1$2$2_0.a 0.99113f
C1199 MUX_8to1_0.passgate$1$2_7.A MUX_8to1_0.in2 0.03634f
C1200 MUX_8to1_0.in3 MUX_8to1_0.in5 0.03242f
C1201 2Div$2_0.d_flip_flop$3$2_4.d 2Div$2_0.d_flip_flop$3$2_3.NAND_3in_nmosx3$1$2_0.y 0.0572f
C1202 pdiv$3_0.div_with_reset$3$2_0.d_flip_flop_reset$1$2_1.NAND_2in_nmosx2$1$1$5_0.a VP 1.02929f
C1203 a_6346_n769# a_7434_n818# 0.01178f
C1204 MUX_8to1_0.in4 2Div$2_0.d_flip_flop$3$2_1.NAND_2in_nmosx2$3$2_0.a 0.1376f
C1205 MUX_8to1_0.out pdiv$3_0.count_data_check$2_0.c0 0.08327f
C1206 MUX_8to1_0.passgate$1$2_0.in_p pdiv$3_0.div_with_reset$3$2_0.d_flip_flop_reset$1$2_1.NAND_2in_nmosx2$1$1$5_0.y 0.01092f
C1207 pdiv$3_0.div_with_reset$3$2_0.d_flip_flop_reset$1$2_4.NAND_3in_nmosx3$1$1$3_1.a VP 1.37196f
C1208 d0 d3 0.0746f
C1209 d2 d5 0.14298f
C1210 2Div$2_0.d_flip_flop$3$2_5.NAND_2in_nmosx2$3$2_0.a 2Div$2_0.d_flip_flop$3$2_5.NAND_3in_nmosx3$1$2_0.y 1.19863f
C1211 a_3001_2632# a_3103_2632# 0.09808f
C1212 MUX_8to1_0.passgate$1$2_2.in_p a_n2333_n2585# 0.09585f
C1213 pdiv$3_0.passgate$3_1.in_p VP 0.2009f
C1214 MUX_8to1_0.out pdiv$3_0.div_with_reset$3$2_0.d_flip_flop_reset$1$2_5.NAND_3in_nmosx3$1$1$3_1.a 0.55611f
C1215 pdiv$3_0.passgate$3_1.A pdiv$3_0.div_with_reset$3$2_0.d_flip_flop_reset$1$2_3.NAND_2in_nmosx2$1$1$5_0.y 0.22234f
C1216 2Div$2_0.d_flip_flop$3$2_2.NAND_3in_nmosx3$1$2_0.y 2Div$2_0.d_flip_flop$3$2_2.d 1.35806f
C1217 MUX_8to1_0.passgate$1$2_3.in_p MUX_8to1_0.inverter_x4_ptap_mirror_fix$2$3_7.OUT 0.30073f
C1218 MUX_8to1_0.inverter_x4_ptap_mirror_fix$2$3_6.OUT MUX_8to1_0.inverter_x4_ptap_mirror_fix$2$3_5.OUT 9.65374f
C1219 pdiv$3_0.count_data_check$2_0.XNOR$1$2_2.y pdiv$3_0.count_data_check$2_0.XNOR$1$2_5.y 0.03643f
C1220 MUX_8to1_0.passgate$1$2_0.B pdiv$3_0.div_with_reset$3$2_0.d_flip_flop_reset$1$2_1.NAND_2in_nmosx2$1$1$5_0.y 0.04257f
C1221 pdiv$3_0.passgate$3_1.A pdiv$3_0.div_with_reset$3$2_0.d_flip_flop_reset$1$2_1.NAND_2in_nmosx2$1$1$5_0.a 1.65942f
C1222 MUX_8to1_0.inverter_x4_ptap_mirror_fix$2$3_5.OUT a2 10.716f
C1223 pdiv$3_0.passgate$3_1.A pdiv$3_0.inverter_x8$3_0.IN 0.33505f
C1224 pdiv$3_0.count_data_check$2_0.XNOR$1$2_5.y a_7434_n818# 0.07825f
C1225 MUX_8to1_0.passgate$1$2_0.B pdiv$3_0.div_with_reset$3$2_0.d_flip_flop_reset$1$2_5.NAND_2in_nmosx2$1$1$5_0.b 0.04615f
C1226 a_n2435_469# a_n2333_469# 0.09425f
C1227 2Div$2_0.d_flip_flop$3$2_5.NAND_3in_nmosx3$1$2_0.y MUX_8to1_0.in8 0.01541f
C1228 MUX_8to1_0.passgate$1$2_1.in_p a_n2333_31# 0.09585f
C1229 pdiv$3_0.div_with_reset$3$2_0.d_flip_flop_reset$1$2_5.NAND_2in_nmosx2$1$1$5_0.b pdiv$3_0.div_with_reset$3$2_0.d_flip_flop_reset$1$2_4.NAND_2in_nmosx2$1$1$5_0.y 0.04918f
C1230 VP d5 0.12885f
C1231 pdiv$3_0.div_with_reset$3$2_0.d_flip_flop_reset$1$2_4.NAND_3in_nmosx3$1$1$3_1.a pdiv$3_0.count_data_check$2_0.c3 0.01001f
C1232 2Div$2_0.d_flip_flop$3$2_6.d VP 0.19541f
C1233 pdiv$3_0.div_with_reset$3$2_0.d_flip_flop_reset$1$2_0.clk VP 0.55806f
C1234 pdiv$3_0.d_flip_flop_reset$2$2_0.reset MUX_8to1_0.out 0.09209f
C1235 MUX_8to1_0.in5 a_n6761_31# 0.01281f
C1236 VP a0 0.01541f
C1237 a_1859_5656# a_1961_5656# 0.07813f
C1238 pdiv$3_0.div_with_reset$3$2_0.d_flip_flop_reset$1$2_2.NAND_2in_nmosx2$1$1$5_0.b a_2695_424# 0.09919f
C1239 2Div$2_0.d_flip_flop$3$2_1.NAND_2in_nmosx2$3$2_0.b a_n5129_3085# 0.09898f
C1240 pdiv$3_0.count_data_check$2_0.c4 d1 0.03201f
C1241 2Div$2_0.d_flip_flop$3$2_6.NAND_3in_nmosx3$1$2_0.y VP 0.77811f
C1242 pdiv$3_0.div_with_reset$3$2_0.d_flip_flop_reset$1$2_1.NAND_2in_nmosx2$1$1$5_0.a a_927_n2600# 0.10914f
C1243 pdiv$3_0.count_data_check$2_0.NAND_3in$2_1/NAND_3in_nmosx3$5$1$2_0.y pdiv$3_0.count_data_check$2_0.XNOR$1$2_1.y 0.54643f
C1244 2Div$2_0.d_flip_flop$3$2_3.d 2Div$2_0.d_flip_flop$3$2_3.NAND_2in_nmosx2$3$2_0.a 0.60818f
C1245 pdiv$3_0.d_flip_flop_reset$2$2_0.d a_n249_5248# 0.01875f
C1246 2Div$2_0.d_flip_flop$3$2_6.NAND_3in_nmosx3$1$2_0.y a_n5259_31# 0.09585f
C1247 pdiv$3_0.div_with_reset$3$2_0.d_flip_flop_reset$1$2_1.NAND_2in_nmosx2$1$1$5_0.a pdiv$3_0.div_with_reset$3$2_0.d_flip_flop_reset$1$2_1.NAND_3in_nmosx3$1$1$3_1.a 1.93937f
C1248 MUX_8to1_0.in5 2Div$2_0.d_flip_flop$3$2_5.NAND_2in_nmosx2$3$2_0.a 0.80109f
C1249 MUX_8to1_0.in3 MUX_8to1_0.inverter_x4_ptap_mirror_fix$2$3_10.OUT 0.51699f
C1250 pdiv$3_0.passgate$3_1.A pdiv$3_0.div_with_reset$3$2_0.d_flip_flop_reset$1$2_0.clk 2.7414f
C1251 MUX_8to1_0.inverter_x4_ptap_mirror_fix$2$3_6.OUT MUX_8to1_0.passgate$1$2_7.A 0.02884f
C1252 MUX_8to1_0.inverter_x4_ptap_mirror_fix$2$3_10.OUT MUX_8to1_0.passgate$1$2_4.in_n 0.26033f
C1253 pdiv$3_0.d_flip_flop_reset$2$2_0.NAND_2in_nmosx2$1$2$2_0.a pdiv$3_0.passgate$3_1.A 0.2881f
C1254 MUX_8to1_0.passgate$1$2_0.B MUX_8to1_0.passgate$1$2_5.in_n 0.11915f
C1255 2Div$2_0.d_flip_flop$3$2_1.NAND_3in_nmosx3$1$2_0.y VP 0.77813f
C1256 pdiv$3_0.passgate$3_1.A d2 0.03601f
C1257 pdiv$3_0.div_with_reset$3$2_0.d_flip_flop_reset$1$2_0.NAND_3in_nmosx3$1$1$3_1.a VP 1.39932f
C1258 pdiv$3_0.count_data_check$2_0.c4 a_1607_n2600# 0.09933f
C1259 pdiv$3_0.div_with_reset$3$2_0.d_flip_flop_reset$1$2_0.NAND_2in_nmosx2$1$1$5_0.a VP 1.07989f
C1260 a_7434_n818# VP 0.09529f
C1261 pdiv$3_0.passgate$3_1.A pdiv$3_0.div_with_reset$3$2_0.d_flip_flop_reset$1$2_4.NAND_2in_nmosx2$1$1$5_0.b 1.05946f
C1262 VP d0 0.5904f
C1263 pdiv$3_0.passgate$3_1.A pdiv$3_0.NOR_2in$3$2_0.B 0.01897f
C1264 MUX_8to1_0.passgate$1$2_6.in_p pdiv$3_0.div_with_reset$3$2_0.d_flip_flop_reset$1$2_3.NAND_2in_nmosx2$1$1$5_0.y 0.01092f
C1265 MUX_8to1_0.passgate$1$2_7.A a2 0.0316f
C1266 pdiv$3_0.div_with_reset$3$2_0.d_flip_flop_reset$1$2_3.clk pdiv$3_0.div_with_reset$3$2_0.d_flip_flop_reset$1$2_3.NAND_2in_nmosx2$1$1$5_0.a 1.28449f
C1267 2Div$2_0.d_flip_flop$3$2_6.NAND_2in_nmosx2$3$2_0.b VP 0.14638f
C1268 MUX_8to1_0.in7 2Div$2_0.d_flip_flop$3$2_3.NAND_2in_nmosx2$3$2_0.y 0.59594f
C1269 2Div$2_0.d_flip_flop$3$2_3.NAND_2in_nmosx2$3$2_0.b a_n7509_n2147# 0.09898f
C1270 MUX_8to1_0.passgate$1$2_5.in_p MUX_8to1_0.passgate$1$2_4.in_p 0.07295f
C1271 MUX_8to1_0.passgate$1$2_0.B MUX_8to1_0.passgate$1$2_6.in_n 0.14829f
C1272 MUX_8to1_0.inverter_x4_ptap_mirror_fix$2$3_5.OUT MUX_8to1_0.passgate$1$2_0.in_p 0.13879f
C1273 2Div$2_0.d_flip_flop$3$2_1.NAND_2in_nmosx2$3$2_0.a MUX_8to1_0.in2 0.71722f
C1274 pdiv$3_0.div_with_reset$3$2_0.d_flip_flop_reset$1$2_4.NAND_2in_nmosx2$1$1$5_0.a VP 1.03888f
C1275 2Div$2_0.d_flip_flop$3$2_5.NAND_2in_nmosx2$3$2_0.b 2Div$2_0.d_flip_flop$3$2_5.NAND_3in_nmosx3$1$2_0.y 0.24214f
C1276 a_839_5248# a_941_5248# 0.07813f
C1277 a_7434_1798# VP 0.09529f
C1278 MUX_8to1_0.passgate$1$2_4.in_n MUX_8to1_0.passgate$1$2_7.in_n 0.06425f
C1279 a_n501_3040# a_n399_3040# 0.07813f
C1280 2Div$2_0.d_flip_flop$3$2_1.NAND_2in_nmosx2$3$2_0.b VP 0.14638f
C1281 pdiv$3_0.d_flip_flop_reset$2$2_0.reset VP 0.75749f
C1282 pdiv$3_0.passgate$3_1.A pdiv$3_0.div_with_reset$3$2_0.d_flip_flop_reset$1$2_2.NAND_2in_nmosx2$1$1$5_0.y 0.22234f
C1283 pdiv$3_0.count_data_check$2_0.c0 d0 0.75647f
C1284 MUX_8to1_0.inverter_x4_ptap_mirror_fix$2$3_6.OUT MUX_8to1_0.passgate$1$2_6.A 0.03234f
C1285 MUX_8to1_0.in6 MUX_8to1_0.in7 0.49513f
C1286 pdiv$3_0.passgate$3_1.A pdiv$3_0.div_with_reset$3$2_0.d_flip_flop_reset$1$2_0.NAND_3in_nmosx3$1$1$3_1.a 2.12477f
C1287 pdiv$3_0.passgate$3_1.in_n MUX_8to1_0.out 1.00483f
C1288 MUX_8to1_0.passgate$1$2_5.A VP 0.06518f
C1289 pdiv$3_0.passgate$3_1.A pdiv$3_0.div_with_reset$3$2_0.d_flip_flop_reset$1$2_0.NAND_2in_nmosx2$1$1$5_0.a 1.33757f
C1290 pdiv$3_0.count_data_check$2_0.c5 d0 0.51075f
C1291 MUX_8to1_0.passgate$1$2_6.A a2 0.17088f
C1292 MUX_8to1_0.inverter_x4_ptap_mirror_fix$2$3_5.OUT MUX_8to1_0.passgate$1$2_0.B 0.01873f
C1293 MUX_8to1_0.passgate$1$2_3.in_p VP 1.06699f
C1294 pdiv$3_0.d_flip_flop_reset$2$2_0.NAND_2in_nmosx2$1$2$2_0.a pdiv$3_0.passgate$3_1.B 1.2998f
C1295 pdiv$3_0.passgate$3_1.B d2 0.0122f
C1296 pdiv$3_0.passgate$3_1.A VP 1.47159f
C1297 pdiv$3_0.div_with_reset$3$2_0.d_flip_flop_reset$1$2_3.NAND_2in_nmosx2$1$1$5_0.b VP 1.19194f
C1298 MUX_8to1_0.in3 2Div$2_0.d_flip_flop$3$2_0.NAND_2in_nmosx2$3$2_0.y 0.59594f
C1299 pdiv$3_0.div_with_reset$3$2_0.d_flip_flop_reset$1$2_0.clk pdiv$3_0.div_with_reset$3$2_0.d_flip_flop_reset$1$2_1.NAND_3in_nmosx3$1$1$3_1.a 1.43515f
C1300 a_6702_n2099# VP 0.53334f
C1301 pdiv$3_0.d_flip_flop_reset$2$2_0.NAND_3in_nmosx3$1$2$3_1.a out_div 1.41645f
C1302 pdiv$3_0.count_data_check$2_0.NAND_3in$2_0/NAND_3in_nmosx3$5$1$2_0.y a_7357_5263# 0.01922f
C1303 pdiv$3_0.passgate$3_1.B pdiv$3_0.NOR_2in$3$2_0.B 0.01058f
C1304 pdiv$3_0.div_with_reset$3$2_0.d_flip_flop_reset$1$2_3.NAND_2in_nmosx2$1$1$5_0.a a_927_16# 0.10914f
C1305 MUX_8to1_0.passgate$1$2_5.in_p VP 1.0981f
C1306 pdiv$3_0.div_with_reset$3$2_0.d_flip_flop_reset$1$2_5.NAND_2in_nmosx2$1$1$5_0.b a_n195_3040# 0.02373f
C1307 pdiv$3_0.count_data_check$2_0.c2 a_1913_16# 0.02299f
C1308 MUX_8to1_0.inverter_x4_ptap_mirror_fix$2$3_5.OUT a1 1.0568f
C1309 MUX_8to1_0.in7 2Div$2_0.d_flip_flop$3$2_3.NAND_3in_nmosx3$1$2_0.y 0.17792f
C1310 MUX_8to1_0.passgate$1$2_5.A a0 0.63587f
C1311 pdiv$3_0.div_with_reset$3$2_0.d_flip_flop_reset$1$2_3.NAND_3in_nmosx3$1$1$3_1.a a_n93_16# 0.10805f
C1312 a_6702_517# VP 0.53334f
C1313 pdiv$3_0.div_with_reset$3$2_0.d_flip_flop_reset$1$2_3.clk pdiv$3_0.div_with_reset$3$2_0.d_flip_flop_reset$1$2_2.clk 0.16868f
C1314 MUX_8to1_0.in4 2Div$2_0.d_flip_flop$3$2_0.d 1.01958f
C1315 2Div$2_0.d_flip_flop$3$2_1.d 2Div$2_0.d_flip_flop$3$2_1.NAND_3in_nmosx3$1$2_0.y 1.35806f
C1316 pdiv$3_0.count_data_check$2_0.c2 pdiv$3_0.div_with_reset$3$2_0.d_flip_flop_reset$1$2_3.NAND_2in_nmosx2$1$1$5_0.y 0.22729f
C1317 pdiv$3_0.div_with_reset$3$2_0.d_flip_flop_reset$1$2_2.NAND_3in_nmosx3$1$1$3_1.a a_3103_16# 0.10805f
C1318 pdiv$3_0.count_data_check$2_0.NAND_3in$2_1/NAND_3in_nmosx3$5$1$2_0.y pdiv$3_0.count_data_check$2_0.XNOR$1$2_2.y 0.41409f
C1319 pdiv$3_0.count_data_check$2_0.XNOR$1$2_2.y a_6702_1847# 0.26213f
C1320 MUX_8to1_0.passgate$1$2_5.in_p a0 0.24566f
C1321 a_519_n2600# a_621_n2600# 0.07813f
C1322 2Div$2_0.d_flip_flop$3$2_1.d 2Div$2_0.d_flip_flop$3$2_1.NAND_2in_nmosx2$3$2_0.y 0.12448f
C1323 MUX_8to1_0.inverter_x4_ptap_mirror_fix$2$3_6.OUT MUX_8to1_0.in2 0.03591f
C1324 pdiv$3_0.div_with_reset$3$2_0.d_flip_flop_reset$1$2_1.NAND_3in_nmosx3$1$1$3_1.a a_n195_n2600# 0.02003f
C1325 pdiv$3_0.div_with_reset$3$2_0.d_flip_flop_reset$1$2_0.q d0 0.06478f
C1326 VP d3 0.02318f
C1327 2Div$2_0.d_flip_flop$3$2_5.d 2Div$2_0.d_flip_flop$3$2_5.NAND_2in_nmosx2$3$2_0.a 0.60818f
C1328 2Div$2_0.d_flip_flop$3$2_4.NAND_3in_nmosx3$1$2_0.y VP 0.80093f
C1329 pdiv$3_0.div_with_reset$3$2_0.d_flip_flop_reset$1$2_4.NAND_2in_nmosx2$1$1$5_0.b pdiv$3_0.div_with_reset$3$2_0.d_flip_flop_reset$1$2_4.clk 2.0105f
C1330 MUX_8to1_0.in7 MUX_8to1_0.passgate$1$2_0.A 0.51699f
C1331 pdiv$3_0.div_with_reset$3$2_0.d_flip_flop_reset$1$2_0.NAND_3in_nmosx3$1$1$3_1.a a_3001_n2600# 0.02003f
C1332 pdiv$3_0.passgate$3_1.in_n VP 0.64433f
C1333 2Div$2_0.d_flip_flop$3$2_1.NAND_2in_nmosx2$3$2_0.b 2Div$2_0.d_flip_flop$3$2_1.d 0.81289f
C1334 2Div$2_0.d_flip_flop$3$2_2.NAND_2in_nmosx2$3$2_0.a MUX_8to1_0.in3 0.12949f
C1335 MUX_8to1_0.in5 2Div$2_0.d_flip_flop$3$2_5.NAND_2in_nmosx2$3$2_0.b 1.5504f
C1336 pdiv$3_0.div_with_reset$3$2_0.d_flip_flop_reset$1$2_4.clk a_1345_3040# 0.10178f
C1337 MUX_8to1_0.in4 a1 0.05089f
C1338 2Div$2_0.d_flip_flop$3$2_4.NAND_2in_nmosx2$3$2_0.b 2Div$2_0.d_flip_flop$3$2_4.NAND_2in_nmosx2$3$2_0.y 0.8991f
C1339 pdiv$3_0.count_data_check$2_0.XNOR$1$2_2.y pdiv$3_0.count_data_check$2_0.XNOR$1$2_1.y 4.14837f
C1340 pdiv$3_0.count_data_check$2_0.NAND_3in$2_0/NAND_3in_nmosx3$5$1$2_0.y pdiv$3_0.count_data_check$2_0.XNOR$1$2_4.y 0.02679f
C1341 pdiv$3_0.passgate$3_1.B reset 0.0262f
C1342 MUX_8to1_0.inverter_x4_ptap_mirror_fix$2$3_4.OUT MUX_8to1_0.passgate$1$2_2.in_n 0.55122f
C1343 2Div$2_0.d_flip_flop$3$2_4.d a_n6761_n2585# 0.09386f
C1344 MUX_8to1_0.passgate$1$2_0.B MUX_8to1_0.passgate$1$2_7.A 0.87709f
C1345 pdiv$3_0.div_with_reset$3$2_0.d_flip_flop_reset$1$2_5.NAND_2in_nmosx2$1$1$5_0.a a_519_2632# 0.10117f
C1346 pdiv$3_0.count_data_check$2_0.c2 a_6346_517# 1.11627f
C1347 2Div$2_0.d_flip_flop$3$2_2.NAND_2in_nmosx2$3$2_0.a a_n5741_5701# 0.01293f
C1348 d3 d4 11.812f
C1349 a_519_16# a_621_16# 0.07813f
C1350 pdiv$3_0.div_with_reset$3$2_0.d_flip_flop_reset$1$2_5.NAND_3in_nmosx3$1$1$3_1.a a_n501_2632# 0.09877f
C1351 MUX_8to1_0.inverter_x4_ptap_mirror_fix$2$3_8.OUT MUX_8to1_0.inverter_x4_ptap_mirror_fix$2$3_7.OUT 0.08017f
C1352 MUX_8to1_0.in6 MUX_8to1_0.inverter_x4_ptap_mirror_fix$2$3_4.OUT 0.07972f
C1353 MUX_8to1_0.passgate$1$2_7.A a1 0.07702f
C1354 2Div$2_0.d_flip_flop$3$2_5.d MUX_8to1_0.in8 0.03218f
C1355 2Div$2_0.d_flip_flop$3$2_5.NAND_2in_nmosx2$3$2_0.a VP 0.50029f
C1356 a_6702_517# a_6702_n769# 0.01157f
C1357 pdiv$3_0.div_with_reset$3$2_0.d_flip_flop_reset$1$2_5.NAND_2in_nmosx2$1$1$5_0.y a_597_3040# 0.1016f
C1358 pdiv$3_0.div_with_reset$3$2_0.d_flip_flop_reset$1$2_4.NAND_3in_nmosx3$1$1$3_1.a a_2695_2632# 0.09877f
C1359 a_4021_n2600# a_4123_n2600# 0.09808f
C1360 pdiv$3_0.count_data_check$2_0.c3 d3 0.67771f
C1361 2Div$2_0.d_flip_flop$3$2_0.NAND_2in_nmosx2$3$2_0.a 2Div$2_0.d_flip_flop$3$2_5.NAND_2in_nmosx2$3$2_0.y 0.01058f
C1362 MUX_8to1_0.passgate$1$2_5.A MUX_8to1_0.passgate$1$2_3.in_p 0.09972f
C1363 MUX_8to1_0.inverter_x4_ptap_mirror_fix$2$3_7.OUT MUX_8to1_0.inverter_x4_ptap_mirror_fix$2$3_10.OUT 0.19835f
C1364 pdiv$3_0.count_data_check$2_0.c1 d1 0.73819f
C1365 VP clk 0.16947f
C1366 2Div$2_0.d_flip_flop$3$2_0.NAND_2in_nmosx2$3$2_0.a VP 0.50029f
C1367 pdiv$3_0.passgate$3_1.A pdiv$3_0.div_with_reset$3$2_0.d_flip_flop_reset$1$2_2.NAND_3in_nmosx3$1$1$3_1.a 2.0499f
C1368 a_6346_1847# d1 0.94865f
C1369 pdiv$3_0.count_data_check$2_0.c2 d2 0.60959f
C1370 MUX_8to1_0.passgate$1$2_0.B MUX_8to1_0.passgate$1$2_6.A 0.88418f
C1371 MUX_8to1_0.inverter_x4_ptap_mirror_fix$2$3_4.OUT a0 0.88047f
C1372 2Div$2_0.d_flip_flop$3$2_2.NAND_2in_nmosx2$3$2_0.a 2Div$2_0.d_flip_flop$3$2_2.d 0.60818f
C1373 a_6702_n769# d3 0.45031f
C1374 pdiv$3_0.passgate$3_1.A pdiv$3_0.count_data_check$2_0.XNOR$1$2_1.y 0.01207f
C1375 MUX_8to1_0.passgate$1$2_3.in_p MUX_8to1_0.passgate$1$2_5.in_p 0.03022f
C1376 MUX_8to1_0.passgate$1$2_1.in_p VP 1.06757f
C1377 pdiv$3_0.count_data_check$2_0.XNOR$1$2_1.y a_7018_3874# 0.07813f
C1378 MUX_8to1_0.passgate$1$2_6.A a1 0.0997f
C1379 pdiv$3_0.count_data_check$2_0.XNOR$1$2_3.y a_7428_n2603# 0.04351f
C1380 MUX_8to1_0.in8 VP 0.54422f
C1381 MUX_8to1_0.passgate$1$2_1.in_n a0 0.01619f
C1382 VP d5 0.5614f
C1383 a_4021_16# a_4123_16# 0.09808f
C1384 pdiv$3_0.count_data_check$2_0.c2 pdiv$3_0.div_with_reset$3$2_0.d_flip_flop_reset$1$2_2.NAND_2in_nmosx2$1$1$5_0.y 0.12259f
C1385 pdiv$3_0.count_data_check$2_0.XNOR$1$2_0.y a_7434_n1358# 0.0789f
C1386 MUX_8to1_0.passgate$1$2_7.in_p VP 1.06757f
C1387 MUX_8to1_0.passgate$1$2_1.A MUX_8to1_0.passgate$1$2_1.in_n 0.55121f
C1388 MUX_8to1_0.passgate$1$2_0.in_n pdiv$3_0.div_with_reset$3$2_0.d_flip_flop_reset$1$2_1.NAND_2in_nmosx2$1$1$5_0.b 0.01755f
C1389 MUX_8to1_0.in6 2Div$2_0.d_flip_flop$3$2_5.NAND_2in_nmosx2$3$2_0.y 0.19573f
C1390 pdiv$3_0.div_with_reset$3$2_0.d_flip_flop_reset$1$2_1.clk d3 0.05343f
C1391 2Div$2_0.d_flip_flop$3$2_6.NAND_2in_nmosx2$3$2_0.a MUX_8to1_0.in7 0.12949f
C1392 2Div$2_0.d_flip_flop$3$2_3.NAND_2in_nmosx2$3$2_0.b 2Div$2_0.d_flip_flop$3$2_3.NAND_2in_nmosx2$3$2_0.a 0.79459f
C1393 MUX_8to1_0.in6 VP 0.54535f
C1394 MUX_8to1_0.inverter_x4_ptap_mirror_fix$2$3_7.OUT VP 0.07552f
C1395 2Div$2_0.d_flip_flop$3$2_5.NAND_3in_nmosx3$1$2_0.y a_n7639_31# 0.09585f
C1396 pdiv$3_0.div_with_reset$3$2_0.d_flip_flop_reset$1$2_3.clk d1 0.05858f
C1397 MUX_8to1_0.passgate$1$2_0.A MUX_8to1_0.inverter_x4_ptap_mirror_fix$2$3_4.OUT 0.06945f
C1398 a_825_2632# a_927_2632# 0.09808f
C1399 pdiv$3_0.d_flip_flop_reset$2$2_0.NAND_2in_nmosx2$1$2$2_0.a MUX_8to1_0.out 0.36247f
C1400 2Div$2_0.d_flip_flop$3$2_1.d a_n6761_2647# 0.09386f
C1401 pdiv$3_0.count_data_check$2_0.c2 VP 1.10617f
C1402 pdiv$3_0.d_flip_flop_reset$2$2_0.NAND_2in_nmosx2$1$2$2_0.b pdiv$3_0.passgate$3_1.A 0.02818f
C1403 2Div$2_0.d_flip_flop$3$2_5.NAND_2in_nmosx2$3$2_0.b 2Div$2_0.d_flip_flop$3$2_5.d 0.81289f
C1404 VP pdiv$3_0.inverter_x8$3_0.IN 0.31532f
C1405 MUX_8to1_0.inverter_x4_ptap_mirror_fix$2$3_6.OUT a2 1.64911f
C1406 2Div$2_0.d_flip_flop$3$2_6.NAND_2in_nmosx2$3$2_0.b 2Div$2_0.d_flip_flop$3$2_6.NAND_3in_nmosx3$1$2_0.y 0.24214f
C1407 pdiv$3_0.count_data_check$2_0.XNOR$1$2_4.y a_6346_1847# 0.03033f
C1408 pdiv$3_0.div_with_reset$3$2_0.d_flip_flop_reset$1$2_3.NAND_2in_nmosx2$1$1$5_0.b pdiv$3_0.div_with_reset$3$2_0.d_flip_flop_reset$1$2_1.NAND_2in_nmosx2$1$1$5_0.y 0.01266f
C1409 pdiv$3_0.d_flip_flop_reset$2$2_0.d out_div 1.11681f
C1410 pdiv$3_0.div_with_reset$3$2_0.d_flip_flop_reset$1$2_3.clk a_4541_3040# 0.10178f
C1411 2Div$2_0.d_flip_flop$3$2_6.NAND_2in_nmosx2$3$2_0.b 2Div$2_0.d_flip_flop$3$2_6.NAND_2in_nmosx2$3$2_0.y 0.8991f
C1412 pdiv$3_0.div_with_reset$3$2_0.d_flip_flop_reset$1$2_1.NAND_2in_nmosx2$1$1$5_0.b pdiv$3_0.div_with_reset$3$2_0.d_flip_flop_reset$1$2_1.NAND_2in_nmosx2$1$1$5_0.a 0.99113f
C1413 pdiv$3_0.count_data_check$2_0.c0 VP 1.10617f
C1414 pdiv$3_0.passgate$3_1.A d5 0.68809f
C1415 pdiv$3_0.div_with_reset$3$2_0.d_flip_flop_reset$1$2_1.clk pdiv$3_0.div_with_reset$3$2_0.d_flip_flop_reset$1$2_0.NAND_2in_nmosx2$1$1$5_0.b 0.40148f
C1416 VP a0 0.1949f
C1417 2Div$2_0.d_flip_flop$3$2_0.d 2Div$2_0.d_flip_flop$3$2_0.NAND_3in_nmosx3$1$2_0.y 1.35806f
C1418 pdiv$3_0.div_with_reset$3$2_0.d_flip_flop_reset$1$2_3.NAND_3in_nmosx3$1$1$3_1.a VP 1.3684f
C1419 pdiv$3_0.NOR_2in$3$2_0.A a_4949_5263# 0.09585f
C1420 MUX_8to1_0.passgate$1$2_1.A VP 0.18926f
C1421 VP d4 0.15061f
C1422 pdiv$3_0.count_data_check$2_0.XNOR$1$2_0.y a_7020_n2099# 0.04296f
C1423 2Div$2_0.d_flip_flop$3$2_0.NAND_2in_nmosx2$3$2_0.a 2Div$2_0.d_flip_flop$3$2_1.d 0.01074f
C1424 pdiv$3_0.div_with_reset$3$2_0.d_flip_flop_reset$1$2_5.NAND_3in_nmosx3$1$1$3_1.a VP 1.3684f
C1425 2Div$2_0.d_flip_flop$3$2_4.d VP 0.19541f
C1426 2Div$2_0.d_flip_flop$3$2_5.NAND_2in_nmosx2$3$2_0.b VP 0.14651f
C1427 pdiv$3_0.count_data_check$2_0.c0 d4 0.03079f
C1428 MUX_8to1_0.inverter_x4_ptap_mirror_fix$2$3_8.OUT VP 0.983f
C1429 pdiv$3_0.d_flip_flop_reset$2$2_0.NAND_2in_nmosx2$1$2$2_0.b pdiv$3_0.passgate$3_1.B 1.88968f
C1430 MUX_8to1_0.passgate$1$2_3.in_n MUX_8to1_0.passgate$1$2_5.in_n 0.06425f
C1431 pdiv$3_0.count_data_check$2_0.XNOR$1$2_5.y a_7428_13# 0.04368f
C1432 a_4803_2632# a_4905_2632# 0.07813f
C1433 MUX_8to1_0.in8 2Div$2_0.d_flip_flop$3$2_4.NAND_3in_nmosx3$1$2_0.y 0.18144f
C1434 MUX_8to1_0.in6 2Div$2_0.d_flip_flop$3$2_4.NAND_2in_nmosx2$3$2_0.a 0.71722f
C1435 pdiv$3_0.count_data_check$2_0.c5 d4 0.03722f
C1436 2Div$2_0.d_flip_flop$3$2_0.NAND_2in_nmosx2$3$2_0.b VP 0.14651f
C1437 MUX_8to1_0.in5 MUX_8to1_0.in7 0.03242f
C1438 MUX_8to1_0.out reset 0.05219f
C1439 pdiv$3_0.d_flip_flop_reset$2$2_0.NAND_2in_nmosx2$1$2$2_0.a VP 0.13183f
C1440 VP d2 0.14773f
C1441 pdiv$3_0.count_data_check$2_0.c1 a_6346_1847# 1.05367f
C1442 pdiv$3_0.d_flip_flop_reset$2$2_0.NAND_2in_nmosx2$1$2$2_0.y out_div 0.05581f
C1443 pdiv$3_0.div_with_reset$3$2_0.d_flip_flop_reset$1$2_4.NAND_2in_nmosx2$1$1$5_0.a a_4123_2632# 0.10914f
C1444 2Div$2_0.d_flip_flop$3$2_1.d VP 0.19541f
C1445 pdiv$3_0.div_with_reset$3$2_0.d_flip_flop_reset$1$2_1.clk MUX_8to1_0.passgate$1$2_2.in_n 0.02014f
C1446 MUX_8to1_0.in4 2Div$2_0.d_flip_flop$3$2_6.d 0.01219f
C1447 pdiv$3_0.NOR_2in$3$2_0.B VP 0.49563f
C1448 pdiv$3_0.passgate$3_1.A VP 1.81444f
C1449 pdiv$3_0.div_with_reset$3$2_0.d_flip_flop_reset$1$2_1.NAND_2in_nmosx2$1$1$5_0.b pdiv$3_0.div_with_reset$3$2_0.d_flip_flop_reset$1$2_0.clk 0.13764f
C1450 MUX_8to1_0.passgate$1$2_4.in_p a_n2333_3085# 0.09585f
C1451 MUX_8to1_0.in7 a_n6761_n2585# 0.01281f
C1452 2Div$2_0.d_flip_flop$3$2_4.NAND_2in_nmosx2$3$2_0.a a0 0.08831f
C1453 MUX_8to1_0.passgate$1$2_6.in_n pdiv$3_0.div_with_reset$3$2_0.d_flip_flop_reset$1$2_3.NAND_2in_nmosx2$1$1$5_0.b 0.01755f
C1454 MUX_8to1_0.passgate$1$2_0.in_p a2 0.09073f
C1455 pdiv$3_0.div_with_reset$3$2_0.d_flip_flop_reset$1$2_1.NAND_2in_nmosx2$1$1$5_0.a a_621_n2600# 0.02156f
C1456 MUX_8to1_0.inverter_x4_ptap_mirror_fix$2$3_5.OUT MUX_8to1_0.passgate$1$2_3.in_n 0.0168f
C1457 pdiv$3_0.d_flip_flop_reset$2$2_0.d a_n555_5248# 0.1084f
C1458 pdiv$3_0.count_data_check$2_0.c2 pdiv$3_0.div_with_reset$3$2_0.d_flip_flop_reset$1$2_2.NAND_3in_nmosx3$1$1$3_1.a 0.52318f
C1459 pdiv$3_0.div_with_reset$3$2_0.d_flip_flop_reset$1$2_1.NAND_2in_nmosx2$1$1$5_0.b a_n195_n2192# 0.02373f
C1460 pdiv$3_0.count_data_check$2_0.c1 pdiv$3_0.div_with_reset$3$2_0.d_flip_flop_reset$1$2_3.clk 1.48512f
C1461 pdiv$3_0.d_flip_flop_reset$2$2_0.NAND_3in_nmosx3$1$2$3_1.a VP 1.3952f
C1462 a_7018_1258# VP 0.09529f
C1463 pdiv$3_0.passgate$3_1.in_p a_4304_4466# 0.05335f
C1464 MUX_8to1_0.in4 2Div$2_0.d_flip_flop$3$2_1.NAND_3in_nmosx3$1$2_0.y 0.20535f
C1465 a_n6421_5701# MUX_8to1_0.in2 0.09893f
C1466 pdiv$3_0.div_with_reset$3$2_0.d_flip_flop_reset$1$2_3.NAND_2in_nmosx2$1$1$5_0.b a_n93_424# 0.10948f
C1467 a_n2333_n2585# a0 0.01114f
C1468 2Div$2_0.d_flip_flop$3$2_4.d 2Div$2_0.d_flip_flop$3$2_4.NAND_3in_nmosx3$1$2_0.y 1.35806f
C1469 pdiv$3_0.div_with_reset$3$2_0.d_flip_flop_reset$1$2_3.NAND_2in_nmosx2$1$1$5_0.b pdiv$3_0.div_with_reset$3$2_0.d_flip_flop_reset$1$2_3.NAND_2in_nmosx2$1$1$5_0.a 0.99113f
C1470 MUX_8to1_0.in4 2Div$2_0.d_flip_flop$3$2_1.NAND_2in_nmosx2$3$2_0.y 0.13403f
C1471 pdiv$3_0.div_with_reset$3$2_0.d_flip_flop_reset$1$2_1.clk pdiv$3_0.count_data_check$2_0.c5 0.03067f
C1472 VP reset 0.20598f
C1473 pdiv$3_0.div_with_reset$3$2_0.d_flip_flop_reset$1$2_1.NAND_3in_nmosx3$1$1$3_1.a VP 1.3563f
C1474 MUX_8to1_0.inverter_x4_ptap_mirror_fix$2$3_6.OUT a1 0.37571f
C1475 pdiv$3_0.div_with_reset$3$2_0.d_flip_flop_reset$1$2_1.NAND_2in_nmosx2$1$1$5_0.b VP 1.19194f
C1476 d2 d0 0.67532f
C1477 MUX_8to1_0.passgate$1$2_0.B pdiv$3_0.div_with_reset$3$2_0.d_flip_flop_reset$1$2_5.NAND_2in_nmosx2$1$1$5_0.y 0.07006f
C1478 a_4304_4466# VP 0.06667f
C1479 2Div$2_0.d_flip_flop$3$2_2.NAND_2in_nmosx2$3$2_0.a 2Div$2_0.d_flip_flop$3$2_2.NAND_2in_nmosx2$3$2_0.y 0.44392f
C1480 pdiv$3_0.passgate$3_1.A pdiv$3_0.div_with_reset$3$2_0.d_flip_flop_reset$1$2_5.NAND_2in_nmosx2$1$1$5_0.a 1.3457f
C1481 MUX_8to1_0.in4 2Div$2_0.d_flip_flop$3$2_1.NAND_2in_nmosx2$3$2_0.b 0.25817f
C1482 pdiv$3_0.NOR_2in$3$2_0.B d0 0.25936f
C1483 a1 a2 10.3156f
C1484 pdiv$3_0.count_data_check$2_0.XNOR$1$2_1.y a_6346_3133# 0.29508f
C1485 2Div$2_0.d_flip_flop$3$2_6.NAND_2in_nmosx2$3$2_0.a VP 0.1411f
C1486 MUX_8to1_0.in3 2Div$2_0.d_flip_flop$3$2_2.d 0.18355f
C1487 pdiv$3_0.div_with_reset$3$2_0.d_flip_flop_reset$1$2_0.clk a_1345_n2192# 0.10178f
C1488 MUX_8to1_0.inverter_x4_ptap_mirror_fix$2$3_8.OUT MUX_8to1_0.passgate$1$2_5.A 0.17795f
C1489 pdiv$3_0.div_with_reset$3$2_0.d_flip_flop_reset$1$2_5.NAND_2in_nmosx2$1$1$5_0.b MUX_8to1_0.passgate$1$2_7.in_p 0.01092f
C1490 2Div$2_0.d_flip_flop$3$2_2.NAND_3in_nmosx3$1$2_0.y clk 0.18316f
C1491 pdiv$3_0.div_with_reset$3$2_0.d_flip_flop_reset$1$2_4.NAND_2in_nmosx2$1$1$5_0.b a_3001_3040# 0.02373f
C1492 pdiv$3_0.passgate$3_1.B pdiv$3_0.passgate$3_1.A 0.81553f
C1493 VP 2Div$2_0.d_flip_flop$3$2_2.NAND_2in_nmosx2$3$2_0.b 0.14638f
C1494 pdiv$3_0.div_with_reset$3$2_0.d_flip_flop_reset$1$2_4.NAND_2in_nmosx2$1$1$5_0.y pdiv$3_0.count_data_check$2_0.c1 0.10471f
C1495 MUX_8to1_0.inverter_x4_ptap_mirror_fix$2$3_4.OUT MUX_8to1_0.passgate$1$2_0.in_n 0.13718f
C1496 pdiv$3_0.div_with_reset$3$2_0.d_flip_flop_reset$1$2_5.NAND_2in_nmosx2$1$1$5_0.b VP 1.21402f
C1497 MUX_8to1_0.passgate$1$2_2.in_p a2 0.14017f
C1498 pdiv$3_0.div_with_reset$3$2_0.d_flip_flop_reset$1$2_4.NAND_3in_nmosx3$1$1$3_1.a d1 0.01693f
C1499 MUX_8to1_0.in6 a_n9141_31# 0.01677f
C1500 a_7020_3133# d0 0.01014f
C1501 MUX_8to1_0.in7 a_n6421_n2147# 0.09596f
C1502 pdiv$3_0.passgate$3_1.A pdiv$3_0.div_with_reset$3$2_0.d_flip_flop_reset$1$2_1.NAND_3in_nmosx3$1$1$3_1.a 2.35652f
C1503 a_2695_3040# a_2797_3040# 0.07813f
C1504 MUX_8to1_0.passgate$1$2_5.A MUX_8to1_0.inverter_x4_ptap_mirror_fix$2$3_10.OUT 0.06769f
C1505 pdiv$3_0.count_data_check$2_0.c2 d5 0.0557f
C1506 a_7018_n3434# VP 0.09529f
C1507 pdiv$3_0.div_with_reset$3$2_0.d_flip_flop_reset$1$2_3.NAND_2in_nmosx2$1$1$5_0.a a_621_16# 0.02156f
C1508 pdiv$3_0.div_with_reset$3$2_0.d_flip_flop_reset$1$2_1.clk pdiv$3_0.div_with_reset$3$2_0.d_flip_flop_reset$1$2_0.q 0.07707f
C1509 VP gd 17.75707f
C1510 VP gd 17.03913f
C1511 VP gd 21.36237f
C1512 VP gd 23.15597f
C1513 VP gd 7.69473f
C1514 a_7434_n3434# gd 1.61392f
C1515 a_7428_n2603# gd 0.06728f
C1516 a_7020_n2603# gd 0.06565f
C1517 a_5211_n2600# gd 0.03349f
C1518 a_5109_n2600# gd 0.12234f
C1519 a_4905_n2600# gd 0.10251f
C1520 a_4803_n2600# gd 1.03619f
C1521 a_4123_n2600# gd 0.03349f
C1522 a_4021_n2600# gd 0.12234f
C1523 a_3817_n2600# gd 0.10251f
C1524 a_3715_n2600# gd 0.02473f
C1525 a_3103_n2600# gd 0.03349f
C1526 a_3001_n2600# gd 0.12234f
C1527 a_2797_n2600# gd 0.10251f
C1528 a_2695_n2600# gd 0.02473f
C1529 a_2015_n2600# gd 0.03349f
C1530 a_1913_n2600# gd 0.12234f
C1531 a_1709_n2600# gd 0.10251f
C1532 a_1607_n2600# gd 0.02473f
C1533 a_927_n2600# gd 0.9838f
C1534 a_825_n2600# gd 0.12234f
C1535 a_621_n2600# gd 0.10251f
C1536 a_519_n2600# gd 0.02473f
C1537 a_n93_n2600# gd 0.25829f
C1538 a_n195_n2600# gd 0.5975f
C1539 a_n399_n2600# gd 1.08361f
C1540 a_n501_n2600# gd 1.00584f
C1541 a_n2333_n2585# gd 0.04162f
C1542 a_n2435_n2585# gd 0.12441f
C1543 a_n5157_n2585# gd 0.12441f
C1544 a_n5259_n2585# gd 0.1854f
C1545 a_n6013_n2585# gd 0.55612f
C1546 a_n6761_n2585# gd 0.1247f
C1547 a_n7537_n2585# gd 0.12441f
C1548 a_n7639_n2585# gd 0.1859f
C1549 a_n8393_n2585# gd 1.28263f
C1550 a_n9141_n2585# gd 1.56465f
C1551 a_7428_n2099# gd 0.44872f
C1552 a_7020_n2099# gd 0.06565f
C1553 a_4541_n2192# gd 0.41756f
C1554 a_3793_n2192# gd 0.37396f
C1555 a_3103_n2192# gd 0.0651f
C1556 a_3001_n2192# gd 0.12234f
C1557 a_2797_n2192# gd 0.10251f
C1558 a_2695_n2192# gd 0.15117f
C1559 a_1345_n2192# gd 0.1211f
C1560 a_597_n2192# gd 3.43642f
C1561 a_n93_n2192# gd 0.03349f
C1562 a_n195_n2192# gd 0.12234f
C1563 a_n399_n2192# gd 0.10251f
C1564 a_n501_n2192# gd 0.02473f
C1565 a_n2333_n2147# gd 1.09331f
C1566 a_n2435_n2147# gd 1.17611f
C1567 a_n5129_n2147# gd 2.54298f
C1568 a_n5741_n2147# gd 0.1247f
C1569 a_n6421_n2147# gd 0.1247f
C1570 a_n7509_n2147# gd 1.46678f
C1571 a_n8121_n2147# gd 0.1247f
C1572 a_n8801_n2147# gd 0.1247f
C1573 a_7434_n1358# gd 1.14499f
C1574 pdiv$3_0.div_with_reset$3$2_0.d_flip_flop_reset$1$2_0.NAND_2in_nmosx2$1$1$5_0.b gd 0.03161f
C1575 MUX_8to1_0.inverter_x4_ptap_mirror_fix$2$3_4.OUT gd 1.77425f
C1576 2Div$2_0.d_flip_flop$3$2_4.d gd 0.63394f
C1577 2Div$2_0.d_flip_flop$3$2_3.d gd 0.66455f
C1578 a_7018_n818# gd 0.74076f
C1579 a_7428_13# gd 0.3876f
C1580 a_7020_13# gd 0.28808f
C1581 a_5211_16# gd 0.65965f
C1582 a_5109_16# gd 0.74851f
C1583 a_4905_16# gd 0.10251f
C1584 a_4803_16# gd 0.02473f
C1585 a_4123_16# gd 1.05555f
C1586 a_4021_16# gd 1.14441f
C1587 a_3817_16# gd 0.10251f
C1588 a_3715_16# gd 0.16171f
C1589 a_3103_16# gd 0.97183f
C1590 a_3001_16# gd 1.61699f
C1591 a_2797_16# gd 0.10251f
C1592 a_2695_16# gd 0.29868f
C1593 a_2015_16# gd 0.03349f
C1594 a_1913_16# gd 0.12234f
C1595 a_1709_16# gd 0.10251f
C1596 a_1607_16# gd 0.02473f
C1597 a_927_16# gd 0.03349f
C1598 a_825_16# gd 0.12234f
C1599 a_621_16# gd 0.10251f
C1600 a_519_16# gd 0.32334f
C1601 a_n93_16# gd 0.90965f
C1602 a_n195_16# gd 0.12234f
C1603 a_n399_16# gd 1.06816f
C1604 a_n501_16# gd 0.99038f
C1605 a_n2333_31# gd 0.04162f
C1606 a_n2435_31# gd 1.93211f
C1607 MUX_8to1_0.passgate$1$2_0.A gd 1.19699f
C1608 a_n5157_31# gd 0.12441f
C1609 a_n5259_31# gd 0.04162f
C1610 a_n6013_31# gd 1.40348f
C1611 a_n6761_31# gd 0.1247f
C1612 a_n7537_31# gd 0.12441f
C1613 a_n7639_31# gd 0.04162f
C1614 a_n8393_31# gd 0.1247f
C1615 a_n9141_31# gd 1.3126f
C1616 pdiv$3_0.div_with_reset$3$2_0.d_flip_flop_reset$1$2_2.NAND_3in_nmosx3$1$1$3_1.a gd 0.03601f
C1617 a_7428_517# gd 0.77395f
C1618 a_7020_517# gd 0.98024f
C1619 a_4541_424# gd 0.1211f
C1620 a_3793_424# gd 0.18958f
C1621 a_3103_424# gd 0.03349f
C1622 a_3001_424# gd 0.12234f
C1623 a_2797_424# gd 0.10251f
C1624 a_2695_424# gd 0.02473f
C1625 a_1345_424# gd 0.19311f
C1626 a_597_424# gd 0.67616f
C1627 a_n93_424# gd 0.4831f
C1628 a_n195_424# gd 0.43135f
C1629 a_n399_424# gd 0.10251f
C1630 a_n501_424# gd 0.30227f
C1631 a_n2333_469# gd 0.04162f
C1632 a_n2435_469# gd 0.12441f
C1633 a_n5129_469# gd 0.1247f
C1634 a_n5741_469# gd 0.1247f
C1635 a_n6421_469# gd 0.36266f
C1636 a_n7509_469# gd 0.1247f
C1637 a_n8121_469# gd 0.1247f
C1638 a_n8801_469# gd 1.36866f
C1639 a_7434_1258# gd 0.2243f
C1640 pdiv$3_0.div_with_reset$3$2_0.d_flip_flop_reset$1$2_2.NAND_2in_nmosx2$1$1$5_0.y gd 0.06849f
C1641 MUX_8to1_0.passgate$1$2_1.A gd 1.93857f
C1642 2Div$2_0.d_flip_flop$3$2_5.d gd 1.05488f
C1643 a_7428_2629# gd 1.75242f
C1644 a_7020_2629# gd 0.39551f
C1645 a_5211_2632# gd 0.03349f
C1646 a_5109_2632# gd 0.12234f
C1647 a_4905_2632# gd 0.84182f
C1648 a_4803_2632# gd 1.20066f
C1649 a_4123_2632# gd 0.03349f
C1650 a_4021_2632# gd 0.12234f
C1651 a_3817_2632# gd 0.10251f
C1652 a_3715_2632# gd 0.02473f
C1653 a_3103_2632# gd 0.03349f
C1654 a_3001_2632# gd 0.12234f
C1655 a_2797_2632# gd 0.66069f
C1656 a_2695_2632# gd 0.02473f
C1657 a_2015_2632# gd 0.67742f
C1658 a_1913_2632# gd 0.76628f
C1659 a_1709_2632# gd 0.10251f
C1660 a_1607_2632# gd 1.40325f
C1661 a_927_2632# gd 0.03349f
C1662 a_825_2632# gd 0.12234f
C1663 a_621_2632# gd 0.10251f
C1664 a_519_2632# gd 0.51893f
C1665 a_n93_2632# gd 0.03349f
C1666 a_n195_2632# gd 0.67736f
C1667 a_n399_2632# gd 0.10251f
C1668 a_n501_2632# gd 0.02473f
C1669 a_n2333_2647# gd 0.04162f
C1670 a_n2435_2647# gd 0.12441f
C1671 MUX_8to1_0.passgate$1$2_6.A gd 1.71575f
C1672 a_n5157_2647# gd 0.12441f
C1673 a_n5259_2647# gd 0.74992f
C1674 a_n6013_2647# gd 0.1247f
C1675 a_n6761_2647# gd 1.70118f
C1676 a_n7537_2647# gd 0.61356f
C1677 a_n7639_2647# gd 0.04162f
C1678 a_n8393_2647# gd 0.63192f
C1679 a_n9141_2647# gd 2.66954f
C1680 a_7428_3133# gd 0.06728f
C1681 a_7020_3133# gd 0.23079f
C1682 a_4541_3040# gd 0.1211f
C1683 a_3793_3040# gd 0.1211f
C1684 a_3103_3040# gd 0.03349f
C1685 a_3001_3040# gd 0.38597f
C1686 a_2797_3040# gd 0.10251f
C1687 a_2695_3040# gd 0.48179f
C1688 a_1345_3040# gd 0.17535f
C1689 a_597_3040# gd 0.1211f
C1690 a_n93_3040# gd 0.03349f
C1691 a_n195_3040# gd 0.12234f
C1692 a_n399_3040# gd 0.85605f
C1693 a_n501_3040# gd 0.77827f
C1694 a_n2333_3085# gd 0.04162f
C1695 a_n2435_3085# gd 0.12441f
C1696 a_7434_3874# gd 2.23644f
C1697 a_n5129_3085# gd 0.41215f
C1698 a_n5741_3085# gd 0.1247f
C1699 a_n6421_3085# gd 0.23604f
C1700 a_n7509_3085# gd 0.8961f
C1701 a_n8121_3085# gd 0.37831f
C1702 a_n8801_3085# gd 0.1247f
C1703 pdiv$3_0.div_with_reset$3$2_0.d_flip_flop_reset$1$2_5.NAND_2in_nmosx2$1$1$5_0.a gd 0.4942f
C1704 MUX_8to1_0.passgate$1$2_7.A gd 1.78463f
C1705 2Div$2_0.d_flip_flop$3$2_0.NAND_2in_nmosx2$3$2_0.b gd 0.89821f
C1706 a_4304_4466# gd 0.69437f
C1707 a_7459_5263# gd 1.67066f
C1708 a_7357_5263# gd 2.41912f
C1709 a_5051_5263# gd 0.12441f
C1710 a_4949_5263# gd 0.04162f
C1711 pdiv$3_0.count_data_check$2_0.XNOR$1$2_5.y gd 0.32032f
C1712 pdiv$3_0.count_data_check$2_0.XNOR$1$2_0.y gd 1.14304f
C1713 a_1961_5248# gd 0.02473f
C1714 a_1859_5248# gd 0.10251f
C1715 a_1655_5248# gd 0.87588f
C1716 a_1553_5248# gd 0.78703f
C1717 a_941_5248# gd 0.62326f
C1718 a_839_5248# gd 0.70103f
C1719 a_635_5248# gd 0.12234f
C1720 a_533_5248# gd 0.03349f
C1721 a_n147_5248# gd 0.02473f
C1722 a_n249_5248# gd 0.10251f
C1723 a_n453_5248# gd 0.78222f
C1724 a_n555_5248# gd 0.69336f
C1725 a_n2333_5263# gd 0.04162f
C1726 a_n2435_5263# gd 0.12441f
C1727 MUX_8to1_0.inverter_x4_ptap_mirror_fix$2$3_10.OUT gd 1.02374f
C1728 a_n5157_5263# gd 0.12441f
C1729 a_n5259_5263# gd 0.37448f
C1730 a_n6013_5263# gd 1.14076f
C1731 a_n6761_5263# gd 2.15682f
C1732 pdiv$3_0.d_flip_flop_reset$2$2_0.NAND_3in_nmosx3$1$2$3_1.a gd 0.15837f
C1733 a_7459_5701# gd 2.21668f
C1734 a_7357_5701# gd 1.57051f
C1735 a_5051_5701# gd 0.12441f
C1736 a_4949_5701# gd 0.04162f
C1737 a_1961_5656# gd 0.34148f
C1738 a_1859_5656# gd 0.98258f
C1739 a_1655_5656# gd 0.12234f
C1740 a_1553_5656# gd 0.47606f
C1741 a_863_5656# gd 0.90909f
C1742 a_115_5656# gd 1.30981f
C1743 a_6888_6498# gd 0.41227f
C1744 a_n2333_5701# gd 0.04162f
C1745 a_n2435_5701# gd 0.12441f
C1746 a_n5129_5701# gd 0.42698f
C1747 a_n5741_5701# gd 0.1247f
C1748 a_n6421_5701# gd 0.1247f
C1749 MUX_8to1_0.out gd 0.58153f
C1750 MUX_8to1_0.passgate$1$2_5.A gd 1.70506f
C1751 MUX_8to1_0.inverter_x4_ptap_mirror_fix$2$3_8.OUT gd 1.75021f
C1752 2Div$2_0.d_flip_flop$3$2_2.d gd 0.10504f
C1753 pdiv$3_0.inverter_x8$3_0.IN gd 1.49314f
.ends

* expanding   symbol:  /foss/designs/CHIP-PLL/schematics/divider/schematics/2Div.sym # of pins=10
** sym_path: /foss/designs/CHIP-PLL/schematics/divider/schematics/2Div.sym
** sch_path: /foss/designs/CHIP-PLL/schematics/divider/schematics/2Div.sch
.subckt 2Div gd vp in div2 div4 div8 div16 div32 div64 div128
*.iopin gd
*.ipin in
*.iopin vp
*.opin div2
*.opin div4
*.opin div8
*.opin div16
*.opin div32
*.opin div64
*.opin div128
x1 div2 vp gd net1 in net1 d_flip_flop
x2 div4 vp gd net2 div2 net2 d_flip_flop
x3 div32 vp gd net5 div16 net5 d_flip_flop
x4 div64 vp gd net6 div32 net6 d_flip_flop
x5 div8 vp gd net3 div4 net3 d_flip_flop
x6 div16 vp gd net4 div8 net4 d_flip_flop
x7 div128 vp gd net7 div64 net7 d_flip_flop
.ends

* expanding   symbol:  /foss/designs/CHIP-PLL/schematics/divider/schematics/MUX_8to1.sym # of pins=14
** sym_path: /foss/designs/CHIP-PLL/schematics/divider/schematics/MUX_8to1.sym
** sch_path: /foss/designs/CHIP-PLL/schematics/divider/schematics/MUX_8to1.sch
.subckt MUX_8to1 gd vp A0 out in1 in2 in3 in4 in5 in6 in7 A1 in8 A2
*.iopin gd
*.iopin vp
*.opin out
*.ipin in1
*.ipin in2
*.ipin in3
*.ipin in4
*.ipin in5
*.ipin in6
*.ipin in7
*.ipin in8
*.ipin A0
*.ipin A1
*.ipin A2
x9 A0 net1 vp gd inverter
x10 A1 net2 vp gd inverter
x11 A2 net3 vp gd inverter
x28 out_unb out vp gd inverter
x29 in4 net8 vp gd inverter
x30 in8 net4 vp gd inverter
x31 in7 net5 vp gd inverter
x32 in6 net6 vp gd inverter
x33 in5 net7 vp gd inverter
x34 in1 net11 vp gd inverter
x35 in2 net10 vp gd inverter
x36 in3 net9 vp gd inverter
x1 en8_ vp gd en8 net4 out_unb passgate
x2 en7_ vp gd en7 net5 out_unb passgate
x3 en6_ vp gd en6 net6 out_unb passgate
x4 en5_ vp gd en5 net7 out_unb passgate
x5 en4_ vp gd en4 net8 out_unb passgate
x6 en3_ vp gd en3 net9 out_unb passgate
x7 en2_ vp gd en2 net10 out_unb passgate
x8 en1_ vp gd en1 net11 out_unb passgate
x13 en1_ en1 vp gd inverter
x15 en2_ en2 vp gd inverter
x17 en3_ en3 vp gd inverter
x19 en4_ en4 vp gd inverter
x21 en5_ en5 vp gd inverter
x23 en6_ en6 vp gd inverter
x25 en7_ en7 vp gd inverter
x27 en8_ en8 vp gd inverter
x12 vp gd net3 en1_ net2 net1 NAND_3in
x14 vp gd net2 en2_ net3 A0 NAND_3in
x16 vp gd net1 en3_ net3 A1 NAND_3in
x18 vp gd net3 en4_ A1 A0 NAND_3in
x20 vp gd net1 en5_ net2 A2 NAND_3in
x22 vp gd net2 en6_ A2 A0 NAND_3in
x24 vp gd net1 en7_ A2 A1 NAND_3in
x26 vp gd A2 en8_ A1 A0 NAND_3in
.ends

* expanding   symbol:  /foss/designs/CHIP-PLL/schematics/divider/schematics/pdiv.sym # of pins=11
** sym_path: /foss/designs/CHIP-PLL/schematics/divider/schematics/pdiv.sym
** sch_path: /foss/designs/CHIP-PLL/schematics/divider/schematics/pdiv.sch
.subckt pdiv gd VP clk reset d0 d1 d2 d3 d4 d5 out_div
*.iopin gd
*.ipin clk
*.iopin VP
*.ipin d0
*.ipin d1
*.ipin d2
*.ipin d3
*.ipin d4
*.ipin d5
*.opin out_div
*.ipin reset
x4 VP gd d0 d012 d1 d2 NAND_3in
x7 VP gd d3 d345 d4 d5 NAND_3in
x5 VP gd d012 bypass d345 NOR_2in
x6 bypass net3 VP gd inverter
x3 net3 VP gd bypass clk net1 passgate_scaled
x9 bypass VP gd net3 out net1 passgate_scaled
x1 gd VP clk out div2 div4 div8 div16 div32 div64 div_with_reset
x2 out_pre_buff VP gd div2 div4 div8 div16 div32 div64 d0 d1 d2 d3 d4 d5 count_data_check
x11 out_div VP gd net2 net1 net2 net4 d_flip_flop_reset
x10 reset net4 VP gd inverter
x13 out_pre_buff out VP gd inverter_x8
.ends

* expanding   symbol:  /foss/designs/CHIP-PLL/schematics/divider/schematics/d_flip_flop.sym # of pins=6
** sym_path: /foss/designs/CHIP-PLL/schematics/divider/schematics/d_flip_flop.sym
** sch_path: /foss/designs/CHIP-PLL/schematics/divider/schematics/d_flip_flop.sch
.subckt d_flip_flop q VP GND q_ clk d
*.iopin GND
*.ipin clk
*.iopin VP
*.ipin d
*.opin q
*.opin q_
x1 VP GND net1 net3 clk net4 NAND_3in
x2 VP GND net4 net2 net1 NAND_2in
x3 VP GND net2 net1 clk NAND_2in
x4 VP GND net3 net4 d NAND_2in
x5 VP GND q q_ net3 NAND_2in
x6 VP GND net1 q q_ NAND_2in
.ends

* expanding   symbol:  /foss/designs/CHIP-PLL/schematics/divider/schematics/inverter.sym # of pins=4
** sym_path: /foss/designs/CHIP-PLL/schematics/divider/schematics/inverter.sym
** sch_path: /foss/designs/CHIP-PLL/schematics/divider/schematics/inverter.sch
.subckt inverter IN OUT VP GND
*.ipin IN
*.iopin VP
*.opin OUT
*.iopin GND
XM1 OUT IN GND GND sg13_lv_nmos w=0.15u l=0.13u ng=1 m=1 mm_ok=1
XM2 OUT IN VP VP sg13_lv_pmos w=0.15u l=0.13u ng=1 m=1 mm_ok=1
.ends

* expanding   symbol:  /foss/designs/CHIP-PLL/schematics/divider/schematics/passgate.sym # of pins=6
** sym_path: /foss/designs/CHIP-PLL/schematics/divider/schematics/passgate.sym
** sch_path: /foss/designs/CHIP-PLL/schematics/divider/schematics/passgate.sch
.subckt passgate en_ VP GND en IO OI
*.iopin OI
*.iopin IO
*.iopin VP
*.iopin GND
*.ipin en_
*.ipin en
XM1 IO en OI GND sg13_lv_nmos w=0.15u l=0.13u ng=1 m=1 mm_ok=1
XM2 IO en_ OI VP sg13_lv_pmos w=0.15u l=0.13u ng=1 m=1 mm_ok=1
.ends

* expanding   symbol:  /foss/designs/CHIP-PLL/schematics/divider/schematics/NAND_3in.sym # of pins=6
** sym_path: /foss/designs/CHIP-PLL/schematics/divider/schematics/NAND_3in.sym
** sch_path: /foss/designs/CHIP-PLL/schematics/divider/schematics/NAND_3in.sch
.subckt NAND_3in VP GND a y b c
*.opin y
*.iopin GND
*.ipin a
*.iopin VP
*.ipin b
*.ipin c
XM1 y a net2 GND sg13_lv_nmos w=0.15u l=0.13u ng=1 m=1 mm_ok=1
XM3 net2 b net1 GND sg13_lv_nmos w=0.15u l=0.13u ng=1 m=1 mm_ok=1
XM4 net1 c GND GND sg13_lv_nmos w=0.15u l=0.13u ng=1 m=1 mm_ok=1
XM7 y c VP VP sg13_lv_pmos w=0.15u l=0.13u ng=1 m=1 mm_ok=1
XM2 y a VP VP sg13_lv_pmos w=0.15u l=0.13u ng=1 m=1 mm_ok=1
XM5 y b VP VP sg13_lv_pmos w=0.15u l=0.13u ng=1 m=1 mm_ok=1
.ends

* expanding   symbol:  /foss/designs/CHIP-PLL/schematics/divider/schematics/NOR_2in.sym # of pins=5
** sym_path: /foss/designs/CHIP-PLL/schematics/divider/schematics/NOR_2in.sym
** sch_path: /foss/designs/CHIP-PLL/schematics/divider/schematics/NOR_2in.sch
.subckt NOR_2in VP GND a y b
*.opin y
*.iopin GND
*.ipin a
*.iopin VP
*.ipin b
XM3 y a GND GND sg13_lv_nmos w=0.15u l=0.13u ng=1 m=1 mm_ok=1
XM2 y b net1 VP sg13_lv_pmos w=0.15u l=0.13u ng=1 m=1 mm_ok=1
XM4 net1 a VP VP sg13_lv_pmos w=0.15u l=0.13u ng=1 m=1 mm_ok=1
XM5 y b GND GND sg13_lv_nmos w=0.15u l=0.13u ng=1 m=1 mm_ok=1
.ends

* expanding   symbol:  /foss/designs/CHIP-PLL/schematics/divider/schematics/passgate_scaled.sym # of pins=6
** sym_path: /foss/designs/CHIP-PLL/schematics/divider/schematics/passgate_scaled.sym
** sch_path: /foss/designs/CHIP-PLL/schematics/divider/schematics/passgate_scaled.sch
.subckt passgate_scaled en_ VP GND en IO OI
*.iopin OI
*.iopin IO
*.iopin VP
*.iopin GND
*.ipin en_
*.ipin en
XM1 IO en OI GND sg13_lv_nmos w=0.15u l=0.13u ng=1 m=1 mm_ok=1
XM2 IO en_ OI VP sg13_lv_pmos w=0.15u l=0.13u ng=1 m=1 mm_ok=1
.ends

* expanding   symbol:  /foss/designs/CHIP-PLL/schematics/divider/schematics/div_with_reset.sym # of pins=10
** sym_path: /foss/designs/CHIP-PLL/schematics/divider/schematics/div_with_reset.sym
** sch_path: /foss/designs/CHIP-PLL/schematics/divider/schematics/div_with_reset.sch
.subckt div_with_reset gd vp in reset div2 div4 div8 div16 div32 div64
*.iopin gd
*.ipin in
*.iopin vp
*.opin div2
*.opin div4
*.opin div8
*.opin div16
*.opin div32
*.opin div64
*.ipin reset
x1 net1 vp gd div4 net2 div4 reset d_flip_flop_reset
x2 net2 vp gd div2 in div2 reset d_flip_flop_reset
x3 net6 vp gd div64 net5 div64 reset d_flip_flop_reset
x4 net5 vp gd div32 net4 div32 reset d_flip_flop_reset
x5 net4 vp gd div16 net3 div16 reset d_flip_flop_reset
x6 net3 vp gd div8 net1 div8 reset d_flip_flop_reset
* noconn #net6
.ends

* expanding   symbol:  /foss/designs/CHIP-PLL/schematics/divider/schematics/count_data_check.sym # of pins=15
** sym_path: /foss/designs/CHIP-PLL/schematics/divider/schematics/count_data_check.sym
** sch_path: /foss/designs/CHIP-PLL/schematics/divider/schematics/count_data_check.sch
.subckt count_data_check out VP GND c0 c1 c2 c3 c4 c5 d0 d1 d2 d3 d4 d5
*.iopin GND
*.ipin c0
*.iopin VP
*.ipin c1
*.opin out
*.ipin c2
*.ipin c3
*.ipin c4
*.ipin c5
*.ipin d0
*.ipin d1
*.ipin d3
*.ipin d4
*.ipin d5
*.ipin d2
x7 VP GND y0 and012 y1 y2 NAND_3in
x8 VP GND y3 and345 y4 y5 NAND_3in
x9 VP GND and012 out and345 NOR_2in
x1 VP GND d0 y0 c0 XNOR
x2 VP GND d1 y1 c1 XNOR
x3 VP GND d2 y2 c2 XNOR
x4 VP GND d3 y3 c3 XNOR
x5 VP GND d4 y4 c4 XNOR
x6 VP GND d5 y5 c5 XNOR
.ends

* expanding   symbol:  /foss/designs/CHIP-PLL/schematics/divider/schematics/d_flip_flop_reset.sym # of pins=7
** sym_path: /foss/designs/CHIP-PLL/schematics/divider/schematics/d_flip_flop_reset.sym
** sch_path: /foss/designs/CHIP-PLL/schematics/divider/schematics/d_flip_flop_reset.sch
.subckt d_flip_flop_reset q VP GND q_ clk d reset
*.iopin GND
*.ipin clk
*.iopin VP
*.ipin d
*.opin q
*.opin q_
*.ipin reset
x3 VP GND net4 net2 net1 NAND_2in
x2 VP GND q q_ net3 reset NAND_3in_x2
x5 VP GND net3 net4 d reset NAND_3in_x2
x6 VP GND net2 net1 clk reset NAND_3in_x2
x4 VP GND net1 q q_ NAND_2in_x2
x1 VP GND net1 net3 clk net4 NAND_3in
.ends

* expanding   symbol:  /foss/designs/CHIP-PLL/schematics/divider/schematics/inverter_x8.sym # of pins=4
** sym_path: /foss/designs/CHIP-PLL/schematics/divider/schematics/inverter_x8.sym
** sch_path: /foss/designs/CHIP-PLL/schematics/divider/schematics/inverter_x8.sch
.subckt inverter_x8 IN OUT VP GND
*.ipin IN
*.iopin VP
*.opin OUT
*.iopin GND
XM1 OUT IN GND GND sg13_lv_nmos w=0.60u l=0.13u ng=1 m=1 mm_ok=1
XM2 OUT IN VP VP sg13_lv_pmos w=1.20u l=0.13u ng=1 m=1 mm_ok=1
.ends

* expanding   symbol:  /foss/designs/CHIP-PLL/schematics/divider/schematics/NAND_2in.sym # of pins=5
** sym_path: /foss/designs/CHIP-PLL/schematics/divider/schematics/NAND_2in.sym
** sch_path: /foss/designs/CHIP-PLL/schematics/divider/schematics/NAND_2in.sch
.subckt NAND_2in VP GND a y b
*.opin y
*.iopin GND
*.ipin a
*.iopin VP
*.ipin b
XM1 y a net1 GND sg13_lv_nmos w=0.15u l=0.13u ng=1 m=1 mm_ok=1
XM3 net1 b GND GND sg13_lv_nmos w=0.15u l=0.13u ng=1 m=1 mm_ok=1
XM2 y b VP VP sg13_lv_pmos w=0.15u l=0.13u ng=1 m=1 mm_ok=1
XM4 y a VP VP sg13_lv_pmos w=0.15u l=0.13u ng=1 m=1 mm_ok=1
.ends

* expanding   symbol:  /foss/designs/CHIP-PLL/schematics/divider/schematics/XNOR.sym # of pins=5
** sym_path: /foss/designs/CHIP-PLL/schematics/divider/schematics/XNOR.sym
** sch_path: /foss/designs/CHIP-PLL/schematics/divider/schematics/XNOR.sch
.subckt XNOR VP GND a y b
*.opin y
*.iopin GND
*.ipin a
*.iopin VP
*.ipin b
XM1 y a net1 GND sg13_lv_nmos w=0.15u l=0.13u ng=1 m=1 mm_ok=1
XM3 net1 _b GND GND sg13_lv_nmos w=0.15u l=0.13u ng=1 m=1 mm_ok=1
XM2 net2 a VP VP sg13_lv_pmos w=0.15u l=0.13u ng=1 m=4 mm_ok=1
XM4 net3 _a VP VP sg13_lv_pmos w=0.15u l=0.13u ng=1 m=4 mm_ok=1
XM5 y _a net4 GND sg13_lv_nmos w=0.15u l=0.13u ng=1 m=1 mm_ok=1
XM6 net4 b GND GND sg13_lv_nmos w=0.15u l=0.13u ng=1 m=1 mm_ok=1
XM7 y b net2 VP sg13_lv_pmos w=0.15u l=0.13u ng=1 m=4 mm_ok=1
XM8 y _b net3 VP sg13_lv_pmos w=0.15u l=0.13u ng=1 m=4 mm_ok=1
x1 a _a VP GND inverter
x2 b _b VP GND inverter
.ends

* expanding   symbol:  /foss/designs/CHIP-PLL/schematics/divider/schematics/NAND_3in_x2.sym # of pins=6
** sym_path: /foss/designs/CHIP-PLL/schematics/divider/schematics/NAND_3in_x2.sym
** sch_path: /foss/designs/CHIP-PLL/schematics/divider/schematics/NAND_3in_x2.sch
.subckt NAND_3in_x2 VP GND a y b c
*.opin y
*.iopin GND
*.ipin a
*.iopin VP
*.ipin b
*.ipin c
XM1 y a net2 GND sg13_lv_nmos w=1.20u l=0.13u ng=1 m=1 mm_ok=1
XM5 y b VP VP sg13_lv_pmos w=0.3u l=0.13u ng=1 m=1 mm_ok=1
XM3 net2 b net1 GND sg13_lv_nmos w=1.20u l=0.13u ng=1 m=1 mm_ok=1
XM4 net1 c GND GND sg13_lv_nmos w=1.20u l=0.13u ng=1 m=1 mm_ok=1
XM2 y a VP VP sg13_lv_pmos w=0.3u l=0.13u ng=1 m=1 mm_ok=1
XM6 y c VP VP sg13_lv_pmos w=0.3u l=0.13u ng=1 m=1 mm_ok=1
.ends

* expanding   symbol:  /foss/designs/CHIP-PLL/schematics/divider/schematics/NAND_2in_x2.sym # of pins=5
** sym_path: /foss/designs/CHIP-PLL/schematics/divider/schematics/NAND_2in_x2.sym
** sch_path: /foss/designs/CHIP-PLL/schematics/divider/schematics/NAND_2in_x2.sch
.subckt NAND_2in_x2 VP GND a y b
*.opin y
*.iopin GND
*.ipin a
*.iopin VP
*.ipin b
XM1 y a net1 GND sg13_lv_nmos w=0.6u l=0.13u ng=1 m=1 mm_ok=1
XM2 y b VP VP sg13_lv_pmos w=0.3u l=0.13u ng=1 m=1 mm_ok=1
XM3 net1 b GND GND sg13_lv_nmos w=0.6u l=0.13u ng=1 m=1 mm_ok=1
XM4 y a VP VP sg13_lv_pmos w=0.3u l=0.13u ng=1 m=1 mm_ok=1
.ends

.end
