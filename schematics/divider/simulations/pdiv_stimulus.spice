Vd0 D0 0 PWL(0.000000000000e+00 1 3.125000000000e-08 1 3.125100000000e-08 0 9.375000000000e-08 0 9.375100000000e-08 1 1.875000000000e-07 1 1.875010000000e-07 0 3.125000000000e-07 0 3.125010000000e-07 1 4.687500000000e-07 1 4.687510000000e-07 0 6.562500000000e-07 0 6.562510000000e-07 1 8.750000000000e-07 1 8.750010000000e-07 0 1.125000000000e-06 0 1.125001000000e-06 1 1.406250000000e-06 1 1.406251000000e-06 0 1.718750000000e-06 0 1.718751000000e-06 1 2.062500000000e-06 1 2.062501000000e-06 0 2.437500000000e-06 0 2.437501000000e-06 1 2.843750000000e-06 1 2.843751000000e-06 0 3.281250000000e-06 0 3.281251000000e-06 1 3.750000000000e-06 1 3.750001000000e-06 0 4.250000000000e-06 0 4.250001000000e-06 1 4.781250000000e-06 1 4.781251000000e-06 0 5.343750000000e-06 0 5.343751000000e-06 1 5.937500000000e-06 1 5.937501000000e-06 0 6.562500000000e-06 0 6.562501000000e-06 1 7.218750000000e-06 1 7.218751000000e-06 0 7.906250000000e-06 0 7.906251000000e-06 1 8.625000000000e-06 1 8.625001000000e-06 0 9.375000000000e-06 0 9.375001000000e-06 1 1.015625000000e-05 1 1.015625100000e-05 0 1.096875000000e-05 0 1.096875100000e-05 1 1.181250000000e-05 1 1.181250100000e-05 0 1.268750000000e-05 0 1.268750100000e-05 1 1.359375000000e-05 1 1.359375100000e-05 0 1.453125000000e-05 0 1.453125100000e-05 1 1.550000000000e-05 1 1.550000100000e-05 0 1.650000000000e-05 0 1.650000100000e-05 1 1.753125000000e-05 1 1.753125100000e-05 0 1.859375000000e-05 0 1.859375100000e-05 1 1.968750000000e-05 1 1.968750100000e-05 0 2.081250000000e-05 0 2.081250100000e-05 1 2.196875000000e-05 1 2.196875100000e-05 0 2.315625000000e-05 0 2.315625100000e-05 1 2.437500000000e-05 1 2.437500100000e-05 0 2.562500000000e-05 0 2.562500100000e-05 1 2.690625000000e-05 1 2.690625100000e-05 0 2.821875000000e-05 0 2.821875100000e-05 1 2.956250000000e-05 1 2.956250100000e-05 0 3.093750000000e-05 0 3.093750100000e-05 1 3.234375000000e-05 1 3.234375100000e-05 0 3.378125000000e-05 0 3.378125100000e-05 1 3.525000000000e-05 1 3.525000100000e-05 0 3.675000000000e-05 0 3.675000100000e-05 1 3.828125000000e-05 1 3.828125100000e-05 0 3.984375000000e-05 0 3.984375100000e-05 1 4.143750000000e-05 1 4.143750100000e-05 0 4.306250000000e-05 0 4.306250100000e-05 1 4.471875000000e-05 1 4.471875100000e-05 0 4.640625000000e-05 0 4.640625100000e-05 1 4.812500000000e-05 1 4.812500100000e-05 0 4.987500000000e-05 0 4.987500100000e-05 1 5.165625000000e-05 1 5.165625100000e-05 0 5.346875000000e-05 0 5.346875100000e-05 1 5.531250000000e-05 1 5.531250100000e-05 0 5.718750000000e-05 0 5.718750100000e-05 1 5.909375000000e-05 1 5.909375100000e-05 0 6.103125000000e-05 0 6.103125100000e-05 1)
Vd1 D1 0 PWL(0.000000000000e+00 0 3.125000000000e-08 0 3.125100000000e-08 1 1.875000000000e-07 1 1.875010000000e-07 0 4.687500000000e-07 0 4.687510000000e-07 1 8.750000000000e-07 1 8.750010000000e-07 0 1.406250000000e-06 0 1.406251000000e-06 1 2.062500000000e-06 1 2.062501000000e-06 0 2.843750000000e-06 0 2.843751000000e-06 1 3.750000000000e-06 1 3.750001000000e-06 0 4.781250000000e-06 0 4.781251000000e-06 1 5.937500000000e-06 1 5.937501000000e-06 0 7.218750000000e-06 0 7.218751000000e-06 1 8.625000000000e-06 1 8.625001000000e-06 0 1.015625000000e-05 0 1.015625100000e-05 1 1.181250000000e-05 1 1.181250100000e-05 0 1.359375000000e-05 0 1.359375100000e-05 1 1.550000000000e-05 1 1.550000100000e-05 0 1.753125000000e-05 0 1.753125100000e-05 1 1.968750000000e-05 1 1.968750100000e-05 0 2.196875000000e-05 0 2.196875100000e-05 1 2.437500000000e-05 1 2.437500100000e-05 0 2.690625000000e-05 0 2.690625100000e-05 1 2.956250000000e-05 1 2.956250100000e-05 0 3.234375000000e-05 0 3.234375100000e-05 1 3.525000000000e-05 1 3.525000100000e-05 0 3.828125000000e-05 0 3.828125100000e-05 1 4.143750000000e-05 1 4.143750100000e-05 0 4.471875000000e-05 0 4.471875100000e-05 1 4.812500000000e-05 1 4.812500100000e-05 0 5.165625000000e-05 0 5.165625100000e-05 1 5.531250000000e-05 1 5.531250100000e-05 0 5.909375000000e-05 0 5.909375100000e-05 1 6.300000000000e-05 1 6.300000100000e-05 0)
Vd2 D2 0 PWL(0.000000000000e+00 0 1.875000000000e-07 0 1.875010000000e-07 1 8.750000000000e-07 1 8.750010000000e-07 0 2.062500000000e-06 0 2.062501000000e-06 1 3.750000000000e-06 1 3.750001000000e-06 0 5.937500000000e-06 0 5.937501000000e-06 1 8.625000000000e-06 1 8.625001000000e-06 0 1.181250000000e-05 0 1.181250100000e-05 1 1.550000000000e-05 1 1.550000100000e-05 0 1.968750000000e-05 0 1.968750100000e-05 1 2.437500000000e-05 1 2.437500100000e-05 0 2.956250000000e-05 0 2.956250100000e-05 1 3.525000000000e-05 1 3.525000100000e-05 0 4.143750000000e-05 0 4.143750100000e-05 1 4.812500000000e-05 1 4.812500100000e-05 0 5.531250000000e-05 0 5.531250100000e-05 1 6.300000000000e-05 1 6.300000100000e-05 0)
Vd3 D3 0 PWL(0.000000000000e+00 0 8.750000000000e-07 0 8.750010000000e-07 1 3.750000000000e-06 1 3.750001000000e-06 0 8.625000000000e-06 0 8.625001000000e-06 1 1.550000000000e-05 1 1.550000100000e-05 0 2.437500000000e-05 0 2.437500100000e-05 1 3.525000000000e-05 1 3.525000100000e-05 0 4.812500000000e-05 0 4.812500100000e-05 1 6.300000000000e-05 1 6.300000100000e-05 0)
Vd4 D4 0 PWL(0.000000000000e+00 0 3.750000000000e-06 0 3.750001000000e-06 1 1.550000000000e-05 1 1.550000100000e-05 0 3.525000000000e-05 0 3.525000100000e-05 1 6.300000000000e-05 1 6.300000100000e-05 0)
Vd5 D5 0 PWL(0.000000000000e+00 0 1.550000000000e-05 0 1.550000100000e-05 1 6.300000000000e-05 1 6.300000100000e-05 0)
