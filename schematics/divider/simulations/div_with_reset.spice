** sch_path: /foss/designs/CHIP-PLL/divider/schematics/div_with_reset.sch
**.subckt div_with_reset gd vp in reset div2 div4 div8 div16 div32 div64
*.iopin gd
*.ipin in
*.iopin vp
*.opin div2
*.opin div4
*.opin div8
*.opin div16
*.opin div32
*.opin div64
*.ipin reset
x7 reset r vp gd inverter_x4
x1 net2 vp gd div2 in div2 r d_flip_flop_reset
x2 net1 vp gd div4 net2 div4 r d_flip_flop_reset
x3 net3 vp gd div8 net1 div8 r d_flip_flop_reset
x4 net4 vp gd div16 net3 div16 r d_flip_flop_reset
x5 net5 vp gd div32 net4 div32 r d_flip_flop_reset
x6 net6 vp gd div64 net5 div64 r d_flip_flop_reset
**.ends

* expanding   symbol:  /foss/designs/CHIP-PLL/divider/schematics/inverter_x4.sym # of pins=4
** sym_path: /foss/designs/CHIP-PLL/divider/schematics/inverter_x4.sym
** sch_path: /foss/designs/CHIP-PLL/divider/schematics/inverter_x4.sch
.subckt inverter_x4 IN OUT VP GND
*.ipin IN
*.iopin VP
*.opin OUT
*.iopin GND
XM1 OUT IN GND GND sg13_lv_nmos w=0.60u l=0.13u ng=1
XM2 OUT IN VP VP sg13_lv_pmos w=0.60u l=0.13u ng=1
.ends

* expanding   symbol:  /foss/designs/CHIP-PLL/divider/schematics/d_flip_flop_reset.sym # of pins=7
** sym_path: /foss/designs/CHIP-PLL/divider/schematics/d_flip_flop_reset.sym
** sch_path: /foss/designs/CHIP-PLL/divider/schematics/d_flip_flop_reset.sch
.subckt d_flip_flop_reset q VP GND q_ clk d reset
*.iopin GND
*.ipin clk
*.iopin VP
*.ipin d
*.opin q
*.opin q_
*.ipin reset
x3 VP GND net4 net2 net1 NAND_2in
x2 VP GND net2 net1 clk reset NAND_3in
x4 VP GND net1 q q_ NAND_2in_x2
x5 VP GND q q_ net3 reset NAND_3in_x2
x6 VP GND net3 net4 d reset NAND_3in
x1 VP GND net1 net3 clk net4 NAND_3in
.ends

* expanding   symbol:  /foss/designs/CHIP-PLL/divider/schematics/NAND_2in.sym # of pins=5
** sym_path: /foss/designs/CHIP-PLL/divider/schematics/NAND_2in.sym
** sch_path: /foss/designs/CHIP-PLL/divider/schematics/NAND_2in.sch
.subckt NAND_2in VP GND a y b
*.opin y
*.iopin GND
*.ipin a
*.iopin VP
*.ipin b
XM1 y a net1 GND sg13_lv_nmos w=0.15u l=0.13u ng=1
XM3 net1 b GND GND sg13_lv_nmos w=0.15u l=0.13u ng=1
XM2 y b VP VP sg13_lv_pmos w=0.15u l=0.13u ng=1
XM4 y a VP VP sg13_lv_pmos w=0.15u l=0.13u ng=1
.ends

* expanding   symbol:  /foss/designs/CHIP-PLL/divider/schematics/NAND_3in.sym # of pins=6
** sym_path: /foss/designs/CHIP-PLL/divider/schematics/NAND_3in.sym
** sch_path: /foss/designs/CHIP-PLL/divider/schematics/NAND_3in.sch
.subckt NAND_3in VP GND a y b c
*.opin y
*.iopin GND
*.ipin a
*.iopin VP
*.ipin b
*.ipin c
XM1 y a net2 GND sg13_lv_nmos w=0.15u l=0.13u ng=1
XM3 net2 b net1 GND sg13_lv_nmos w=0.15u l=0.13u ng=1
XM4 net1 c GND GND sg13_lv_nmos w=0.15u l=0.13u ng=1
XM7 y c VP VP sg13_lv_pmos w=0.15u l=0.13u ng=1
XM2 y a VP VP sg13_lv_pmos w=0.15u l=0.13u ng=1
XM5 y b VP VP sg13_lv_pmos w=0.15u l=0.13u ng=1
.ends

* expanding   symbol:  /foss/designs/CHIP-PLL/divider/schematics/NAND_2in_x2.sym # of pins=5
** sym_path: /foss/designs/CHIP-PLL/divider/schematics/NAND_2in_x2.sym
** sch_path: /foss/designs/CHIP-PLL/divider/schematics/NAND_2in_x2.sch
.subckt NAND_2in_x2 VP GND a y b
*.opin y
*.iopin GND
*.ipin a
*.iopin VP
*.ipin b
XM1 y a net1 GND sg13_lv_nmos w=0.15u l=0.13u ng=1 m=2
XM3 net1 b GND GND sg13_lv_nmos w=0.15u l=0.13u ng=1 m=2
XM2 y b VP VP sg13_lv_pmos w=0.15u l=0.13u ng=1 m=2
XM4 y a VP VP sg13_lv_pmos w=0.150u l=0.13u ng=1 m=2
.ends

* expanding   symbol:  /foss/designs/CHIP-PLL/divider/schematics/NAND_3in_x2.sym # of pins=6
** sym_path: /foss/designs/CHIP-PLL/divider/schematics/NAND_3in_x2.sym
** sch_path: /foss/designs/CHIP-PLL/divider/schematics/NAND_3in_x2.sch
.subckt NAND_3in_x2 VP GND a y b c
*.opin y
*.iopin GND
*.ipin a
*.iopin VP
*.ipin b
*.ipin c
XM1 y a net2 GND sg13_lv_nmos w=0.150u l=0.13u ng=1 m=2
XM3 net2 b net1 GND sg13_lv_nmos w=0.150u l=0.13u ng=1 m=2
XM4 net1 c GND GND sg13_lv_nmos w=0.150u l=0.13u ng=1 m=2
XM7 y c VP VP sg13_lv_pmos w=0.150u l=0.13u ng=1 m=2
XM2 y a VP VP sg13_lv_pmos w=0.150u l=0.13u ng=1 m=2
XM5 y b VP VP sg13_lv_pmos w=0.150u l=0.13u ng=1 m=2
.ends

.end
