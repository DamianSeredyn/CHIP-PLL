** sch_path: /foss/designs/CHIP-PLL/schematics/divider/schematics/div_with_reset.sch
.subckt div_with_reset gd vp in reset r_div2 r_div4 r_div8 r_div16 r_div32 r_div64
*.PININFO gd:B in:I vp:B r_div2:O r_div4:O r_div8:O r_div16:O r_div32:O r_div64:O reset:I
x1 net1 vp gd r_div4 net2 r_div4 reset d_flip_flop_reset
x2 net2 vp gd r_div2 in r_div2 reset d_flip_flop_reset
x3 net6 vp gd r_div64 net5 r_div64 reset d_flip_flop_reset
x4 net5 vp gd r_div32 net4 r_div32 reset d_flip_flop_reset
x5 net4 vp gd r_div16 net3 r_div16 reset d_flip_flop_reset
x6 net3 vp gd r_div8 net1 r_div8 reset d_flip_flop_reset
* noconn #net6
.ends

* expanding   symbol:  /foss/designs/CHIP-PLL/schematics/divider/schematics/d_flip_flop_reset.sym # of pins=7
** sym_path: /foss/designs/CHIP-PLL/schematics/divider/schematics/d_flip_flop_reset.sym
** sch_path: /foss/designs/CHIP-PLL/schematics/divider/schematics/d_flip_flop_reset.sch
.subckt d_flip_flop_reset q VP GND q_ clk d reset
*.PININFO GND:B clk:I VP:B d:I q:O q_:O reset:I
x2 VP GND q q_ net3 reset NAND_3in_x3
x5 VP GND net3 net4 d reset NAND_3in_x3
x6 VP GND net2 net1 clk reset NAND_3in_x3
x4 VP GND net1 q q_ NAND_2in_x2
x3 VP GND net4 net2 net1 NAND_2in_x2
x1 VP GND net1 net3 clk net4 NAND_3in_x3
.ends

* expanding   symbol:  /foss/designs/CHIP-PLL/schematics/divider/schematics/NAND_3in_x3.sym # of pins=6
** sym_path: /foss/designs/CHIP-PLL/schematics/divider/schematics/NAND_3in_x3.sym
** sch_path: /foss/designs/CHIP-PLL/schematics/divider/schematics/NAND_3in_x3.sch
.subckt NAND_3in_x3 VP GND a y b c
*.PININFO y:O GND:B a:I VP:B b:I c:I
MM1 y a net2 GND sg13_lv_nmos w=1.20u l=0.13u ng=1
MM5 y b VP VP sg13_lv_pmos w=0.3u l=0.13u ng=1
MM3 net2 b net1 GND sg13_lv_nmos w=1.20u l=0.13u ng=1
MM4 net1 c GND GND sg13_lv_nmos w=1.20u l=0.13u ng=1
MM2 y a VP VP sg13_lv_pmos w=0.3u l=0.13u ng=1
MM6 y c VP VP sg13_lv_pmos w=0.3u l=0.13u ng=1
.ends

* expanding   symbol:  /foss/designs/CHIP-PLL/schematics/divider/schematics/NAND_2in_x2.sym # of pins=5
** sym_path: /foss/designs/CHIP-PLL/schematics/divider/schematics/NAND_2in_x2.sym
** sch_path: /foss/designs/CHIP-PLL/schematics/divider/schematics/NAND_2in_x2.sch
.subckt NAND_2in_x2 VP GND a y b
*.PININFO y:O GND:B a:I VP:B b:I
MM1 y a net1 GND sg13_lv_nmos w=0.6u l=0.13u ng=1
MM2 y b VP VP sg13_lv_pmos w=0.3u l=0.13u ng=1
MM3 net1 b GND GND sg13_lv_nmos w=0.6u l=0.13u ng=1
MM4 y a VP VP sg13_lv_pmos w=0.3u l=0.13u ng=1
.ends
