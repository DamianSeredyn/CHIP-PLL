** sch_path: /foss/designs/CHIP-PLL/schematics/PFD/PFD_cell_2.sch
**.subckt PFD_cell_2 gnd vp cRef UP DOWN cVco rst
*.iopin gnd
*.iopin vp
*.ipin cRef
*.ipin cVco
*.ipin rst
*.opin UP
*.opin DOWN
x9 rst reset_n vp gnd inverter_x4
XM4 DOWN rst gnd gnd sg13_lv_nmos w=0.45u l=0.15u ng=1 m=1 mm_ok=1
XM5 UP rst gnd gnd sg13_lv_nmos w=0.45u l=0.15u ng=1 m=1 mm_ok=1
x4 net2 DOWN vp gnd inverter_x4
x6 net1 UP vp gnd inverter_x4
x2 pre_down net2 vp gnd inverter_x4
x5 pre_up net1 vp gnd inverter_x4
x1 rst vp flip_flop_reset vp gnd reset_n PFD_passgate
x3 reset_n vp flip_flop_reset net6 gnd rst PFD_passgate
x8 gnd vp net7 net5 PFD_buffor
x7 vp gnd pre_down post_nand pre_up NAND_2in
* noconn #net3
x10 cRef flip_flop_reset vp pre_down net4 vp gnd PFD_flip_flop
* noconn #net4
x11 post_nand net5 vp gnd inverter_x4
x12 cVco flip_flop_reset vp pre_up net3 vp gnd PFD_flip_flop
C2 pre_down gnd 2f
C1 pre_up gnd 2f
C5 flip_flop_reset gnd 2f
C7 post_nand gnd 2f
x13 gnd vp net6 net7 PFD_buffor
**.ends

* expanding   symbol:  /foss/designs/CHIP-PLL/schematics/divider/schematics/inverter_x4.sym # of pins=4
** sym_path: /foss/designs/CHIP-PLL/schematics/divider/schematics/inverter_x4.sym
** sch_path: /foss/designs/CHIP-PLL/schematics/divider/schematics/inverter_x4.sch
.subckt inverter_x4 IN OUT VP GND
*.ipin IN
*.iopin VP
*.opin OUT
*.iopin GND
XM1 OUT IN GND GND sg13_lv_nmos w=0.60u l=0.13u ng=1 m=1 mm_ok=1
XM2 OUT IN VP VP sg13_lv_pmos w=0.60u l=0.13u ng=1 m=1 mm_ok=1
.ends

* expanding   symbol:  PFD_passgate.sym # of pins=6
** sym_path: /foss/designs/CHIP-PLL/schematics/PFD/PFD_passgate.sym
** sch_path: /foss/designs/CHIP-PLL/schematics/PFD/PFD_passgate.sch
.subckt PFD_passgate in_n vp A B gnd in_p
*.ipin in_n
*.ipin in_p
*.iopin vp
*.iopin gnd
*.iopin B
*.iopin A
XM4 B in_p A vp sg13_lv_pmos w=0.3u l=0.15u ng=1 m=1 mm_ok=1
XM5 B in_n A gnd sg13_lv_nmos w=0.3u l=0.15u ng=1 m=1 mm_ok=1
.ends

* expanding   symbol:  PFD_buffor.sym # of pins=4
** sym_path: /foss/designs/CHIP-PLL/schematics/PFD/PFD_buffor.sym
** sch_path: /foss/designs/CHIP-PLL/schematics/PFD/PFD_buffor.sch
.subckt PFD_buffor gnd vp out in
*.iopin gnd
*.iopin vp
*.ipin in
*.iopin out
XM1 out_stage1 in gnd gnd sg13_lv_nmos w=0.2u l=0.8u ng=1 m=1 mm_ok=1
XM4 out_stage1 in vp vp sg13_lv_pmos w=0.2u l=0.8u ng=1 m=1 mm_ok=1
XM2 out out_stage1 gnd gnd sg13_lv_nmos w=0.2u l=0.8u ng=1 m=1 mm_ok=1
XM3 out out_stage1 vp vp sg13_lv_pmos w=0.2u l=0.8u ng=1 m=1 mm_ok=1
.ends

* expanding   symbol:  /foss/designs/CHIP-PLL/schematics/divider/schematics/NAND_2in.sym # of pins=5
** sym_path: /foss/designs/CHIP-PLL/schematics/divider/schematics/NAND_2in.sym
** sch_path: /foss/designs/CHIP-PLL/schematics/divider/schematics/NAND_2in.sch
.subckt NAND_2in VP GND a y b
*.opin y
*.iopin GND
*.ipin a
*.iopin VP
*.ipin b
XM1 y a net1 GND sg13_lv_nmos w=0.15u l=0.13u ng=1 m=1 mm_ok=1
XM3 net1 b GND GND sg13_lv_nmos w=0.15u l=0.13u ng=1 m=1 mm_ok=1
XM2 y b VP VP sg13_lv_pmos w=0.15u l=0.13u ng=1 m=1 mm_ok=1
XM4 y a VP VP sg13_lv_pmos w=0.15u l=0.13u ng=1 m=1 mm_ok=1
.ends

* expanding   symbol:  PFD_flip_flop.sym # of pins=7
** sym_path: /foss/designs/CHIP-PLL/schematics/PFD/PFD_flip_flop.sym
** sch_path: /foss/designs/CHIP-PLL/schematics/PFD/PFD_flip_flop.sch
.subckt PFD_flip_flop clk rst D Q NQ vp gd
*.ipin D
*.opin Q
*.opin NQ
*.ipin clk
*.ipin rst
*.ipin gd
*.ipin vp
x8 clk vp post_NOR 1 gd clk_n PFD_passgate
x4 clk vp 2 3 gd clk_n PFD_passgate
x7 clk_n vp NQ 3 gd clk PFD_passgate
C2 3 gd 2f
C1 NQ gd 2f
C3 1 gd 2f
C4 post_NOR gd 2f
x3 vp rst 3 Q gd PFD_NOR
x5 vp rst 2 post_NOR gd PFD_NOR
x2 clk clk_n vp gd inverter_x4
x6 Q NQ vp gd inverter_x8
x9 1 2 vp gd inverter_x8
x1 clk_n vp D 1 gd clk PFD_passgate
.ends

* expanding   symbol:  PFD_NOR.sym # of pins=5
** sym_path: /foss/designs/CHIP-PLL/schematics/PFD/PFD_NOR.sym
** sch_path: /foss/designs/CHIP-PLL/schematics/PFD/PFD_NOR.sch
.subckt PFD_NOR vp A B Out gd
*.ipin vp
*.ipin gd
*.ipin B
*.ipin A
*.opin Out
XM1 Out A net1 vp sg13_lv_pmos w=0.3u l=0.15u ng=1 m=1 mm_ok=1
XM4 net1 B vp vp sg13_lv_pmos w=0.3u l=0.15u ng=1 m=1 mm_ok=1
XM2 Out A gd gd sg13_lv_nmos w=0.3u l=0.15u ng=1 m=1 mm_ok=1
XM3 Out B gd gd sg13_lv_nmos w=0.3u l=0.15u ng=1 m=1 mm_ok=1
.ends

* expanding   symbol:  /foss/designs/CHIP-PLL/schematics/divider/schematics/inverter_x8.sym # of pins=4
** sym_path: /foss/designs/CHIP-PLL/schematics/divider/schematics/inverter_x8.sym
** sch_path: /foss/designs/CHIP-PLL/schematics/divider/schematics/inverter_x8.sch
.subckt inverter_x8 IN OUT VP GND
*.ipin IN
*.iopin VP
*.opin OUT
*.iopin GND
XM1 OUT IN GND GND sg13_lv_nmos w=1.20u l=0.13u ng=1 m=1 mm_ok=1
XM2 OUT IN VP VP sg13_lv_pmos w=1.20u l=0.13u ng=1 m=1 mm_ok=1
.ends

.end
