** sch_path: /foss/designs/CHIP-PLL/schematics/PFD/PFD_flip_flop.sch
**.subckt PFD_flip_flop clk rst D Q NQ vp gd
*.ipin D
*.opin Q
*.opin NQ
*.ipin clk
*.ipin rst
*.ipin gd
*.ipin vp
x8 clk vp post_NOR 1 gd clk_n PFD_passgate
x4 clk vp 2 3 gd clk_n PFD_passgate
x7 clk_n vp NQ 3 gd clk PFD_passgate
C2 3 gd 50f
C1 NQ gd 4f
C3 1 gd 50f
C4 post_NOR gd 50f
x3 vp rst 3 Q gd PFD_NOR
x5 vp rst 2 post_NOR gd PFD_NOR
x2 clk clk_n vp gd inverter_x4
x6 Q NQ vp gd inverter_x8
x9 1 2 vp gd inverter_x8
x1 clk_n vp D 1 gd clk PFD_passgate
**.ends

* expanding   symbol:  PFD_passgate.sym # of pins=6
** sym_path: /foss/designs/CHIP-PLL/schematics/PFD/PFD_passgate.sym
** sch_path: /foss/designs/CHIP-PLL/schematics/PFD/PFD_passgate.sch
.subckt PFD_passgate in_n vp A B gnd in_p
*.ipin in_n
*.ipin in_p
*.iopin vp
*.iopin gnd
*.iopin B
*.iopin A
XM4 B in_p A vp sg13_lv_pmos w=0.3u l=0.15u ng=1 m=1 mm_ok=1
XM5 B in_n A gnd sg13_lv_nmos w=0.3u l=0.15u ng=1 m=1 mm_ok=1
.ends

* expanding   symbol:  PFD_NOR.sym # of pins=5
** sym_path: /foss/designs/CHIP-PLL/schematics/PFD/PFD_NOR.sym
** sch_path: /foss/designs/CHIP-PLL/schematics/PFD/PFD_NOR.sch
.subckt PFD_NOR vp A B Out gd
*.ipin vp
*.ipin gd
*.ipin B
*.ipin A
*.opin Out
XM1 Out A net1 vp sg13_lv_pmos w=0.3u l=0.15u ng=1 m=1 mm_ok=1
XM4 net1 B vp vp sg13_lv_pmos w=0.3u l=0.15u ng=1 m=1 mm_ok=1
XM2 Out A gd gd sg13_lv_nmos w=0.3u l=0.15u ng=1 m=1 mm_ok=1
XM3 Out B gd gd sg13_lv_nmos w=0.3u l=0.15u ng=1 m=1 mm_ok=1
.ends

* expanding   symbol:  /foss/designs/CHIP-PLL/schematics/divider/schematics/inverter_x4.sym # of pins=4
** sym_path: /foss/designs/CHIP-PLL/schematics/divider/schematics/inverter_x4.sym
** sch_path: /foss/designs/CHIP-PLL/schematics/divider/schematics/inverter_x4.sch
.subckt inverter_x4 IN OUT VP GND
*.ipin IN
*.iopin VP
*.opin OUT
*.iopin GND
XM1 OUT IN GND GND sg13_lv_nmos w=0.60u l=0.13u ng=1 m=1 mm_ok=1
XM2 OUT IN VP VP sg13_lv_pmos w=0.60u l=0.13u ng=1 m=1 mm_ok=1
.ends

* expanding   symbol:  /foss/designs/CHIP-PLL/schematics/divider/schematics/inverter_x8.sym # of pins=4
** sym_path: /foss/designs/CHIP-PLL/schematics/divider/schematics/inverter_x8.sym
** sch_path: /foss/designs/CHIP-PLL/schematics/divider/schematics/inverter_x8.sch
.subckt inverter_x8 IN OUT VP GND
*.ipin IN
*.iopin VP
*.opin OUT
*.iopin GND
XM1 OUT IN GND GND sg13_lv_nmos w=1.20u l=0.13u ng=1 m=1 mm_ok=1
XM2 OUT IN VP VP sg13_lv_pmos w=1.20u l=0.13u ng=1 m=1 mm_ok=1
.ends

.end
