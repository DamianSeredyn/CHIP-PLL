** sch_path: /foss/designs/CHIP-PLL/schematics/PFD/PFD_NOR.sch
.subckt PFD_NOR vp A B Out gd
*.PININFO vp:I gd:I B:I A:I Out:O
MM1 Out A net1 net3 sg13_lv_pmos w=0.3u l=0.15u ng=1
MM4 net1 B vp net3 sg13_lv_pmos w=0.3u l=0.15u ng=1
MM2 Out A gd net2 sg13_lv_nmos w=0.3u l=0.15u ng=1
MM3 Out B gd net2 sg13_lv_nmos w=0.3u l=0.15u ng=1
RR1 vp net3 ntap1 A=6.084e-13 P=3.12e-06
RR2 gd net2 ptap1 A=6.084e-13 P=3.12e-06
.ends
