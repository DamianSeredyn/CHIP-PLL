** sch_path: /foss/designs/CHIP-PLL/schematics/PFD/PFD_tb.sch
**.subckt PFD_tb
Vref CRef_prebuf GND dc 0 ac 0 pulse(0 {Vph} {T/2} 10n 10n {T/2} {T})
Vco CVco GND dc 0 ac 0 pulse(1u {Vp} {dly} 10n 10n {T/2} {T}
Vp vp GND dc {Vp}
C1 UP GND 1p
C2 DOWN GND 1p
x2 vp CRef_prebuf CRef GND buffer_hv
Vp1 rst GND dc 0 ac 0 PULSE({Vp} 0 63u 1p 1p 1 2
x1 GND vp CRef UP DOWN CVco rst PFD_cell_2
**** begin user architecture code

.temp=25
.param T = 31.25u
.param dly=0.5u
.param Vp=1.08
.param Vph=3.3
.control
save all
tran 0.05u 312.5u

meas tran pw_up avg v(UP) from=120u to=312.5u
meas tran pw_down avg v(DOWN) from=120u to=312.5u
plot v(pw_up) v(pw_down)
write PFD_tb.raw
.endc

 .lib cornerMOSlv.lib mos_tt
.lib cornerRES.lib res_typ
.lib cornerMOShv.lib mos_tt

**** end user architecture code
**.ends

* expanding   symbol:  /foss/designs/CHIP-PLL/schematics/misc/buffer_hv.sym # of pins=4
** sym_path: /foss/designs/CHIP-PLL/schematics/misc/buffer_hv.sym
** sch_path: /foss/designs/CHIP-PLL/schematics/misc/buffer_hv.sch
.subckt buffer_hv vph in out gd
*.ipin in
*.opin out
*.ipin vph
*.ipin gd
XM1 buf_stage_1 in vph vph sg13_hv_pmos w=1u l=0.45u ng=1 m=1 mm_ok=1
XM2 buf_stage_1 in gd gd sg13_hv_nmos w=1u l=0.45u ng=1 m=1 mm_ok=1
XM3 out buf_stage_1 vph vph sg13_hv_pmos w=1u l=0.45u ng=1 m=1 mm_ok=1
XM4 out buf_stage_1 gd gd sg13_hv_nmos w=1u l=0.45u ng=1 m=1 mm_ok=1
.ends

* expanding   symbol:  PFD_cell_2.sym # of pins=7
** sym_path: /foss/designs/CHIP-PLL/schematics/PFD/PFD_cell_2.sym
** sch_path: /foss/designs/CHIP-PLL/schematics/PFD/PFD_cell_2.sch
.subckt PFD_cell_2 gnd vp cRef UP DOWN cVco rst
*.iopin gnd
*.iopin vp
*.ipin cRef
*.ipin cVco
*.ipin rst
*.opin UP
*.opin DOWN
x7 vp gnd pre_up post_nand pre_down NAND_2in
* noconn #net1
* noconn #net4
x9 rst reset_n vp gnd inverter_x4
xflipFlopCref cRef flip_flop_reset vp pre_up net1 vp gnd PFD_flip_flop
xFlipFlopCvco cVco flip_flop_reset vp pre_down net4 vp gnd PFD_flip_flop
XM4 UP rst gnd gnd sg13_lv_nmos w=0.45u l=0.15u ng=1 m=1 mm_ok=1
XM5 DOWN rst gnd gnd sg13_lv_nmos w=0.45u l=0.15u ng=1 m=1 mm_ok=1
x4 net6 UP vp gnd inverter_x4
x6 net5 DOWN vp gnd inverter_x4
x2 pre_up net6 vp gnd inverter_x4
x5 pre_down net5 vp gnd inverter_x4
x1 rst vp vp flip_flop_reset gnd reset_n PFD_passgate
x3 reset_n vp flip_flop_reset net3 gnd rst PFD_passgate
x8 gnd vp net3 net2 PFD_buffor
x11 post_nand net2 vp gnd inverter_x4
.ends

* expanding   symbol:  /foss/designs/CHIP-PLL/schematics/divider/schematics/NAND_2in.sym # of pins=5
** sym_path: /foss/designs/CHIP-PLL/schematics/divider/schematics/NAND_2in.sym
** sch_path: /foss/designs/CHIP-PLL/schematics/divider/schematics/NAND_2in.sch
.subckt NAND_2in VP GND a y b
*.opin y
*.iopin GND
*.ipin a
*.iopin VP
*.ipin b
XM1 y a net1 GND sg13_lv_nmos w=0.15u l=0.13u ng=1 m=1 mm_ok=1
XM3 net1 b GND GND sg13_lv_nmos w=0.15u l=0.13u ng=1 m=1 mm_ok=1
XM2 y b VP VP sg13_lv_pmos w=0.15u l=0.13u ng=1 m=1 mm_ok=1
XM4 y a VP VP sg13_lv_pmos w=0.15u l=0.13u ng=1 m=1 mm_ok=1
.ends

* expanding   symbol:  /foss/designs/CHIP-PLL/schematics/divider/schematics/inverter_x4.sym # of pins=4
** sym_path: /foss/designs/CHIP-PLL/schematics/divider/schematics/inverter_x4.sym
** sch_path: /foss/designs/CHIP-PLL/schematics/divider/schematics/inverter_x4.sch
.subckt inverter_x4 IN OUT VP GND
*.ipin IN
*.iopin VP
*.opin OUT
*.iopin GND
XM1 OUT IN GND GND sg13_lv_nmos w=0.60u l=0.13u ng=1 m=1 mm_ok=1
XM2 OUT IN VP VP sg13_lv_pmos w=0.60u l=0.13u ng=1 m=1 mm_ok=1
.ends

* expanding   symbol:  PFD_flip_flop.sym # of pins=7
** sym_path: /foss/designs/CHIP-PLL/schematics/PFD/PFD_flip_flop.sym
** sch_path: /foss/designs/CHIP-PLL/schematics/PFD/PFD_flip_flop.sch
.subckt PFD_flip_flop clk rst D Q NQ vp gd
*.ipin D
*.opin Q
*.opin NQ
*.ipin clk
*.ipin rst
*.ipin gd
*.ipin vp
x8 clk vp 1 net1 gd clk_n PFD_passgate
x4 clk vp 2 3 gd clk_n PFD_passgate
x7 clk_n vp 3 NQ gd clk PFD_passgate
C2 3 gd 0.2p
C1 NQ gd 0.2p
C3 1 gd 0.2p
C4 net1 gd 0.2p
x3 vp rst 3 Q gd PFD_NOR
x5 vp rst 2 net1 gd PFD_NOR
x2 clk clk_n vp gd inverter_x4
x6 Q NQ vp gd inverter_x8
x9 1 2 vp gd inverter_x8
x1 clk_n vp D 1 gd clk PFD_passgate
.ends

* expanding   symbol:  PFD_passgate.sym # of pins=6
** sym_path: /foss/designs/CHIP-PLL/schematics/PFD/PFD_passgate.sym
** sch_path: /foss/designs/CHIP-PLL/schematics/PFD/PFD_passgate.sch
.subckt PFD_passgate in_n vp A B gnd in_p
*.ipin in_n
*.ipin in_p
*.iopin vp
*.iopin gnd
*.iopin B
*.iopin A
XM4 B in_p A net1 sg13_lv_pmos w=0.3u l=0.15u ng=1 m=1 mm_ok=1
XM5 B in_n A net2 sg13_lv_nmos w=0.3u l=0.15u ng=1 m=1 mm_ok=1
XR1 vp net1 ntap1 R=262.8473 w=0.78e-6 l=0.78e-6
XR2 gnd net2 ptap1 R=262.8473 w=0.78e-6 l=0.78e-6
.ends

* expanding   symbol:  PFD_buffor.sym # of pins=4
** sym_path: /foss/designs/CHIP-PLL/schematics/PFD/PFD_buffor.sym
** sch_path: /foss/designs/CHIP-PLL/schematics/PFD/PFD_buffor.sch
.subckt PFD_buffor gnd vp out in
*.iopin gnd
*.iopin vp
*.ipin in
*.iopin out
XM1 out_stage1 in gnd gnd sg13_lv_nmos w=0.4u l=0.5u ng=1 m=1 mm_ok=1
XM4 out_stage1 in vp vp sg13_lv_pmos w=0.4u l=0.5u ng=1 m=1 mm_ok=1
XM2 out out_stage1 gnd gnd sg13_lv_nmos w=0.4u l=0.5u ng=1 m=1 mm_ok=1
XM3 out out_stage1 vp vp sg13_lv_pmos w=0.4u l=0.5u ng=1 m=1 mm_ok=1
.ends

* expanding   symbol:  PFD_NOR.sym # of pins=5
** sym_path: /foss/designs/CHIP-PLL/schematics/PFD/PFD_NOR.sym
** sch_path: /foss/designs/CHIP-PLL/schematics/PFD/PFD_NOR.sch
.subckt PFD_NOR vp A B Out gd
*.ipin vp
*.ipin gd
*.ipin B
*.ipin A
*.opin Out
XM1 Out A net1 net3 sg13_lv_pmos w=0.3u l=0.15u ng=1 m=1 mm_ok=1
XM4 net1 B vp net3 sg13_lv_pmos w=0.3u l=0.15u ng=1 m=1 mm_ok=1
XM2 Out A gd net2 sg13_lv_nmos w=0.3u l=0.15u ng=1 m=1 mm_ok=1
XM3 Out B gd net2 sg13_lv_nmos w=0.3u l=0.15u ng=1 m=1 mm_ok=1
XR1 vp net3 ntap1 R=262.8473 w=0.78e-6 l=0.78e-6
XR2 gd net2 ptap1 R=262.8473 w=0.78e-6 l=0.78e-6
.ends

* expanding   symbol:  /foss/designs/CHIP-PLL/schematics/divider/schematics/inverter_x8.sym # of pins=4
** sym_path: /foss/designs/CHIP-PLL/schematics/divider/schematics/inverter_x8.sym
** sch_path: /foss/designs/CHIP-PLL/schematics/divider/schematics/inverter_x8.sch
.subckt inverter_x8 IN OUT VP GND
*.ipin IN
*.iopin VP
*.opin OUT
*.iopin GND
XM1 OUT IN GND GND sg13_lv_nmos w=1.20u l=0.13u ng=1 m=1 mm_ok=1
XM2 OUT IN VP VP sg13_lv_pmos w=1.20u l=0.13u ng=1 m=1 mm_ok=1
.ends

.GLOBAL GND
.end
