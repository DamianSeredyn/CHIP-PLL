** sch_path: /foss/designs/CHIP-PLL/PLL0663-main/schematic/xschem/top/chip_top.sch
**.subckt chip_top vp gd clk_in data_en data_in clk_ref rst out vout vph debug_out
*.ipin vp
*.ipin gd
*.ipin clk_in
*.ipin data_en
*.ipin data_in
*.ipin clk_ref
*.ipin rst
*.opin out
*.opin vout
*.ipin vph
*.opin debug_out
x2 vp vph gd clk_ref out net4 net6 net2 net7 net8 net9 net5 net1 net3 rst vout net19 net21 net20 net18 net17 net16 PLL_top
x1 vp gd net12 net11 net10 net1 net2 net3 net4 net5 net6 net7 net8 net9 net13 net14 net15 input_register
x3 vp data_in net10 gd buffer_hv
x4 vp data_en net11 gd buffer_hv
x5 vp clk_in net12 gd buffer_hv
x6 net15 net14 net13 gd vp debug_out net16 net17 net18 net19 net20 net21 gd gd vph Test_mux
**.ends

* expanding   symbol:  //foss/designs/CHIP-PLL/PLL0663-main/schematic/xschem/top/PLL_top.sym # of pins=22
** sym_path: //foss/designs/CHIP-PLL/PLL0663-main/schematic/xschem/top/PLL_top.sym
** sch_path: //foss/designs/CHIP-PLL/PLL0663-main/schematic/xschem/top/PLL_top.sch
.subckt PLL_top vp vph gd clk_ref out d5 d3 a1 d2 d1 d0 d4 a2 a0 rst vout cref UP DOWN cvco vco_out_buffered out_PLL_divided
*.ipin clk_ref
*.opin out
*.ipin gd
*.ipin vph
*.ipin vp
*.ipin a0
*.ipin a1
*.ipin a2
*.ipin d0
*.ipin d1
*.ipin d2
*.ipin d3
*.ipin d4
*.ipin d5
*.ipin rst
*.opin vout
*.opin UP
*.opin DOWN
*.opin cvco
*.opin vco_out_buffered
*.opin out_PLL_divided
*.opin cref
x2 vp clk_ref cref gd buffer_hv
xPFD gd vp cref UP DOWN cvco rst_lv PFD_cell_2
xBUF vph aft_LS out gd buf
xDiv gd vp vco_out_buffered d0 d1 d2 d3 d4 d5 a0 a1 a2 cvco rst_lv Divider_top
xOutFlipFlop out_PLL_divided vp gd net1 vco_out_buffered net1 d_flip_flop
xLS vph aft_LS vp pre_LS gd level_shifter
x1 out_PLL_divided net2 vp gd inverter_x2
x3 net2 pre_LS vp gd inverter_x4_top
xCP vp UP vout DOWN rst_n gd charge_pump_cell
x9 rst_lv rst_n vp gd inverter_x4
xVCO vco_out_buffered gd vp a0 a1 a2 d0 d1 d2 d3 d4 d5 vout vco_top
x4 vp rst rst_lv gd buffer_hv
XM1 gd vp gd gd sg13_lv_nmos w=240u l=5u ng=1 m=1 mm_ok=1
.ends

* expanding   symbol:  //foss/designs/CHIP-PLL/PLL0663-main/schematic/xschem/divider/input_register.sym # of pins=17
** sym_path: //foss/designs/CHIP-PLL/PLL0663-main/schematic/xschem/divider/input_register.sym
** sch_path: //foss/designs/CHIP-PLL/PLL0663-main/schematic/xschem/divider/input_register.sch
.subckt input_register VP GND clk_in data_en d d0 d1 d2 d3 d4 d5 d6 d7 d8 d9 d10 d11
*.iopin VP
*.ipin clk_in
*.iopin GND
*.ipin data_en
*.ipin d
*.opin d0
*.opin d2
*.opin d3
*.opin d4
*.opin d5
*.opin d6
*.opin d7
*.opin d1
*.opin d8
*.opin d9
*.opin d10
*.opin d11
x2 d0 VP GND net1 clk_buf d d_flip_flop
x3 d1 VP GND net2 clk_buf d0 d_flip_flop
x4 d2 VP GND net3 clk_buf d1 d_flip_flop
x5 d3 VP GND net4 clk_buf d2 d_flip_flop
x6 d4 VP GND net5 clk_buf d3 d_flip_flop
x7 d5 VP GND net6 clk_buf d4 d_flip_flop
x8 d6 VP GND net7 clk_buf d5 d_flip_flop
x9 d7 VP GND net8 clk_buf d6 d_flip_flop
x10 d8 VP GND net9 clk_buf d7 d_flip_flop
x11 _clk_un clk_buf VP GND inverter_x4
x12 d9 VP GND net10 clk_buf d8 d_flip_flop
x13 d10 VP GND net11 clk_buf d9 d_flip_flop
x14 d11 VP GND net12 clk_buf d10 d_flip_flop
* noconn #net1
* noconn #net2
* noconn #net3
* noconn #net4
* noconn #net5
* noconn #net6
* noconn #net7
* noconn #net8
* noconn #net9
* noconn #net10
* noconn #net11
* noconn #net12
x1 VP GND data_en _clk_un clk_in NAND_2in_x2
.ends

* expanding   symbol:  /foss/designs/CHIP-PLL/PLL0663-main/schematic/xschem/misc/buffer_hv.sym # of pins=4
** sym_path: /foss/designs/CHIP-PLL/PLL0663-main/schematic/xschem/misc/buffer_hv.sym
** sch_path: /foss/designs/CHIP-PLL/PLL0663-main/schematic/xschem/misc/buffer_hv.sch
.subckt buffer_hv vph in out gd
*.ipin in
*.opin out
*.ipin vph
*.ipin gd
XM1 buf_stage_1 in vph vph sg13_hv_pmos w=4u l=0.45u ng=1 m=1 mm_ok=1
XM2 buf_stage_1 in gd gd sg13_hv_nmos w=4u l=0.45u ng=1 m=1 mm_ok=1
XM3 net1 buf_stage_1 vph vph sg13_hv_pmos w=4u l=0.45u ng=1 m=1 mm_ok=1
XM4 net1 buf_stage_1 gd gd sg13_hv_nmos w=4u l=0.45u ng=1 m=1 mm_ok=1
XM5 buf_stage_2 net1 vph vph sg13_hv_pmos w=3u l=0.45u ng=1 m=1 mm_ok=1
XM6 buf_stage_2 net1 gd gd sg13_hv_nmos w=3u l=0.45u ng=1 m=1 mm_ok=1
XM7 net2 buf_stage_2 vph vph sg13_hv_pmos w=3u l=0.45u ng=1 m=1 mm_ok=1
XM8 net2 buf_stage_2 gd gd sg13_hv_nmos w=3u l=0.45u ng=1 m=1 mm_ok=1
XM9 buf_stage_3 net2 vph vph sg13_hv_pmos w=2u l=0.45u ng=1 m=1 mm_ok=1
XM10 buf_stage_3 net2 gd gd sg13_hv_nmos w=2u l=0.45u ng=1 m=1 mm_ok=1
XM11 net3 buf_stage_3 vph vph sg13_hv_pmos w=2u l=0.45u ng=1 m=1 mm_ok=1
XM12 net3 buf_stage_3 gd gd sg13_hv_nmos w=2u l=0.45u ng=1 m=1 mm_ok=1
XM13 buf_stage_4 net3 vph vph sg13_hv_pmos w=1u l=0.45u ng=1 m=1 mm_ok=1
XM14 buf_stage_4 net3 gd gd sg13_hv_nmos w=1u l=0.45u ng=1 m=1 mm_ok=1
XM15 out buf_stage_4 vph vph sg13_hv_pmos w=1u l=0.45u ng=1 m=1 mm_ok=1
XM16 out buf_stage_4 gd gd sg13_hv_nmos w=1u l=0.45u ng=1 m=1 mm_ok=1
.ends

* expanding   symbol:  //foss/designs/CHIP-PLL/PLL0663-main/schematic/xschem/misc/Test_mux.sym # of pins=15
** sym_path: //foss/designs/CHIP-PLL/PLL0663-main/schematic/xschem/misc/Test_mux.sym
** sch_path: //foss/designs/CHIP-PLL/PLL0663-main/schematic/xschem/misc/Test_mux.sch
.subckt Test_mux t0 t1 t2 ground VP debug_out in1 in2 in3 in4 in5 in6 in7 in8 VPHIGH
*.iopin ground
*.iopin VP
*.opin debug_out
*.ipin in1
*.ipin in2
*.ipin in3
*.ipin in4
*.ipin in5
*.ipin in6
*.ipin in7
*.ipin in8
*.iopin VPHIGH
*.ipin t2
*.ipin t1
*.ipin t0
x2 VP net1 debug_out ground buf_lp
x1 ground VP t0 MUX_out in1 in2 in3 in4 in5 in6 in7 t1 in8 t2 mux8to1
x3 VPHIGH net1 VP MUX_out ground debug_level_shifter
.ends

* expanding   symbol:  /foss/designs/CHIP-PLL/PLL0663-main/schematic/xschem/PFD/PFD_cell_2.sym # of pins=7
** sym_path: /foss/designs/CHIP-PLL/PLL0663-main/schematic/xschem/PFD/PFD_cell_2.sym
** sch_path: /foss/designs/CHIP-PLL/PLL0663-main/schematic/xschem/PFD/PFD_cell_2.sch
.subckt PFD_cell_2 gnd vp cRef UP DOWN cVco rst
*.iopin gnd
*.iopin vp
*.ipin cRef
*.ipin cVco
*.ipin rst
*.opin UP
*.opin DOWN
XM4 UP rst gnd gnd sg13_lv_nmos w=0.45u l=0.15u ng=1 m=1 mm_ok=1
XM5 DOWN rst gnd gnd sg13_lv_nmos w=0.45u l=0.15u ng=1 m=1 mm_ok=1
x1 rst vp flip_flop_reset vp gnd reset_n PFD_passgate
x3 reset_n vp flip_flop_reset net3 gnd rst PFD_passgate
x7 vp gnd pre_up post_nand pre_down NAND_2in
* noconn #net5
x8 gnd vp net3 net4 PFD_buffor
x11 cRef flip_flop_reset vp pre_up net5 vp gnd PFD_flip_flop
x12 cVco flip_flop_reset vp pre_down net6 vp gnd PFD_flip_flop
* noconn #net6
x2 pre_down net1 vp gnd PFD_inverter_x4
x4 net1 DOWN vp gnd PFD_inverter_x4
x5 net2 UP vp gnd PFD_inverter_x4
x6 pre_up net2 vp gnd PFD_inverter_x4
x9 rst reset_n vp gnd PFD_inverter_x4
x10 post_nand net4 vp gnd PFD_inverter_x4
.ends

* expanding   symbol:  /foss/designs/CHIP-PLL/PLL0663-main/schematic/xschem/buf/buf.sym # of pins=4
** sym_path: /foss/designs/CHIP-PLL/PLL0663-main/schematic/xschem/buf/buf.sym
** sch_path: /foss/designs/CHIP-PLL/PLL0663-main/schematic/xschem/buf/buf.sch
.subckt buf VDD INPUT OUT GND
*.ipin INPUT
*.iopin VDD
*.iopin GND
*.opin OUT
XM9 OUT net3 VDD VDD sg13_hv_pmos w=10u l=0.4u ng=1 m=12 mm_ok=1
XM6 net3 net2 VDD VDD sg13_hv_pmos w=10u l=0.4u ng=1 m=4 mm_ok=1
XM4 net2 net1 VDD VDD sg13_hv_pmos w=10u l=0.4u ng=1 m=2 mm_ok=1
XM2 net1 INPUT VDD VDD sg13_hv_pmos w=10u l=0.4u ng=1 m=1 mm_ok=1
XM1 OUT net3 GND GND sg13_hv_nmos w=10u l=0.45u ng=1 m=12 mm_ok=1
XM3 net3 net2 GND GND sg13_hv_nmos w=10u l=0.45u ng=1 m=4 mm_ok=1
XM5 net2 net1 GND GND sg13_hv_nmos w=10u l=0.45u ng=1 m=2 mm_ok=1
XM7 net1 INPUT GND GND sg13_hv_nmos w=10u l=0.45u ng=1 m=1 mm_ok=1
.ends

* expanding   symbol:  /foss/designs/CHIP-PLL/PLL0663-main/schematic/xschem/divider/Divider_top.sym # of pins=14
** sym_path: /foss/designs/CHIP-PLL/PLL0663-main/schematic/xschem/divider/Divider_top.sym
** sch_path: /foss/designs/CHIP-PLL/PLL0663-main/schematic/xschem/divider/Divider_top.sch
.subckt Divider_top gd VP clk d0 d1 d2 d3 d4 d5 a0 a1 a2 out_div rst
*.iopin gd
*.ipin clk
*.iopin VP
*.opin out_div
*.ipin d0
*.ipin d1
*.ipin d2
*.ipin d3
*.ipin d4
*.ipin d5
*.ipin a0
*.ipin a1
*.ipin a2
*.ipin rst
x1 gd VP clk div2 div4 div8 div16 div32 div64 div128 2Div
x2 gd VP a0 MUX_out clk div2 div4 div8 div16 div32 div64 a1 div128 a2 MUX_8to1
x3 gd VP MUX_out rst d0 d1 d2 d3 d4 d5 out_div pdiv
.ends

* expanding   symbol:  /foss/designs/CHIP-PLL/PLL0663-main/schematic/xschem/divider/d_flip_flop.sym # of pins=6
** sym_path: /foss/designs/CHIP-PLL/PLL0663-main/schematic/xschem/divider/d_flip_flop.sym
** sch_path: /foss/designs/CHIP-PLL/PLL0663-main/schematic/xschem/divider/d_flip_flop.sch
.subckt d_flip_flop q VP GND q_ clk d
*.iopin GND
*.ipin clk
*.iopin VP
*.ipin d
*.opin q
*.opin q_
x1 VP GND net1 net3 clk net4 NAND_3in
x2 VP GND net4 net2 net1 NAND_2in_x2
x3 VP GND net2 net1 clk NAND_2in_x2
x4 VP GND net1 q q_ NAND_2in_x2
x5 VP GND q q_ net3 NAND_2in_x2
x6 VP GND net3 net4 d NAND_2in_x2
.ends

* expanding   symbol:  /foss/designs/CHIP-PLL/PLL0663-main/schematic/xschem/misc/level_shifter.sym # of pins=5
** sym_path: /foss/designs/CHIP-PLL/PLL0663-main/schematic/xschem/misc/level_shifter.sym
** sch_path: /foss/designs/CHIP-PLL/PLL0663-main/schematic/xschem/misc/level_shifter.sch
.subckt level_shifter vph out vpl in gd
*.ipin in
*.opin out
*.ipin gd
*.ipin vph
*.ipin vpl
XM1 1_stage_out in vpl vpl sg13_lv_pmos w=2u l=0.45u ng=1 m=1 mm_ok=1
XM3 1_stage_out in net1 gd sg13_lv_nmos w=1u l=0.45u ng=1 m=1 mm_ok=1
XM4 net1 in gd gd sg13_lv_nmos w=1u l=0.45u ng=1 m=1 mm_ok=1
XM2 2_stage_out 1_stage_out vpl vpl sg13_lv_pmos w=2u l=0.45u ng=1 m=1 mm_ok=1
XM5 2_stage_out 1_stage_out net4 gd sg13_lv_nmos w=1u l=0.45u ng=1 m=1 mm_ok=1
XM6 net4 1_stage_out gd gd sg13_lv_nmos w=1u l=0.45u ng=1 m=1 mm_ok=1
XM7 net2 3_stage_out vph vph sg13_hv_pmos w=1u l=0.45u ng=1 m=1 mm_ok=1
XM8 3_stage_out 2_stage_out gd gd sg13_hv_nmos w=4u l=0.45u ng=1 m=1 mm_ok=1
XM9 4 1_stage_out net2 vph sg13_hv_pmos w=1u l=0.45u ng=1 m=1 mm_ok=1
XM10 3_stage_out 2_stage_out net3 vph sg13_hv_pmos w=2u l=0.45u ng=1 m=1 mm_ok=1
XM11 net3 4 vph vph sg13_hv_pmos w=2u l=0.45u ng=1 m=1 mm_ok=1
XM12 4 1_stage_out gd gd sg13_hv_nmos w=2u l=0.45u ng=1 m=1 mm_ok=1
XM15 out 3_stage_out vph vph sg13_hv_pmos w=2u l=0.45u ng=1 m=1 mm_ok=1
XM14 out 3_stage_out net5 gd sg13_hv_nmos w=1u l=0.45u ng=1 m=1 mm_ok=1
XM13 net5 3_stage_out gd gd sg13_hv_nmos w=1u l=0.45u ng=1 m=1 mm_ok=1
.ends

* expanding   symbol:  /foss/designs/CHIP-PLL/PLL0663-main/schematic/xschem/divider/inverter_x2.sym # of pins=4
** sym_path: /foss/designs/CHIP-PLL/PLL0663-main/schematic/xschem/divider/inverter_x2.sym
** sch_path: /foss/designs/CHIP-PLL/PLL0663-main/schematic/xschem/divider/inverter_x2.sch
.subckt inverter_x2 IN OUT VP GND
*.ipin IN
*.iopin VP
*.opin OUT
*.iopin GND
XM1 OUT IN GND GND sg13_lv_nmos w=0.30u l=0.13u ng=1 m=1 mm_ok=1
XM2 OUT IN VP VP sg13_lv_pmos w=0.30u l=0.13u ng=1 m=1 mm_ok=1
.ends

* expanding   symbol:  /foss/designs/CHIP-PLL/PLL0663-main/schematic/xschem/divider/inverter_x4_top.sym # of pins=4
** sym_path: /foss/designs/CHIP-PLL/PLL0663-main/schematic/xschem/divider/inverter_x4_top.sym
** sch_path: /foss/designs/CHIP-PLL/PLL0663-main/schematic/xschem/divider/inverter_x4_top.sch
.subckt inverter_x4_top IN OUT VP GND
*.ipin IN
*.iopin VP
*.opin OUT
*.iopin GND
XM1 OUT IN GND GND sg13_lv_nmos w=0.60u l=0.13u ng=1 m=1 mm_ok=1
XM2 OUT IN VP VP sg13_lv_pmos w=0.60u l=0.13u ng=1 m=1 mm_ok=1
.ends

* expanding   symbol:  /foss/designs/CHIP-PLL/PLL0663-main/schematic/xschem/charge_pump/charge_pump_cell.sym # of pins=6
** sym_path: /foss/designs/CHIP-PLL/PLL0663-main/schematic/xschem/charge_pump/charge_pump_cell.sym
** sch_path: /foss/designs/CHIP-PLL/PLL0663-main/schematic/xschem/charge_pump/charge_pump_cell.sch
.subckt charge_pump_cell vp UP vout DN rst gd
*.iopin UP
*.iopin DN
*.iopin gd
*.iopin vp
*.opin vout
*.iopin rst
x1 vp gd bias vbias
x2 vp net6 gd curr_source
XM20 net8 net15 vp vp sg13_lv_pmos w=1.6u l=0.6u ng=1 m=1 mm_ok=1
XM3 net15 bias net8 vp sg13_lv_pmos w=1.6u l=0.6u ng=1 m=1 mm_ok=1
XM12 net1 net6 vp vp sg13_lv_pmos w=1u l=0.6u ng=1 m=1 mm_ok=1
XM14 net1 bias net2 gd sg13_lv_nmos w=4.8u l=0.6u ng=1 m=1 mm_ok=1
XM9 net2 net1 gd gd sg13_lv_nmos w=4.8u l=0.6u ng=1 m=1 mm_ok=1
XM17 net7 net1 gd gd sg13_lv_nmos w=1.6u l=0.6u ng=1 m=1 mm_ok=1
XM6 net10 bias net7 gd sg13_lv_nmos w=1.6u l=0.6u ng=1 m=1 mm_ok=1
XM10 net5 net15 vp vp sg13_lv_pmos w=1.65u l=0.6u ng=1 m=1 mm_ok=1
XM2 net3 bias net5 vp sg13_lv_pmos w=1.6u l=0.6u ng=1 m=1 mm_ok=1
XM5 vout net9 net3 vp sg13_lv_pmos w=1u l=0.6u ng=1 m=1 mm_ok=1
XM7 net9 UP vp vp sg13_lv_pmos w=1u l=0.6u ng=1 m=1 mm_ok=1
XM4 net9 UP gd gd sg13_lv_nmos w=1u l=0.6u ng=1 m=1 mm_ok=1
XM11 vout DN net13 gd sg13_lv_nmos w=1u l=0.6u ng=1 m=1 mm_ok=1
XM13 net13 bias net4 gd sg13_lv_nmos w=1.6u l=0.6u ng=1 m=1 mm_ok=1
XM8 net4 net1 gd gd sg13_lv_nmos w=1.6u l=0.6u ng=1 m=1 mm_ok=1
XM15 vtest vtest vp vp sg13_lv_pmos w=1.8u l=1.8u ng=1 m=1 mm_ok=1
XM16 vtest vtest gd gd sg13_lv_nmos w=0.6u l=1.8u ng=1 m=1 mm_ok=1
XM18 vout rst vtest vp sg13_lv_pmos w=1.8u l=0.6u ng=1 m=1 mm_ok=1
XM1 net15 bias net10 gd sg13_lv_nmos w=1.6u l=0.6u ng=1 m=1 mm_ok=1
XM19 gd gd gd gd sg13_lv_nmos w=1.6u l=0.6u ng=1 m=1 mm_ok=1
XM21 gd gd gd gd sg13_lv_nmos w=0.6u l=1.8u ng=1 m=1 mm_ok=1
XM22 gd gd gd gd sg13_lv_nmos w=0.46u l=1.8u ng=1 m=2 mm_ok=1
XM23 gd gd gd gd sg13_lv_nmos w=1u l=0.6u ng=1 m=1 mm_ok=1
XM24 vp vp vp vp sg13_lv_pmos w=1.8u l=0.6u ng=1 m=1 mm_ok=1
XM25 gd gd gd gd sg13_lv_nmos w=1.86u l=0.6u ng=1 m=1 mm_ok=1
XM26 gd gd gd gd sg13_lv_nmos w=1.2u l=0.6u ng=1 m=1 mm_ok=1
XM27 vp vp vp vp sg13_lv_pmos w=1.375u l=0.6u ng=1 m=1 mm_ok=1
XR1 gd gd gd rppd w=1u l=0.5u m=1 b=0 mm_ok=1
.ends

* expanding   symbol:  /foss/designs/CHIP-PLL/PLL0663-main/schematic/xschem/divider/inverter_x4.sym # of pins=4
** sym_path: /foss/designs/CHIP-PLL/PLL0663-main/schematic/xschem/divider/inverter_x4.sym
** sch_path: /foss/designs/CHIP-PLL/PLL0663-main/schematic/xschem/divider/inverter_x4.sch
.subckt inverter_x4 IN OUT VP GND
*.ipin IN
*.iopin VP
*.opin OUT
*.iopin GND
XM1 OUT IN GND GND sg13_lv_nmos w=0.60u l=0.13u ng=1 m=1 mm_ok=1
XM2 OUT IN VP VP sg13_lv_pmos w=0.60u l=0.13u ng=1 m=1 mm_ok=1
.ends

* expanding   symbol:  /foss/designs/CHIP-PLL/PLL0663-main/schematic/xschem/vco/vco_top.sym # of pins=13
** sym_path: /foss/designs/CHIP-PLL/PLL0663-main/schematic/xschem/vco/vco_top.sym
** sch_path: /foss/designs/CHIP-PLL/PLL0663-main/schematic/xschem/vco/vco_top.sch
.subckt vco_top out gd VP c0 c1 c2 f0 f1 f2 f3 f4 f5 vco_in
*.iopin gd
*.iopin VP
*.ipin c1
*.ipin c2
*.ipin f0
*.ipin f1
*.ipin c0
*.ipin f2
*.ipin f3
*.ipin f4
*.ipin f5
*.opin out
*.ipin vco_in
x1 VP_vco0 gd net1 net10 vco_core_0
x2 VP_vco1 gd net2 VCO2_5_sel net6 nVCO2_11_sel nVCO2_5_sel VCO2_11_sel vco_core_1
x3 VP_vco2 gd net3 net7 VCO3_5_sel nVCO3_5_sel nVCO3_11_sel VCO3_11_sel vco_core_2
x4 VP_vco3 gd net4 net8 VCO4_5_sel nVCO4_5_sel nVCO4_11_sel VCO4_11_sel vco_core_3
x5 VP_vco4 gd net5 net9 vco_core_4
x6 VP gd vco_0_out net1 0_buf
x7 VP gd vco_1_out net2 0_buf
x8 VP gd vco_2_out net3 0_buf
x9 VP gd vco_3_out net4 0_buf
x10 VP gd vco_4_out net5 0_buf
x11 gd VP c0 c1 c2 f0 f1 f2 f3 f4 f5 vco_0_out vco_1_out vco_2_out vco_3_out vco_4_out VCO2_11_sel VCO2_5_sel VCO3_11_sel
+ VCO3_5_sel VCO4_11_sel VCO4_5_sel out VCO4_SEL VCO3_SEL VCO2_SEL VCO_SEL VCO5_SEL VCO_MUX_and_decoder
x12 VCO2_5_sel nVCO2_5_sel VP gd inverter
x13 VCO2_11_sel nVCO2_11_sel VP gd inverter
x14 VCO3_5_sel nVCO3_5_sel VP gd inverter
x15 VCO3_11_sel nVCO3_11_sel VP gd inverter
x16 VCO4_5_sel nVCO4_5_sel VP gd inverter
x17 VCO4_11_sel nVCO4_11_sel VP gd inverter
x19 VCO_SEL VCO_SEL_n VP gd inverter
x21 VCO2_SEL VCO2_SEL_n VP gd inverter
x23 VCO3_SEL VCO3_SEL_n VP gd inverter
x25 VCO4_SEL VCO4_SEL_n VP gd inverter
x27 VCO5_SEL VCO5_SEL_n VP gd inverter
XM1 net6 VCO2_SEL_n gd gd sg13_lv_nmos w=0.3u l=0.13u ng=1 m=1 mm_ok=1
XM6 VP_vco4 VCO5_SEL_n gd gd sg13_lv_nmos w=0.3u l=0.13u ng=1 m=1 mm_ok=1
XM7 VP_vco3 VCO4_SEL_n gd gd sg13_lv_nmos w=0.3u l=0.13u ng=1 m=1 mm_ok=1
XM8 VP_vco2 VCO3_SEL_n gd gd sg13_lv_nmos w=0.3u l=0.13u ng=1 m=1 mm_ok=1
XM9 VP_vco1 VCO2_SEL_n gd gd sg13_lv_nmos w=0.3u l=0.13u ng=1 m=1 mm_ok=1
XM10 VP_vco0 VCO_SEL_n gd gd sg13_lv_nmos w=0.3u l=0.13u ng=1 m=1 mm_ok=1
x28 VCO2_SEL VP vco_in net6 gd VCO2_SEL_n PFD_passgate
XM2 net7 VCO3_SEL_n gd gd sg13_lv_nmos w=0.3u l=0.13u ng=1 m=1 mm_ok=1
x26 VCO3_SEL VP vco_in net7 gd VCO3_SEL_n PFD_passgate
XM3 net8 VCO4_SEL_n gd gd sg13_lv_nmos w=0.3u l=0.13u ng=1 m=1 mm_ok=1
x29 VCO4_SEL VP vco_in net8 gd VCO4_SEL_n PFD_passgate
XM4 net9 VCO5_SEL_n gd gd sg13_lv_nmos w=0.3u l=0.13u ng=1 m=1 mm_ok=1
x30 VCO5_SEL VP vco_in net9 gd VCO5_SEL_n PFD_passgate
XM5 net10 VCO_SEL_n gd gd sg13_lv_nmos w=0.3u l=0.13u ng=1 m=1 mm_ok=1
x31 VCO_SEL VP vco_in net10 gd VCO_SEL_n PFD_passgate
x18 VCO_SEL_n VP gd VCO_SEL VP VP_vco0 vco_passgate
x20 VCO2_SEL_n VP gd VCO2_SEL VP VP_vco1 vco_passgate
x22 VCO3_SEL_n VP gd VCO3_SEL VP VP_vco2 vco_passgate
x24 VCO4_SEL_n VP gd VCO4_SEL VP VP_vco3 vco_passgate
x32 VCO5_SEL_n VP gd VCO5_SEL VP VP_vco4 vco_passgate
.ends

* expanding   symbol:  /foss/designs/CHIP-PLL/PLL0663-main/schematic/xschem/divider/NAND_2in_x2.sym # of pins=5
** sym_path: /foss/designs/CHIP-PLL/PLL0663-main/schematic/xschem/divider/NAND_2in_x2.sym
** sch_path: /foss/designs/CHIP-PLL/PLL0663-main/schematic/xschem/divider/NAND_2in_x2.sch
.subckt NAND_2in_x2 VP GND a y b
*.opin y
*.iopin GND
*.ipin a
*.iopin VP
*.ipin b
XM1 y a net1 GND sg13_lv_nmos w=0.6u l=0.13u ng=1 m=1 mm_ok=1
XM2 y b VP VP sg13_lv_pmos w=0.3u l=0.13u ng=1 m=1 mm_ok=1
XM3 net1 b GND GND sg13_lv_nmos w=0.6u l=0.13u ng=1 m=1 mm_ok=1
XM4 y a VP VP sg13_lv_pmos w=0.3u l=0.13u ng=1 m=1 mm_ok=1
.ends

* expanding   symbol:  /foss/designs/CHIP-PLL/PLL0663-main/schematic/xschem/buf/buf_lp.sym # of pins=4
** sym_path: /foss/designs/CHIP-PLL/PLL0663-main/schematic/xschem/buf/buf_lp.sym
** sch_path: /foss/designs/CHIP-PLL/PLL0663-main/schematic/xschem/buf/buf_lp.sch
.subckt buf_lp VDD INPUT OUT GND
*.ipin INPUT
*.iopin VDD
*.iopin GND
*.opin OUT
XM9 OUT net3 VDD VDD sg13_hv_pmos w=3u l=0.4u ng=1 m=4 mm_ok=1
XM6 net3 net2 VDD VDD sg13_hv_pmos w=3u l=0.4u ng=1 m=3 mm_ok=1
XM4 net2 net1 VDD VDD sg13_hv_pmos w=3u l=0.4u ng=1 m=2 mm_ok=1
XM2 net1 INPUT VDD VDD sg13_hv_pmos w=3u l=0.4u ng=1 m=1 mm_ok=1
XM1 OUT net3 GND GND sg13_hv_nmos w=2u l=0.45u ng=1 m=4 mm_ok=1
XM3 net3 net2 GND GND sg13_hv_nmos w=2u l=0.45u ng=1 m=3 mm_ok=1
XM5 net2 net1 GND GND sg13_hv_nmos w=2u l=0.45u ng=1 m=2 mm_ok=1
XM7 net1 INPUT GND GND sg13_hv_nmos w=2u l=0.45u ng=1 m=1 mm_ok=1
.ends

* expanding   symbol:  /foss/designs/CHIP-PLL/PLL0663-main/schematic/xschem/misc/mux8to1.sym # of pins=14
** sym_path: /foss/designs/CHIP-PLL/PLL0663-main/schematic/xschem/misc/mux8to1.sym
** sch_path: /foss/designs/CHIP-PLL/PLL0663-main/schematic/xschem/misc/mux8to1.sch
.subckt mux8to1 gd vp A0 out in1 in2 in3 in4 in5 in6 in7 A1 in8 A2
*.iopin gd
*.iopin vp
*.opin out
*.ipin in1
*.ipin in2
*.ipin in3
*.ipin in4
*.ipin in5
*.ipin in6
*.ipin in7
*.ipin in8
*.ipin A0
*.ipin A1
*.ipin A2
x9 A0 net1 vp gd inverter_x4
x10 A1 net2 vp gd inverter_x4
x11 A2 net3 vp gd inverter_x4
x28 out_unb out vp gd inverter_x4
x29 in4 net8 vp gd inverter_x4
x30 in8 net4 vp gd inverter_x4
x31 in7 net5 vp gd inverter_x4
x32 in6 net6 vp gd inverter_x4
x33 in5 net7 vp gd inverter_x4
x34 in1 net11 vp gd inverter_x4
x35 in2 net10 vp gd inverter_x4
x36 in3 net9 vp gd inverter_x4
x13 en1_ en1 vp gd inverter_x4
x15 en2_ en2 vp gd inverter_x4
x17 en3_ en3 vp gd inverter_x4
x19 en4_ en4 vp gd inverter_x4
x21 en5_ en5 vp gd inverter_x4
x23 en6_ en6 vp gd inverter_x4
x25 en7_ en7 vp gd inverter_x4
x27 en8_ en8 vp gd inverter_x4
x12 vp gd net3 en1_ net2 net1 NAND_3in
x14 vp gd net2 en2_ net3 A0 NAND_3in
x16 vp gd net1 en3_ net3 A1 NAND_3in
x18 vp gd net3 en4_ A1 A0 NAND_3in
x20 vp gd net1 en5_ net2 A2 NAND_3in
x22 vp gd net2 en6_ A2 A0 NAND_3in
x24 vp gd net1 en7_ A2 A1 NAND_3in
x26 vp gd A2 en8_ A1 A0 NAND_3in
x1 en8_ vp gd en8 net4 out_unb passgate
x2 en4_ vp gd en4 net8 out_unb passgate
x3 en7_ vp gd en7 net5 out_unb passgate
x4 en3_ vp gd en3 net9 out_unb passgate
x5 en6_ vp gd en6 net6 out_unb passgate
x6 en2_ vp gd en2 net10 out_unb passgate
x7 en5_ vp gd en5 net7 out_unb passgate
x8 en1_ vp gd en1 net11 out_unb passgate
.ends

* expanding   symbol:  /foss/designs/CHIP-PLL/PLL0663-main/schematic/xschem/misc/debug_level_shifter.sym # of pins=5
** sym_path: /foss/designs/CHIP-PLL/PLL0663-main/schematic/xschem/misc/debug_level_shifter.sym
** sch_path: /foss/designs/CHIP-PLL/PLL0663-main/schematic/xschem/misc/debug_level_shifter.sch
.subckt debug_level_shifter vph out vpl in gd
*.ipin in
*.opin out
*.ipin gd
*.ipin vph
*.ipin vpl
XM1 1_stage_out in vpl vpl sg13_lv_pmos w=2u l=0.45u ng=1 m=1 mm_ok=1
XM3 1_stage_out in net1 gd sg13_lv_nmos w=1u l=0.45u ng=1 m=1 mm_ok=1
XM4 net1 in gd gd sg13_lv_nmos w=1u l=0.45u ng=1 m=1 mm_ok=1
XM2 2_stage_out 1_stage_out vpl vpl sg13_lv_pmos w=2u l=0.45u ng=1 m=1 mm_ok=1
XM5 2_stage_out 1_stage_out net4 gd sg13_lv_nmos w=1u l=0.45u ng=1 m=1 mm_ok=1
XM6 net4 1_stage_out gd gd sg13_lv_nmos w=1u l=0.45u ng=1 m=1 mm_ok=1
XM7 net2 3_stage_out vph vph sg13_hv_pmos w=1u l=0.45u ng=1 m=1 mm_ok=1
XM8 3_stage_out 2_stage_out gd gd sg13_hv_nmos w=4u l=0.45u ng=1 m=1 mm_ok=1
XM9 4 1_stage_out net2 vph sg13_hv_pmos w=1u l=0.45u ng=1 m=1 mm_ok=1
XM10 3_stage_out 2_stage_out net3 vph sg13_hv_pmos w=2u l=0.45u ng=1 m=1 mm_ok=1
XM11 net3 4 vph vph sg13_hv_pmos w=2u l=0.45u ng=1 m=1 mm_ok=1
XM12 4 1_stage_out gd gd sg13_hv_nmos w=2u l=0.45u ng=1 m=1 mm_ok=1
XM15 out 3_stage_out vph vph sg13_hv_pmos w=2u l=0.45u ng=1 m=1 mm_ok=1
XM14 out 3_stage_out net5 gd sg13_hv_nmos w=1u l=0.45u ng=1 m=1 mm_ok=1
XM13 net5 3_stage_out gd gd sg13_hv_nmos w=1u l=0.45u ng=1 m=1 mm_ok=1
.ends

* expanding   symbol:  /foss/designs/CHIP-PLL/PLL0663-main/schematic/xschem/PFD/PFD_passgate.sym # of pins=6
** sym_path: /foss/designs/CHIP-PLL/PLL0663-main/schematic/xschem/PFD/PFD_passgate.sym
** sch_path: /foss/designs/CHIP-PLL/PLL0663-main/schematic/xschem/PFD/PFD_passgate.sch
.subckt PFD_passgate in_n vp A B gnd in_p
*.ipin in_n
*.ipin in_p
*.iopin vp
*.iopin gnd
*.iopin B
*.iopin A
XM4 B in_p A vp sg13_lv_pmos w=0.3u l=0.15u ng=1 m=1 mm_ok=1
XM5 B in_n A gnd sg13_lv_nmos w=0.3u l=0.15u ng=1 m=1 mm_ok=1
.ends

* expanding   symbol:  /foss/designs/CHIP-PLL/PLL0663-main/schematic/xschem/divider/NAND_2in.sym # of pins=5
** sym_path: /foss/designs/CHIP-PLL/PLL0663-main/schematic/xschem/divider/NAND_2in.sym
** sch_path: /foss/designs/CHIP-PLL/PLL0663-main/schematic/xschem/divider/NAND_2in.sch
.subckt NAND_2in VP GND a y b
*.opin y
*.iopin GND
*.ipin a
*.iopin VP
*.ipin b
XM1 y a net1 GND sg13_lv_nmos w=0.15u l=0.13u ng=1 m=1 mm_ok=1
XM3 net1 b GND GND sg13_lv_nmos w=0.15u l=0.13u ng=1 m=1 mm_ok=1
XM2 y b VP VP sg13_lv_pmos w=0.15u l=0.13u ng=1 m=1 mm_ok=1
XM4 y a VP VP sg13_lv_pmos w=0.15u l=0.13u ng=1 m=1 mm_ok=1
.ends

* expanding   symbol:  /foss/designs/CHIP-PLL/PLL0663-main/schematic/xschem/PFD/PFD_buffor.sym # of pins=4
** sym_path: /foss/designs/CHIP-PLL/PLL0663-main/schematic/xschem/PFD/PFD_buffor.sym
** sch_path: /foss/designs/CHIP-PLL/PLL0663-main/schematic/xschem/PFD/PFD_buffor.sch
.subckt PFD_buffor gnd vp out in
*.iopin gnd
*.iopin vp
*.ipin in
*.iopin out
XM1 out_stage1 in gnd gnd sg13_lv_nmos w=0.4u l=0.75u ng=1 m=1 mm_ok=1
XM4 out_stage1 in vp vp sg13_lv_pmos w=0.4u l=0.75u ng=1 m=1 mm_ok=1
XM2 out out_stage1 gnd gnd sg13_lv_nmos w=0.4u l=0.75u ng=1 m=1 mm_ok=1
XM3 out out_stage1 vp vp sg13_lv_pmos w=0.4u l=0.75u ng=1 m=1 mm_ok=1
.ends

* expanding   symbol:  /foss/designs/CHIP-PLL/PLL0663-main/schematic/xschem/PFD/PFD_flip_flop.sym # of pins=7
** sym_path: /foss/designs/CHIP-PLL/PLL0663-main/schematic/xschem/PFD/PFD_flip_flop.sym
** sch_path: /foss/designs/CHIP-PLL/PLL0663-main/schematic/xschem/PFD/PFD_flip_flop.sch
.subckt PFD_flip_flop clk rst D Q NQ vp gd
*.ipin D
*.opin Q
*.opin NQ
*.ipin clk
*.ipin rst
*.ipin gd
*.ipin vp
x8 clk vp post_NOR 1 gd clk_n PFD_passgate
x4 clk vp 2 3 gd clk_n PFD_passgate
x7 clk_n vp NQ 3 gd clk PFD_passgate
x3 vp rst 3 Q gd PFD_NOR
x5 vp rst 2 post_NOR gd PFD_NOR
x1 clk_n vp D 1 gd clk PFD_passgate
XM1 gd 1 gd gd sg13_lv_nmos w=10u l=5u ng=1 m=1 mm_ok=1
XM2 gd 3 gd gd sg13_lv_nmos w=10u l=5u ng=1 m=1 mm_ok=1
XM3 gd 2 gd gd sg13_lv_nmos w=10u l=5u ng=1 m=1 mm_ok=1
x9 1 2 vp gd PFD_inverter_x8
x6 Q NQ vp gd PFD_inverter_x8
x2 clk clk_n vp gd PFD_inverter_x4
.ends

* expanding   symbol:  /foss/designs/CHIP-PLL/PLL0663-main/schematic/xschem/PFD/PFD_inverter_x4.sym # of pins=4
** sym_path: /foss/designs/CHIP-PLL/PLL0663-main/schematic/xschem/PFD/PFD_inverter_x4.sym
** sch_path: /foss/designs/CHIP-PLL/PLL0663-main/schematic/xschem/PFD/PFD_inverter_x4.sch
.subckt PFD_inverter_x4 IN OUT VP GND
*.ipin IN
*.iopin VP
*.opin OUT
*.iopin GND
XM1 OUT IN GND GND sg13_lv_nmos w=0.60u l=0.13u ng=1 m=1 mm_ok=1
XM2 OUT IN VP VP sg13_lv_pmos w=0.60u l=0.13u ng=1 m=1 mm_ok=1
.ends

* expanding   symbol:  /foss/designs/CHIP-PLL/PLL0663-main/schematic/xschem/divider/2Div.sym # of pins=10
** sym_path: /foss/designs/CHIP-PLL/PLL0663-main/schematic/xschem/divider/2Div.sym
** sch_path: /foss/designs/CHIP-PLL/PLL0663-main/schematic/xschem/divider/2Div.sch
.subckt 2Div gd vp in div2 div4 div8 div16 div32 div64 div128
*.iopin gd
*.ipin in
*.iopin vp
*.opin div2
*.opin div4
*.opin div8
*.opin div16
*.opin div32
*.opin div64
*.opin div128
x3 div32 vp gd net5 div16 net5 d_flip_flop
x4 div64 vp gd net6 div32 net6 d_flip_flop
x7 div128 vp gd net7 div64 net7 d_flip_flop
x1 div2 vp gd net1 in net1 d_flip_flop
x2 div4 vp gd net2 div2 net2 d_flip_flop
x5 div8 vp gd net3 div4 net3 d_flip_flop
x6 div16 vp gd net4 div8 net4 d_flip_flop
.ends

* expanding   symbol:  /foss/designs/CHIP-PLL/PLL0663-main/schematic/xschem/divider/MUX_8to1.sym # of pins=14
** sym_path: /foss/designs/CHIP-PLL/PLL0663-main/schematic/xschem/divider/MUX_8to1.sym
** sch_path: /foss/designs/CHIP-PLL/PLL0663-main/schematic/xschem/divider/MUX_8to1.sch
.subckt MUX_8to1 gd vp A0 out in1 in2 in3 in4 in5 in6 in7 A1 in8 A2
*.iopin gd
*.iopin vp
*.opin out
*.ipin in1
*.ipin in2
*.ipin in3
*.ipin in4
*.ipin in5
*.ipin in6
*.ipin in7
*.ipin in8
*.ipin A0
*.ipin A1
*.ipin A2
x9 A0 net1 vp gd inverter_x4
x10 A1 net2 vp gd inverter_x4
x11 A2 net3 vp gd inverter_x4
x28 out_unb out vp gd inverter_x4
x29 in4 net8 vp gd inverter_x4
x30 in8 net4 vp gd inverter_x4
x31 in7 net5 vp gd inverter_x4
x32 in6 net6 vp gd inverter_x4
x33 in5 net7 vp gd inverter_x4
x34 in1 net11 vp gd inverter_x4
x35 in2 net10 vp gd inverter_x4
x36 in3 net9 vp gd inverter_x4
x13 en1_ en1 vp gd inverter_x4
x15 en2_ en2 vp gd inverter_x4
x17 en3_ en3 vp gd inverter_x4
x19 en4_ en4 vp gd inverter_x4
x21 en5_ en5 vp gd inverter_x4
x23 en6_ en6 vp gd inverter_x4
x25 en7_ en7 vp gd inverter_x4
x27 en8_ en8 vp gd inverter_x4
x12 vp gd net3 en1_ net2 net1 NAND_3in
x14 vp gd net2 en2_ net3 A0 NAND_3in
x16 vp gd net1 en3_ net3 A1 NAND_3in
x18 vp gd net3 en4_ A1 A0 NAND_3in
x20 vp gd net1 en5_ net2 A2 NAND_3in
x22 vp gd net2 en6_ A2 A0 NAND_3in
x24 vp gd net1 en7_ A2 A1 NAND_3in
x26 vp gd A2 en8_ A1 A0 NAND_3in
x1 en8_ vp gd en8 net4 out_unb passgate
x2 en4_ vp gd en4 net8 out_unb passgate
x3 en7_ vp gd en7 net5 out_unb passgate
x4 en3_ vp gd en3 net9 out_unb passgate
x5 en6_ vp gd en6 net6 out_unb passgate
x6 en2_ vp gd en2 net10 out_unb passgate
x7 en5_ vp gd en5 net7 out_unb passgate
x8 en1_ vp gd en1 net11 out_unb passgate
.ends

* expanding   symbol:  /foss/designs/CHIP-PLL/PLL0663-main/schematic/xschem/divider/pdiv.sym # of pins=11
** sym_path: /foss/designs/CHIP-PLL/PLL0663-main/schematic/xschem/divider/pdiv.sym
** sch_path: /foss/designs/CHIP-PLL/PLL0663-main/schematic/xschem/divider/pdiv.sch
.subckt pdiv gd VP clk reset d0 d1 d2 d3 d4 d5 out_div
*.iopin gd
*.ipin clk
*.iopin VP
*.ipin d0
*.ipin d1
*.ipin d2
*.ipin d3
*.ipin d4
*.ipin d5
*.opin out_div
*.ipin reset
x4 VP gd d0 d012 d1 d2 NAND_3in
x7 VP gd d3 d345 d4 d5 NAND_3in
x5 VP gd d012 bypass d345 NOR_2in
x1 gd VP clk out r_div2 r_div4 r_div8 r_div16 r_div32 r_div64 div_with_reset
x2 out_pre_buff VP gd r_div2 r_div4 r_div8 r_div16 r_div32 r_div64 d0 d1 d2 d3 d4 d5 count_data_check
x11 out_div VP gd net2 net1 net2 net4 d_flip_flop_reset
x13 out_pre_buff out VP gd inverter_x8
x3 net3 VP gd bypass clk net1 passgate
x8 bypass VP gd net3 out net1 passgate
x6 bypass net3 VP gd inverter_x4
x9 reset net4 VP gd inverter_x4
.ends

* expanding   symbol:  /foss/designs/CHIP-PLL/PLL0663-main/schematic/xschem/divider/NAND_3in.sym # of pins=6
** sym_path: /foss/designs/CHIP-PLL/PLL0663-main/schematic/xschem/divider/NAND_3in.sym
** sch_path: /foss/designs/CHIP-PLL/PLL0663-main/schematic/xschem/divider/NAND_3in.sch
.subckt NAND_3in VP GND a y b c
*.opin y
*.iopin GND
*.ipin a
*.iopin VP
*.ipin b
*.ipin c
XM1 y a net2 GND sg13_lv_nmos w=0.3u l=0.13u ng=1 m=1 mm_ok=1
XM3 net2 b net1 GND sg13_lv_nmos w=0.3u l=0.13u ng=1 m=1 mm_ok=1
XM4 net1 c GND GND sg13_lv_nmos w=0.3u l=0.13u ng=1 m=1 mm_ok=1
XM7 y c VP VP sg13_lv_pmos w=0.15u l=0.13u ng=1 m=1 mm_ok=1
XM2 y a VP VP sg13_lv_pmos w=0.15u l=0.13u ng=1 m=1 mm_ok=1
XM5 y b VP VP sg13_lv_pmos w=0.15u l=0.13u ng=1 m=1 mm_ok=1
.ends

* expanding   symbol:  /foss/designs/CHIP-PLL/PLL0663-main/schematic/xschem/charge_pump/vbias.sym # of pins=3
** sym_path: /foss/designs/CHIP-PLL/PLL0663-main/schematic/xschem/charge_pump/vbias.sym
** sch_path: /foss/designs/CHIP-PLL/PLL0663-main/schematic/xschem/charge_pump/vbias.sch
.subckt vbias vp gd vbias
*.opin vbias
*.iopin gd
*.iopin vp
XM5 net1 iref vp vp sg13_lv_pmos w=1.2u l=0.6u ng=1 m=1 mm_ok=1
XM6 vbias net1 net2 gd sg13_lv_nmos w=3.6u l=0.6u ng=1 m=1 mm_ok=1
XM2 net2 net2 gd gd sg13_lv_nmos w=1.2u l=0.6u ng=1 m=1 mm_ok=1
XM3 gd gd gd gd sg13_lv_nmos w=1.86u l=0.6u ng=1 m=1 mm_ok=1
XM7 vp vp vp vp sg13_lv_pmos w=1.375u l=0.6u ng=1 m=1 mm_ok=1
XR1 net1 vbias gd rppd w=1e-6 l=1.7e-6 m=1 b=0 mm_ok=1
x1 vp iref gd curr_source
.ends

* expanding   symbol:  /foss/designs/CHIP-PLL/PLL0663-main/schematic/xschem/charge_pump//curr_source.sym # of pins=3
** sym_path: /foss/designs/CHIP-PLL/PLL0663-main/schematic/xschem/charge_pump//curr_source.sym
** sch_path: /foss/designs/CHIP-PLL/PLL0663-main/schematic/xschem/charge_pump//curr_source.sch
.subckt curr_source vp iref gd
*.iopin vp
*.iopin gd
*.opin iref
XM9 net3 net3 gd gd sg13_lv_nmos w=1u l=0.6u ng=1 m=1 mm_ok=1
XM4 iref iref vp vp sg13_lv_pmos w=1.4u l=0.6u ng=1 m=1 mm_ok=1
XM5 net2 iref vp vp sg13_lv_pmos w=1.2u l=0.6u ng=1 m=1 mm_ok=1
XM10 iref net2 net1 gd sg13_lv_nmos w=1.2u l=0.6u ng=1 m=1 mm_ok=1
XM1 net2 net2 gd gd sg13_lv_nmos w=1.4u l=0.6u ng=1 m=1 mm_ok=1
XM3 vp vp net3 gd sg13_lv_nmos w=1u l=0.6u ng=1 m=1 mm_ok=1
XM6 vp net3 iref gd sg13_lv_nmos w=1u l=0.6u ng=1 m=1 mm_ok=1
XM2 gd gd gd gd sg13_lv_nmos w=0.4u l=0.6u ng=1 m=1 mm_ok=1
XR2 net1 gd gd rppd w=1e-6 l=1.7e-6 m=1 b=0 mm_ok=1
.ends

* expanding   symbol:  /foss/designs/CHIP-PLL/PLL0663-main/schematic/xschem/vco/vco_core_0.sym # of pins=4
** sym_path: /foss/designs/CHIP-PLL/PLL0663-main/schematic/xschem/vco/vco_core_0.sym
** sch_path: /foss/designs/CHIP-PLL/PLL0663-main/schematic/xschem/vco/vco_core_0.sch
.subckt vco_core_0 vp gnd out in
*.ipin in
*.iopin vp
*.opin out
*.iopin gnd
XM1 pgt in gnd gnd sg13_lv_nmos w=0.8u l=0.14*4u ng=1 m=1 mm_ok=1
XM2 pgt pgt vp vp sg13_lv_pmos w=1.2u l=0.14*4u ng=1 m=1 mm_ok=1
x1 vp pgt out net1 in gnd vco_delay_cell_0
x2 vp pgt net1 2th in gnd vco_delay_cell_0
x3 vp pgt 2th 3th in gnd vco_delay_cell_0
x4 vp pgt 3th 4th in gnd vco_delay_cell_0
x7 vp pgt 4th out in gnd vco_delay_cell_0
.ends

* expanding   symbol:  /foss/designs/CHIP-PLL/PLL0663-main/schematic/xschem/vco/vco_core_1.sym # of pins=8
** sym_path: /foss/designs/CHIP-PLL/PLL0663-main/schematic/xschem/vco/vco_core_1.sym
** sch_path: /foss/designs/CHIP-PLL/PLL0663-main/schematic/xschem/vco/vco_core_1.sch
.subckt vco_core_1 vp gnd out en5 in nen11 nen5 en11
*.ipin in
*.iopin vp
*.opin out
*.iopin gnd
*.ipin en5
*.ipin en11
*.ipin nen11
*.ipin nen5
XM1 pgt in gnd gnd sg13_lv_nmos w=0.8u l=0.35*4u ng=1 m=1 mm_ok=1
XM2 pgt pgt vp vp sg13_lv_pmos w=1.2u l=0.35*4u ng=1 m=1 mm_ok=1
x1 vp pgt out 1th in gnd vco_delay_cell_1
x2 vp pgt 1th 2th in gnd vco_delay_cell_1
x3 vp pgt 2th 3th in gnd vco_delay_cell_1
x4 vp pgt 3th 4th in gnd vco_delay_cell_1
x7 vp pgt 5th out in gnd vco_delay_cell_1
x8 vp pgt 11_1st 6th in gnd vco_delay_cell_1
x9 vp pgt 6th 7th in gnd vco_delay_cell_1
x10 vp pgt 7th 8th in gnd vco_delay_cell_1
x11 vp pgt 8th 9th in gnd vco_delay_cell_1
x12 vp pgt 9th 10th in gnd vco_delay_cell_1
x13 vp pgt 10th 11_lst in gnd vco_delay_cell_1
XM4 11_1st nen11 4th vp sg13_lv_pmos w=0.3u l=0.15u ng=1 m=1 mm_ok=1
XM5 11_1st en11 4th gnd sg13_lv_nmos w=0.3u l=0.15u ng=1 m=1 mm_ok=1
XM3 5th nen11 11_lst vp sg13_lv_pmos w=0.3u l=0.15u ng=1 m=1 mm_ok=1
XM6 5th en11 11_lst gnd sg13_lv_nmos w=0.3u l=0.15u ng=1 m=1 mm_ok=1
XM7 5th nen5 4th vp sg13_lv_pmos w=0.3u l=0.15u ng=1 m=1 mm_ok=1
XM8 5th en5 4th gnd sg13_lv_nmos w=0.3u l=0.15u ng=1 m=1 mm_ok=1
.ends

* expanding   symbol:  /foss/designs/CHIP-PLL/PLL0663-main/schematic/xschem/vco/vco_core_2.sym # of pins=8
** sym_path: /foss/designs/CHIP-PLL/PLL0663-main/schematic/xschem/vco/vco_core_2.sym
** sch_path: /foss/designs/CHIP-PLL/PLL0663-main/schematic/xschem/vco/vco_core_2.sch
.subckt vco_core_2 vp gnd out in en5 nen5 nen11 en11
*.ipin in
*.iopin vp
*.opin out
*.iopin gnd
*.ipin en5
*.ipin en11
*.ipin nen11
*.ipin nen5
XM1 pgt in gnd gnd sg13_lv_nmos w=0.8u l=1.4*4u ng=1 m=1 mm_ok=1
XM2 pgt pgt vp vp sg13_lv_pmos w=1.2u l=1.4*4u ng=1 m=1 mm_ok=1
x1 vp pgt out 1th in gnd vco_delay_cell_2
x2 vp pgt 1th 2th in gnd vco_delay_cell_2
x3 vp pgt 2th 3th in gnd vco_delay_cell_2
x4 vp pgt 3th 4th in gnd vco_delay_cell_2
x7 vp pgt 5th out in gnd vco_delay_cell_2
x8 vp pgt 11_1st 6th in gnd vco_delay_cell_2
x9 vp pgt 6th 7th in gnd vco_delay_cell_2
x10 vp pgt 7th 8th in gnd vco_delay_cell_2
x11 vp pgt 8th 9th in gnd vco_delay_cell_2
x12 vp pgt 9th 10th in gnd vco_delay_cell_2
x13 vp pgt 10th 11_lst in gnd vco_delay_cell_2
XM4 11_1st nen11 4th vp sg13_lv_pmos w=0.3u l=0.15u ng=1 m=1 mm_ok=1
XM5 11_1st en11 4th gnd sg13_lv_nmos w=0.3u l=0.15u ng=1 m=1 mm_ok=1
XM3 5th nen11 11_lst vp sg13_lv_pmos w=0.3u l=0.15u ng=1 m=1 mm_ok=1
XM6 5th en11 11_lst gnd sg13_lv_nmos w=0.3u l=0.15u ng=1 m=1 mm_ok=1
XM7 5th nen5 4th vp sg13_lv_pmos w=0.3u l=0.15u ng=1 m=1 mm_ok=1
XM8 5th en5 4th gnd sg13_lv_nmos w=0.3u l=0.15u ng=1 m=1 mm_ok=1
.ends

* expanding   symbol:  /foss/designs/CHIP-PLL/PLL0663-main/schematic/xschem/vco/vco_core_3.sym # of pins=8
** sym_path: /foss/designs/CHIP-PLL/PLL0663-main/schematic/xschem/vco/vco_core_3.sym
** sch_path: /foss/designs/CHIP-PLL/PLL0663-main/schematic/xschem/vco/vco_core_3.sch
.subckt vco_core_3 vp gnd out in en5 nen5 nen11 en11
*.ipin in
*.iopin vp
*.opin out
*.iopin gnd
*.ipin en5
*.ipin en11
*.ipin nen11
*.ipin nen5
XM1 pgt in gnd gnd sg13_lv_nmos w=0.8u l=4.25*4u ng=1 m=1 mm_ok=1
XM2 pgt pgt vp vp sg13_lv_pmos w=1.2u l=4.25*4u ng=1 m=1 mm_ok=1
x1 vp pgt out 1th in gnd vco_delay_cell_3
x2 vp pgt 1th 2th in gnd vco_delay_cell_3
x3 vp pgt 2th 3th in gnd vco_delay_cell_3
x4 vp pgt 3th 4th in gnd vco_delay_cell_3
x7 vp pgt 5th out in gnd vco_delay_cell_3
x8 vp pgt 11_1st 6th in gnd vco_delay_cell_3
x9 vp pgt 6th 7th in gnd vco_delay_cell_3
x10 vp pgt 7th 8th in gnd vco_delay_cell_3
x11 vp pgt 8th 9th in gnd vco_delay_cell_3
x12 vp pgt 9th 10th in gnd vco_delay_cell_3
x13 vp pgt 10th 11_lst in gnd vco_delay_cell_3
XM4 11_1st nen11 4th vp sg13_lv_pmos w=0.3u l=0.15u ng=1 m=1 mm_ok=1
XM5 11_1st en11 4th gnd sg13_lv_nmos w=0.3u l=0.15u ng=1 m=1 mm_ok=1
XM3 5th nen11 11_lst vp sg13_lv_pmos w=0.3u l=0.15u ng=1 m=1 mm_ok=1
XM6 5th en11 11_lst gnd sg13_lv_nmos w=0.3u l=0.15u ng=1 m=1 mm_ok=1
XM7 5th nen5 4th vp sg13_lv_pmos w=0.3u l=0.15u ng=1 m=1 mm_ok=1
XM8 5th en5 4th gnd sg13_lv_nmos w=0.3u l=0.15u ng=1 m=1 mm_ok=1
.ends

* expanding   symbol:  /foss/designs/CHIP-PLL/PLL0663-main/schematic/xschem/vco/vco_core_4.sym # of pins=4
** sym_path: /foss/designs/CHIP-PLL/PLL0663-main/schematic/xschem/vco/vco_core_4.sym
** sch_path: /foss/designs/CHIP-PLL/PLL0663-main/schematic/xschem/vco/vco_core_4.sch
.subckt vco_core_4 vp gnd out in
*.ipin in
*.iopin vp
*.opin out
*.iopin gnd
XM1 pgt in gnd gnd sg13_lv_nmos w=0.8u l=5.9*4u ng=1 m=1 mm_ok=1
XM2 pgt pgt vp vp sg13_lv_pmos w=1.2u l=5.9*4u ng=1 m=1 mm_ok=1
x1 vp pgt out 1th in gnd vco_delay_cell_4
x2 vp pgt 1th 2th in gnd vco_delay_cell_4
x3 vp pgt 2th 3th in gnd vco_delay_cell_4
x4 vp pgt 3th 4th in gnd vco_delay_cell_4
x7 vp pgt 10th out in gnd vco_delay_cell_4
x8 vp pgt 4th 5th in gnd vco_delay_cell_4
x9 vp pgt 5th 6th in gnd vco_delay_cell_4
x10 vp pgt 6th 7th in gnd vco_delay_cell_4
x11 vp pgt 7th 8th in gnd vco_delay_cell_4
x12 vp pgt 8th 9th in gnd vco_delay_cell_4
x13 vp pgt 9th 10th in gnd vco_delay_cell_4
.ends

* expanding   symbol:  /foss/designs/CHIP-PLL/PLL0663-main/schematic/xschem/vco/0_buf.sym # of pins=4
** sym_path: /foss/designs/CHIP-PLL/PLL0663-main/schematic/xschem/vco/0_buf.sym
** sch_path: /foss/designs/CHIP-PLL/PLL0663-main/schematic/xschem/vco/0_buf.sch
.subckt 0_buf vp gnd out in
*.ipin in
*.opin out
*.iopin vp
*.iopin gnd
XM9 3th 2th vp vp sg13_lv_pmos w=2.5u l=0.13u ng=1 m=1 mm_ok=1
XM10 3th 2th gnd gnd sg13_lv_nmos w=2.5u l=0.13u ng=1 m=1 mm_ok=1
XM11 2th 1th vp vp sg13_lv_pmos w=2.4u l=0.13u ng=1 m=1 mm_ok=1
XM12 2th 1th gnd gnd sg13_lv_nmos w=1.2u l=0.13u ng=1 m=1 mm_ok=1
XM1 4th 3th vp vp sg13_lv_pmos w=5u l=0.13u ng=1 m=1 mm_ok=1
XM2 4th 3th gnd gnd sg13_lv_nmos w=5u l=0.13u ng=1 m=1 mm_ok=1
XM3 5th 4th vp vp sg13_lv_pmos w=10u l=0.13u ng=1 m=1 mm_ok=1
XM4 5th 4th gnd gnd sg13_lv_nmos w=10u l=0.13u ng=1 m=1 mm_ok=1
XM5 out 5th vp vp sg13_lv_pmos w=10u l=0.13u ng=1 m=2 mm_ok=1
XM6 out 5th gnd gnd sg13_lv_nmos w=10u l=0.13u ng=1 m=2 mm_ok=1
XM7 1th in gnd gnd sg13_lv_nmos w=0.8u l=0.13u ng=1 m=1 mm_ok=1
XM8 1th in vp vp sg13_lv_pmos w=1.5u l=0.13u ng=1 m=1 mm_ok=1
.ends

* expanding   symbol:  /foss/designs/CHIP-PLL/PLL0663-main/schematic/xschem/divider/VCO_MUX_and_decoder.sym # of pins=28
** sym_path: /foss/designs/CHIP-PLL/PLL0663-main/schematic/xschem/divider/VCO_MUX_and_decoder.sym
** sch_path: /foss/designs/CHIP-PLL/PLL0663-main/schematic/xschem/divider/VCO_MUX_and_decoder.sch
.subckt VCO_MUX_and_decoder gd VP c0 c1 c2 f0 f1 f2 f3 f4 f5 VCO_in VCO2_in VCO3_in VCO4_in VCO5_in VCO2_11_sel VCO2_5_sel
+ VCO3_11_sel VCO3_5_sel VCO4_11_sel VCO4_5_sel out VCO4_sel VCO3_sel VCO2_sel VCO_sel VCO5_sel
*.iopin gd
*.iopin VP
*.ipin c1
*.ipin c2
*.ipin f0
*.ipin f1
*.ipin c0
*.opin VCO2_11_sel
*.opin VCO2_5_sel
*.opin VCO3_11_sel
*.opin VCO3_5_sel
*.opin VCO4_11_sel
*.opin VCO4_5_sel
*.ipin f2
*.ipin f3
*.ipin f4
*.ipin f5
*.ipin VCO_in
*.ipin VCO2_in
*.ipin VCO3_in
*.ipin VCO4_in
*.ipin VCO5_in
*.opin out
*.opin VCO_sel
*.opin VCO2_sel
*.opin VCO3_sel
*.opin VCO4_sel
*.opin VCO5_sel
x2 gd VP VCO_in VCO2_in VCO3_in VCO4_in VCO5_in VCO_sel VCO2_sel VCO3_sel VCO4_sel VCO5_sel out VCO_MUX
x4 VP gd VCO2_11_sel net1 VCO2_5_sel NOR_2in
x5 net1 VCO2_sel VP gd inverter
x3 VP gd VCO3_11_sel net2 VCO3_5_sel NOR_2in
x6 VP gd VCO4_11_sel net3 VCO4_5_sel NOR_2in
x7 net2 VCO3_sel VP gd inverter
x8 net3 VCO4_sel VP gd inverter
x9 gd VP c0 c1 c2 f0 f1 f2 f3 f4 f5 VCO_sel VCO2_11_sel VCO2_5_sel VCO3_11_sel VCO3_5_sel VCO4_11_sel VCO4_5_sel VCO5_sel
+ VCO_decoder_cells
.ends

* expanding   symbol:  /foss/designs/CHIP-PLL/PLL0663-main/schematic/xschem/divider/inverter.sym # of pins=4
** sym_path: /foss/designs/CHIP-PLL/PLL0663-main/schematic/xschem/divider/inverter.sym
** sch_path: /foss/designs/CHIP-PLL/PLL0663-main/schematic/xschem/divider/inverter.sch
.subckt inverter IN OUT VP GND
*.ipin IN
*.iopin VP
*.opin OUT
*.iopin GND
XM1 OUT IN GND GND sg13_lv_nmos w=0.15u l=0.13u ng=1 m=1 mm_ok=1
XM2 OUT IN VP VP sg13_lv_pmos w=0.15u l=0.13u ng=1 m=1 mm_ok=1
.ends

* expanding   symbol:  /foss/designs/CHIP-PLL/PLL0663-main/schematic/xschem/vco/vco_passgate.sym # of pins=6
** sym_path: /foss/designs/CHIP-PLL/PLL0663-main/schematic/xschem/vco/vco_passgate.sym
** sch_path: /foss/designs/CHIP-PLL/PLL0663-main/schematic/xschem/vco/vco_passgate.sch
.subckt vco_passgate en_ VP GND en IO OI
*.iopin OI
*.iopin IO
*.iopin VP
*.iopin GND
*.ipin en_
*.ipin en
XM1 IO en OI GND sg13_lv_nmos w=2.5u l=0.13u ng=1 m=1 mm_ok=1
XM2 IO en_ OI VP sg13_lv_pmos w=2.5u l=0.13u ng=1 m=1 mm_ok=1
.ends

* expanding   symbol:  /foss/designs/CHIP-PLL/PLL0663-main/schematic/xschem/divider/passgate.sym # of pins=6
** sym_path: /foss/designs/CHIP-PLL/PLL0663-main/schematic/xschem/divider/passgate.sym
** sch_path: /foss/designs/CHIP-PLL/PLL0663-main/schematic/xschem/divider/passgate.sch
.subckt passgate in_p vp gnd in_n A B
*.ipin in_n
*.ipin in_p
*.iopin vp
*.iopin gnd
*.iopin B
*.iopin A
XM4 B in_p A vp sg13_lv_pmos w=0.3u l=0.15u ng=1 m=1 mm_ok=1
XM5 B in_n A gnd sg13_lv_nmos w=0.3u l=0.15u ng=1 m=1 mm_ok=1
.ends

* expanding   symbol:  /foss/designs/CHIP-PLL/PLL0663-main/schematic/xschem/PFD/PFD_NOR.sym # of pins=5
** sym_path: /foss/designs/CHIP-PLL/PLL0663-main/schematic/xschem/PFD/PFD_NOR.sym
** sch_path: /foss/designs/CHIP-PLL/PLL0663-main/schematic/xschem/PFD/PFD_NOR.sch
.subckt PFD_NOR vp A B Out gd
*.ipin vp
*.ipin gd
*.ipin B
*.ipin A
*.opin Out
XM1 Out A net1 vp sg13_lv_pmos w=0.3u l=0.15u ng=1 m=1 mm_ok=1
XM4 net1 B vp vp sg13_lv_pmos w=0.3u l=0.15u ng=1 m=1 mm_ok=1
XM2 Out A gd gd sg13_lv_nmos w=0.3u l=0.15u ng=1 m=1 mm_ok=1
XM3 Out B gd gd sg13_lv_nmos w=0.3u l=0.15u ng=1 m=1 mm_ok=1
.ends

* expanding   symbol:  /foss/designs/CHIP-PLL/PLL0663-main/schematic/xschem/PFD/PFD_inverter_x8.sym # of pins=4
** sym_path: /foss/designs/CHIP-PLL/PLL0663-main/schematic/xschem/PFD/PFD_inverter_x8.sym
** sch_path: /foss/designs/CHIP-PLL/PLL0663-main/schematic/xschem/PFD/PFD_inverter_x8.sch
.subckt PFD_inverter_x8 IN OUT VP GND
*.ipin IN
*.iopin VP
*.opin OUT
*.iopin GND
XM1 OUT IN GND GND sg13_lv_nmos w=1.20u l=0.13u ng=1 m=1 mm_ok=1
XM2 OUT IN VP VP sg13_lv_pmos w=1.20u l=0.13u ng=1 m=1 mm_ok=1
.ends

* expanding   symbol:  /foss/designs/CHIP-PLL/PLL0663-main/schematic/xschem/divider/NOR_2in.sym # of pins=5
** sym_path: /foss/designs/CHIP-PLL/PLL0663-main/schematic/xschem/divider/NOR_2in.sym
** sch_path: /foss/designs/CHIP-PLL/PLL0663-main/schematic/xschem/divider/NOR_2in.sch
.subckt NOR_2in vp gd A Out B
*.opin Out
*.iopin gd
*.ipin A
*.iopin vp
*.ipin B
XM3 Out A gd gd sg13_lv_nmos w=0.15u l=0.13u ng=1 m=1 mm_ok=1
XM2 Out B net1 vp sg13_lv_pmos w=0.15u l=0.13u ng=1 m=1 mm_ok=1
XM4 net1 A vp vp sg13_lv_pmos w=0.15u l=0.13u ng=1 m=1 mm_ok=1
XM5 Out B gd gd sg13_lv_nmos w=0.15u l=0.13u ng=1 m=1 mm_ok=1
.ends

* expanding   symbol:  /foss/designs/CHIP-PLL/PLL0663-main/schematic/xschem/divider/div_with_reset.sym # of pins=10
** sym_path: /foss/designs/CHIP-PLL/PLL0663-main/schematic/xschem/divider/div_with_reset.sym
** sch_path: /foss/designs/CHIP-PLL/PLL0663-main/schematic/xschem/divider/div_with_reset.sch
.subckt div_with_reset gd vp in reset r_div2 r_div4 r_div8 r_div16 r_div32 r_div64
*.iopin gd
*.ipin in
*.iopin vp
*.opin r_div2
*.opin r_div4
*.opin r_div8
*.opin r_div16
*.opin r_div32
*.opin r_div64
*.ipin reset
x1 net1 vp gd r_div4 net2 r_div4 reset d_flip_flop_reset
x2 net2 vp gd r_div2 in r_div2 reset d_flip_flop_reset
x3 net6 vp gd r_div64 net5 r_div64 reset d_flip_flop_reset
x4 net5 vp gd r_div32 net4 r_div32 reset d_flip_flop_reset
x5 net4 vp gd r_div16 net3 r_div16 reset d_flip_flop_reset
x6 net3 vp gd r_div8 net1 r_div8 reset d_flip_flop_reset
* noconn #net6
.ends

* expanding   symbol:  /foss/designs/CHIP-PLL/PLL0663-main/schematic/xschem/divider/count_data_check.sym # of pins=15
** sym_path: /foss/designs/CHIP-PLL/PLL0663-main/schematic/xschem/divider/count_data_check.sym
** sch_path: /foss/designs/CHIP-PLL/PLL0663-main/schematic/xschem/divider/count_data_check.sch
.subckt count_data_check out VP GND c0 c1 c2 c3 c4 c5 d0 d1 d2 d3 d4 d5
*.iopin GND
*.ipin c0
*.iopin VP
*.ipin c1
*.opin out
*.ipin c2
*.ipin c3
*.ipin c4
*.ipin c5
*.ipin d0
*.ipin d1
*.ipin d3
*.ipin d4
*.ipin d5
*.ipin d2
x7 VP GND y0 and012 y1 y2 NAND_3in
x8 VP GND y3 and345 y4 y5 NAND_3in
x9 VP GND and012 out and345 NOR_2in
x1 VP GND d0 y0 c0 XNOR
x2 VP GND d1 y1 c1 XNOR
x3 VP GND d2 y2 c2 XNOR
x4 VP GND d3 y3 c3 XNOR
x5 VP GND d4 y4 c4 XNOR
x6 VP GND d5 y5 c5 XNOR
.ends

* expanding   symbol:  /foss/designs/CHIP-PLL/PLL0663-main/schematic/xschem/divider/d_flip_flop_reset.sym # of pins=7
** sym_path: /foss/designs/CHIP-PLL/PLL0663-main/schematic/xschem/divider/d_flip_flop_reset.sym
** sch_path: /foss/designs/CHIP-PLL/PLL0663-main/schematic/xschem/divider/d_flip_flop_reset.sch
.subckt d_flip_flop_reset q VP GND q_ clk d reset
*.iopin GND
*.ipin clk
*.iopin VP
*.ipin d
*.opin q
*.opin q_
*.ipin reset
x2 VP GND q q_ net3 reset NAND_3in_x3
x5 VP GND net3 net4 d reset NAND_3in_x3
x6 VP GND net2 net1 clk reset NAND_3in_x3
x4 VP GND net1 q q_ NAND_2in_x2
x3 VP GND net4 net2 net1 NAND_2in_x2
x1 VP GND net1 net3 clk net4 NAND_3in_x3
.ends

* expanding   symbol:  /foss/designs/CHIP-PLL/PLL0663-main/schematic/xschem/divider/inverter_x8.sym # of pins=4
** sym_path: /foss/designs/CHIP-PLL/PLL0663-main/schematic/xschem/divider/inverter_x8.sym
** sch_path: /foss/designs/CHIP-PLL/PLL0663-main/schematic/xschem/divider/inverter_x8.sch
.subckt inverter_x8 IN OUT VP GND
*.ipin IN
*.iopin VP
*.opin OUT
*.iopin GND
XM1 OUT IN GND GND sg13_lv_nmos w=0.60u l=0.13u ng=1 m=1 mm_ok=1
XM2 OUT IN VP VP sg13_lv_pmos w=1.20u l=0.13u ng=1 m=1 mm_ok=1
.ends

* expanding   symbol:  /foss/designs/CHIP-PLL/PLL0663-main/schematic/xschem/vco/vco_delay_cell_0.sym # of pins=6
** sym_path: /foss/designs/CHIP-PLL/PLL0663-main/schematic/xschem/vco/vco_delay_cell_0.sym
** sch_path: /foss/designs/CHIP-PLL/PLL0663-main/schematic/xschem/vco/vco_delay_cell_0.sch
.subckt vco_delay_cell_0 vp pgt in out ngt gnd
*.ipin in
*.opin out
*.iopin gnd
*.iopin vp
*.iopin pgt
*.iopin ngt
XM23 up pgt vp vp sg13_lv_pmos w=1.2u l=0.14*4u ng=1 m=1 mm_ok=1
XM1 out in up vp sg13_lv_pmos w=1.2u l=0.14*2u ng=1 m=1 mm_ok=1
XM2 out in dn gnd sg13_lv_nmos w=0.8u l=0.14*2u ng=1 m=1 mm_ok=1
XM26 dn ngt gnd gnd sg13_lv_nmos w=0.8u l=0.14*4u ng=1 m=1 mm_ok=1
.ends

* expanding   symbol:  /foss/designs/CHIP-PLL/PLL0663-main/schematic/xschem/vco/vco_delay_cell_1.sym # of pins=6
** sym_path: /foss/designs/CHIP-PLL/PLL0663-main/schematic/xschem/vco/vco_delay_cell_1.sym
** sch_path: /foss/designs/CHIP-PLL/PLL0663-main/schematic/xschem/vco/vco_delay_cell_1.sch
.subckt vco_delay_cell_1 vp pgt in out ngt gnd
*.ipin in
*.opin out
*.iopin gnd
*.iopin vp
*.iopin pgt
*.iopin ngt
XM23 up pgt vp vp sg13_lv_pmos w=1.2u l=0.35*4u ng=1 m=1 mm_ok=1
XM24 out in up vp sg13_lv_pmos w=1.2u l=0.35*2u ng=1 m=1 mm_ok=1
XM25 out in dn gnd sg13_lv_nmos w=0.8u l=0.35*2u ng=1 m=1 mm_ok=1
XM26 dn ngt gnd gnd sg13_lv_nmos w=0.8u l=0.35*4u ng=1 m=1 mm_ok=1
.ends

* expanding   symbol:  /foss/designs/CHIP-PLL/PLL0663-main/schematic/xschem/vco/vco_delay_cell_2.sym # of pins=6
** sym_path: /foss/designs/CHIP-PLL/PLL0663-main/schematic/xschem/vco/vco_delay_cell_2.sym
** sch_path: /foss/designs/CHIP-PLL/PLL0663-main/schematic/xschem/vco/vco_delay_cell_2.sch
.subckt vco_delay_cell_2 vp pgt in out ngt gnd
*.ipin in
*.opin out
*.iopin gnd
*.iopin vp
*.iopin pgt
*.iopin ngt
XM23 up pgt vp vp sg13_lv_pmos w=1.2u l=1.4*4u ng=1 m=1 mm_ok=1
XM24 out in up vp sg13_lv_pmos w=1.2u l=1.4*2u ng=1 m=1 mm_ok=1
XM25 out in dn gnd sg13_lv_nmos w=0.8u l=1.4*2u ng=1 m=1 mm_ok=1
XM26 dn ngt gnd gnd sg13_lv_nmos w=0.8u l=1.4*4u ng=1 m=1 mm_ok=1
.ends

* expanding   symbol:  /foss/designs/CHIP-PLL/PLL0663-main/schematic/xschem/vco/vco_delay_cell_3.sym # of pins=6
** sym_path: /foss/designs/CHIP-PLL/PLL0663-main/schematic/xschem/vco/vco_delay_cell_3.sym
** sch_path: /foss/designs/CHIP-PLL/PLL0663-main/schematic/xschem/vco/vco_delay_cell_3.sch
.subckt vco_delay_cell_3 vp pgt in out ngt gnd
*.ipin in
*.opin out
*.iopin gnd
*.iopin vp
*.iopin pgt
*.iopin ngt
XM23 up pgt vp vp sg13_lv_pmos w=1.2u l=4.25*4u ng=1 m=1 mm_ok=1
XM24 out in up vp sg13_lv_pmos w=1.2u l=4.25*2u ng=1 m=1 mm_ok=1
XM25 out in dn gnd sg13_lv_nmos w=0.8u l=4.25*2u ng=1 m=1 mm_ok=1
XM26 dn ngt gnd gnd sg13_lv_nmos w=0.8u l=4.25*4u ng=1 m=1 mm_ok=1
.ends

* expanding   symbol:  /foss/designs/CHIP-PLL/PLL0663-main/schematic/xschem/vco/vco_delay_cell_4.sym # of pins=6
** sym_path: /foss/designs/CHIP-PLL/PLL0663-main/schematic/xschem/vco/vco_delay_cell_4.sym
** sch_path: /foss/designs/CHIP-PLL/PLL0663-main/schematic/xschem/vco/vco_delay_cell_4.sch
.subckt vco_delay_cell_4 vp pgt in out ngt gnd
*.ipin in
*.opin out
*.iopin gnd
*.iopin vp
*.iopin pgt
*.iopin ngt
XM23 up pgt vp vp sg13_lv_pmos w=1.2u l=5.9*4u ng=1 m=1 mm_ok=1
XM24 out in up vp sg13_lv_pmos w=1.2u l=5.9*2u ng=1 m=1 mm_ok=1
XM25 out in dn gnd sg13_lv_nmos w=0.8u l=5.9*2u ng=1 m=1 mm_ok=1
XM26 dn ngt gnd gnd sg13_lv_nmos w=0.8u l=5.9*4u ng=1 m=1 mm_ok=1
.ends

* expanding   symbol:  /foss/designs/CHIP-PLL/PLL0663-main/schematic/xschem/divider/VCO_MUX.sym # of pins=13
** sym_path: /foss/designs/CHIP-PLL/PLL0663-main/schematic/xschem/divider/VCO_MUX.sym
** sch_path: /foss/designs/CHIP-PLL/PLL0663-main/schematic/xschem/divider/VCO_MUX.sch
.subckt VCO_MUX gd VP VCO_in VCO2_in VCO3_in VCO4_in VCO5_in VCO_sel VCO2_sel VCO3_sel VCO4_sel VCO5_sel out
*.iopin gd
*.iopin VP
*.ipin VCO2_in
*.ipin VCO3_in
*.ipin VCO4_in
*.ipin VCO5_in
*.opin out
*.ipin VCO_in
*.ipin VCO2_sel
*.ipin VCO3_sel
*.ipin VCO_sel
*.ipin VCO4_sel
*.ipin VCO5_sel
x2 VCO_sel net1 VP gd inverter_dek
x3 net2 VP gd VCO2_sel VCO2_in out passgate_scaled
x4 VCO2_sel net2 VP gd inverter_dek
x5 net3 VP gd VCO3_sel VCO3_in out passgate_scaled
x6 VCO3_sel net3 VP gd inverter_dek
x7 net4 VP gd VCO4_sel VCO4_in out passgate_scaled
x8 VCO4_sel net4 VP gd inverter_dek
x9 net5 VP gd VCO5_sel VCO5_in out passgate_scaled
x10 VCO5_sel net5 VP gd inverter_dek
x1 net1 VP gd VCO_sel VCO_in out vco_passgate_mux
.ends

* expanding   symbol:  /foss/designs/CHIP-PLL/PLL0663-main/schematic/xschem/divider/VCO_decoder_cells.sym # of pins=19
** sym_path: /foss/designs/CHIP-PLL/PLL0663-main/schematic/xschem/divider/VCO_decoder_cells.sym
** sch_path: /foss/designs/CHIP-PLL/PLL0663-main/schematic/xschem/divider/VCO_decoder_cells.sch
.subckt VCO_decoder_cells gd VP c0 c1 c2 f0 f1 f2 f3 f4 f5 VCO_sel VCO2_11_sel VCO2_5_sel VCO3_11_sel VCO3_5_sel VCO4_11_sel
+ VCO4_5_sel VCO5_11_sel
*.iopin gd
*.iopin VP
*.ipin c1
*.ipin c2
*.ipin f0
*.ipin f1
*.ipin c0
*.opin VCO2_11_sel
*.opin VCO2_5_sel
*.opin VCO_sel
*.opin VCO3_11_sel
*.opin VCO3_5_sel
*.opin VCO4_11_sel
*.opin VCO4_5_sel
*.opin VCO5_11_sel
*.ipin f2
*.ipin f3
*.ipin f4
*.ipin f5
x6 gd VP c0 c1 c2 000 001 010 011 100 101 110 111 3bit_to_8_outs
x7 after_000011 after_000011_n 000000 f5_n gd after_000111 VP after_000111_n after_001111 after_001111_n f1 f2 f3 f4 f5 000000_n
+ f0 row_section_decoding
x4 gd VP 110 after_001111_n after_000111 111 000000_n 101 after_000011 after_001111 f5_n after_000111_n 010 100 after_000011_n 011
+ f5 VCO2_5_sel VCO2_11_sel VCO2_selection
x2 gd VP 000000 000 000000_n after_001111_n 010 after_000011_n 011 001 after_000011 after_000111_n VCO4_11_sel VCO4_5_sel f0 f1
+ VCO4_selection
x1 VCO_sel after_000111 111 gd VP after_001111 110 101 f5 VCO_selection
x5 gd VP f5_n 000000 after_000111_n 001 000000_n 110 011 101 000 after_000011_n after_000111 after_001111 100 after_001111_n
+ after_000011 010 VCO3_11_sel VCO3_5_sel f5 VCO3_selection
x3 gd VP VCO5_11_sel 000 after_000011_n 010 000000 VCO5_selection
.ends

* expanding   symbol:  /foss/designs/CHIP-PLL/PLL0663-main/schematic/xschem/divider/XNOR.sym # of pins=5
** sym_path: /foss/designs/CHIP-PLL/PLL0663-main/schematic/xschem/divider/XNOR.sym
** sch_path: /foss/designs/CHIP-PLL/PLL0663-main/schematic/xschem/divider/XNOR.sch
.subckt XNOR VP GND a y b
*.opin y
*.iopin GND
*.ipin a
*.iopin VP
*.ipin b
XM1 y a net1 GND sg13_lv_nmos w=0.15u l=0.13u ng=1 m=1 mm_ok=1
XM3 net1 _b GND GND sg13_lv_nmos w=0.15u l=0.13u ng=1 m=1 mm_ok=1
XM2 net2 a VP VP sg13_lv_pmos w=0.15u l=0.13u ng=1 m=4 mm_ok=1
XM4 net3 _a VP VP sg13_lv_pmos w=0.15u l=0.13u ng=1 m=4 mm_ok=1
XM5 y _a net4 GND sg13_lv_nmos w=0.15u l=0.13u ng=1 m=1 mm_ok=1
XM6 net4 b GND GND sg13_lv_nmos w=0.15u l=0.13u ng=1 m=1 mm_ok=1
XM7 y b net2 VP sg13_lv_pmos w=0.15u l=0.13u ng=1 m=4 mm_ok=1
XM8 y _b net3 VP sg13_lv_pmos w=0.15u l=0.13u ng=1 m=4 mm_ok=1
x1 a _a VP GND inverter
x2 b _b VP GND inverter
.ends

* expanding   symbol:  /foss/designs/CHIP-PLL/PLL0663-main/schematic/xschem/divider/NAND_3in_x3.sym # of pins=6
** sym_path: /foss/designs/CHIP-PLL/PLL0663-main/schematic/xschem/divider/NAND_3in_x3.sym
** sch_path: /foss/designs/CHIP-PLL/PLL0663-main/schematic/xschem/divider/NAND_3in_x3.sch
.subckt NAND_3in_x3 VP GND a y b c
*.opin y
*.iopin GND
*.ipin a
*.iopin VP
*.ipin b
*.ipin c
XM1 y a net2 GND sg13_lv_nmos w=1.20u l=0.13u ng=1 m=1 mm_ok=1
XM5 y b VP VP sg13_lv_pmos w=0.3u l=0.13u ng=1 m=1 mm_ok=1
XM3 net2 b net1 GND sg13_lv_nmos w=1.20u l=0.13u ng=1 m=1 mm_ok=1
XM4 net1 c GND GND sg13_lv_nmos w=1.20u l=0.13u ng=1 m=1 mm_ok=1
XM2 y a VP VP sg13_lv_pmos w=0.3u l=0.13u ng=1 m=1 mm_ok=1
XM6 y c VP VP sg13_lv_pmos w=0.3u l=0.13u ng=1 m=1 mm_ok=1
.ends

* expanding   symbol:  /foss/designs/CHIP-PLL/PLL0663-main/schematic/xschem/divider/inverter_dek.sym # of pins=4
** sym_path: /foss/designs/CHIP-PLL/PLL0663-main/schematic/xschem/divider/inverter_dek.sym
** sch_path: /foss/designs/CHIP-PLL/PLL0663-main/schematic/xschem/divider/inverter_dek.sch
.subckt inverter_dek IN OUT VP GND
*.ipin IN
*.iopin VP
*.opin OUT
*.iopin GND
XM1 OUT IN GND GND sg13_lv_nmos w=0.15u l=0.13u ng=1 m=1 mm_ok=1
XM2 OUT IN VP VP sg13_lv_pmos w=0.15u l=0.13u ng=1 m=1 mm_ok=1
.ends

* expanding   symbol:  /foss/designs/CHIP-PLL/PLL0663-main/schematic/xschem/divider/passgate_scaled.sym # of pins=6
** sym_path: /foss/designs/CHIP-PLL/PLL0663-main/schematic/xschem/divider/passgate_scaled.sym
** sch_path: /foss/designs/CHIP-PLL/PLL0663-main/schematic/xschem/divider/passgate_scaled.sch
.subckt passgate_scaled en_ VP GND en IO OI
*.iopin OI
*.iopin IO
*.iopin VP
*.iopin GND
*.ipin en_
*.ipin en
XM1 IO en OI GND sg13_lv_nmos w=0.15u l=0.13u ng=1 m=1 mm_ok=1
XM2 IO en_ OI VP sg13_lv_pmos w=0.15u l=0.13u ng=1 m=1 mm_ok=1
.ends

* expanding   symbol:  /foss/designs/CHIP-PLL/PLL0663-main/schematic/xschem/divider/vco_passgate_mux.sym # of pins=6
** sym_path: /foss/designs/CHIP-PLL/PLL0663-main/schematic/xschem/divider/vco_passgate_mux.sym
** sch_path: /foss/designs/CHIP-PLL/PLL0663-main/schematic/xschem/divider/vco_passgate_mux.sch
.subckt vco_passgate_mux en_ VP GND en IO OI
*.iopin OI
*.iopin IO
*.iopin VP
*.iopin GND
*.ipin en_
*.ipin en
XM1 IO en OI GND sg13_lv_nmos w=2.5u l=0.13u ng=1 m=1 mm_ok=1
XM2 IO en_ OI VP sg13_lv_pmos w=2.5u l=0.13u ng=1 m=1 mm_ok=1
.ends

* expanding   symbol:  /foss/designs/CHIP-PLL/PLL0663-main/schematic/xschem/divider/3bit_to_8_outs.sym # of pins=13
** sym_path: /foss/designs/CHIP-PLL/PLL0663-main/schematic/xschem/divider/3bit_to_8_outs.sym
** sch_path: /foss/designs/CHIP-PLL/PLL0663-main/schematic/xschem/divider/3bit_to_8_outs.sch
.subckt 3bit_to_8_outs gd VP c0 c1 c2 coarse_0 coarse_1 coarse_2 coarse_3 coarse_4 coarse_5 coarse_6 coarse_7
*.iopin gd
*.iopin VP
*.ipin c1
*.ipin c2
*.ipin c0
*.opin coarse_1
*.opin coarse_2
*.opin coarse_0
*.opin coarse_3
*.opin coarse_4
*.opin coarse_5
*.opin coarse_6
*.opin coarse_7
x1 c0 c0_n VP gd inverter_dek
x4 VP gd c0_n net1 c1_n c2_n NAND_3in_dek
x2 c1 c1_n VP gd inverter_dek
x3 c2 c2_n VP gd inverter_dek
x8 net4 coarse_3 VP gd inverter_dek
x9 net3 coarse_2 VP gd inverter_dek
x10 net2 coarse_1 VP gd inverter_dek
x11 net1 coarse_0 VP gd inverter_dek
x12 net8 coarse_7 VP gd inverter_dek
x13 net7 coarse_6 VP gd inverter_dek
x15 net6 coarse_5 VP gd inverter_dek
x16 net5 coarse_4 VP gd inverter_dek
x5 VP gd c0 net2 c1_n c2_n NAND_3in_dek
x6 VP gd c0_n net3 c1 c2_n NAND_3in_dek
x7 VP gd c0 net4 c1 c2_n NAND_3in_dek
x14 VP gd c0 net8 c1 c2 NAND_3in_dek
x17 VP gd c0_n net7 c1 c2 NAND_3in_dek
x18 VP gd c0 net6 c1_n c2 NAND_3in_dek
x19 VP gd c0_n net5 c1_n c2 NAND_3in_dek
.ends

* expanding   symbol:  /foss/designs/CHIP-PLL/PLL0663-main/schematic/xschem/divider/row_section_decoding.sym # of pins=17
** sym_path: /foss/designs/CHIP-PLL/PLL0663-main/schematic/xschem/divider/row_section_decoding.sym
** sch_path: /foss/designs/CHIP-PLL/PLL0663-main/schematic/xschem/divider/row_section_decoding.sch
.subckt row_section_decoding after_000011 after_000011_n 000000 f5_n gd after_000111 VP after_000111_n after_001111 after_001111_n
+ f1 f2 f3 f4 f5 000000_n f0
*.ipin f1
*.ipin f2
*.ipin f3
*.ipin f4
*.ipin f5
*.iopin gd
*.iopin VP
*.opin after_000011_n
*.opin 000000
*.opin after_000011
*.opin f5_n
*.opin after_000111
*.opin after_000111_n
*.opin after_001111
*.opin after_001111_n
*.opin 000000_n
*.ipin f0
x2 VP gd f2 net1 f3 NOR_2in_dek
x3 VP gd f4 net2 f5 NOR_2in_dek
x4 VP gd f3 after_000111_n f4 f5 NOR_3in_dek
x5 VP gd f4 after_001111_n f5 NOR_2in_dek
x6 VP gd net1 after_000011 net2 NAND_2in_dek
x7 after_000111_n after_000111 VP gd inverter_dek
x8 after_001111_n after_001111 VP gd inverter_dek
x9 after_000011 after_000011_n VP gd inverter_dek
x10 f5 f5_n VP gd inverter_dek
x11 VP gd f2 net3 f3 NOR_2in_dek
x27 VP gd f4 net4 f5 NOR_2in_dek
x29 VP gd f1 net5 f0 NOR_2in_dek
x31 VP gd net3 000000_n net4 net5 NAND_3in_dek
x33 000000_n 000000 VP gd inverter_dek
.ends

* expanding   symbol:  /foss/designs/CHIP-PLL/PLL0663-main/schematic/xschem/divider/VCO2_selection.sym # of pins=19
** sym_path: /foss/designs/CHIP-PLL/PLL0663-main/schematic/xschem/divider/VCO2_selection.sym
** sch_path: /foss/designs/CHIP-PLL/PLL0663-main/schematic/xschem/divider/VCO2_selection.sch
.subckt VCO2_selection gd VP 110 after_001111_n after_000111 111 000000_n 101 after_000011 after_001111 f5_n after_000111_n 010
+ 100 after_000011_n 011 f5 VCO2_5_sel VCO2_11_sel
*.iopin gd
*.iopin VP
*.ipin after_001111_n
*.ipin after_000111
*.ipin 000000_n
*.ipin 110
*.opin VCO2_11_sel
*.opin VCO2_5_sel
*.ipin 101
*.ipin f5_n
*.ipin 100
*.ipin f5
*.ipin 011
*.ipin after_000111_n
*.ipin after_000011
*.ipin 111
*.ipin after_000011_n
*.ipin 010
*.ipin after_001111
x15 VP gd 110 net1 after_001111_n after_000111 NAND_3in_dek
x16 VP gd 100 net3 f5 NAND_2in_dek
x19 VP gd net1 VCO2_5_sel net2 net3 net4 NAND_4in_dek
x22 net9 net10 VP gd inverter_dek
x1 VP gd 101 net2 after_000111 f5_n NAND_3in_dek
x2 VP gd 111 net4 after_000011 after_000111_n NAND_3in_dek
x3 VP gd 010 net11 f5 NAND_2in_dek
x4 VP gd 011 net6 after_001111 NAND_2in_dek
x5 VP gd 111 net7 after_000011_n NAND_2in_dek
x6 VP gd 100 net5 after_000111 f5_n NAND_3in_dek
x7 VP gd 101 net8 after_000011 after_000111_n NAND_3in_dek
x8 VP gd 110 net12 after_000111_n 000000_n NAND_3in_dek
x9 VP gd net10 VCO2_11_sel net8 net12 net7 NAND_4in_dek
x10 VP gd net11 net9 net6 net5 NAND_3in_dek
.ends

* expanding   symbol:  /foss/designs/CHIP-PLL/PLL0663-main/schematic/xschem/divider/VCO4_selection.sym # of pins=16
** sym_path: /foss/designs/CHIP-PLL/PLL0663-main/schematic/xschem/divider/VCO4_selection.sym
** sch_path: /foss/designs/CHIP-PLL/PLL0663-main/schematic/xschem/divider/VCO4_selection.sch
.subckt VCO4_selection gd VP 000000 000 000000_n after_001111_n 010 after_000011_n 011 001 after_000011 after_000111_n VCO4_11_sel
+ VCO4_5_sel f0 f1
*.iopin gd
*.iopin VP
*.ipin 000000_n
*.opin VCO4_5_sel
*.opin VCO4_11_sel
*.ipin 000
*.ipin 000000
*.ipin after_001111_n
*.ipin 010
*.ipin after_000011_n
*.ipin 011
*.ipin 001
*.ipin after_000011
*.ipin after_000111_n
*.ipin f1
*.ipin f0
x1 VP gd 001 net5 after_000011_n nand_f1_f0 NAND_3in_dek
x2 VP gd 010 net2 after_000011_n 000000_n NAND_3in_dek
x3 VP gd 001 net4 after_000111_n Z NAND_3in_dek
x4 VP gd 000 net1 after_000011 after_001111_n NAND_3in_dek
x7 VP gd 011 net3 000000 NAND_2in_dek
x8 VP gd f1 nand_f1_f0 f0 NAND_2in_dek
x9 VP gd nand_f1_f0 Z after_000011_n NAND_2in_dek
x5 net5 VCO4_11_sel VP gd inverter_dek
x6 VP gd net1 VCO4_5_sel net4 net2 net3 NAND_4in_dek
.ends

* expanding   symbol:  /foss/designs/CHIP-PLL/PLL0663-main/schematic/xschem/divider/VCO_selection.sym # of pins=9
** sym_path: /foss/designs/CHIP-PLL/PLL0663-main/schematic/xschem/divider/VCO_selection.sym
** sch_path: /foss/designs/CHIP-PLL/PLL0663-main/schematic/xschem/divider/VCO_selection.sch
.subckt VCO_selection VCO_sel after_000111 111 gd VP after_001111 110 101 f5
*.iopin gd
*.iopin VP
*.ipin after_000111
*.ipin 111
*.ipin after_001111
*.ipin 110
*.ipin 101
*.ipin f5
*.opin VCO_sel
x11 VP gd after_000111 net1 111 NAND_2in_dek
x14 VP gd net1 VCO_sel net2 net3 NAND_3in_dek
x1 VP gd after_001111 net2 110 NAND_2in_dek
x2 VP gd 101 net3 f5 NAND_2in_dek
.ends

* expanding   symbol:  /foss/designs/CHIP-PLL/PLL0663-main/schematic/xschem/divider/VCO3_selection.sym # of pins=21
** sym_path: /foss/designs/CHIP-PLL/PLL0663-main/schematic/xschem/divider/VCO3_selection.sym
** sch_path: /foss/designs/CHIP-PLL/PLL0663-main/schematic/xschem/divider/VCO3_selection.sch
.subckt VCO3_selection gd VP f5_n 000000 after_000111_n 001 000000_n 110 011 101 000 after_000011_n after_000111 after_001111 100
+ after_001111_n after_000011 010 VCO3_11_sel VCO3_5_sel f5
*.iopin gd
*.iopin VP
*.ipin 000000_n
*.ipin 000000
*.opin VCO3_11_sel
*.opin VCO3_5_sel
*.ipin 011
*.ipin after_000111
*.ipin after_001111_n
*.ipin 010
*.ipin 001
*.ipin 101
*.ipin f5_n
*.ipin 100
*.ipin after_000011
*.ipin after_000011_n
*.ipin 110
*.ipin 000
*.ipin after_000111_n
*.ipin after_001111
*.ipin f5
x47 VP gd 010 net2 after_000111 f5_n NAND_3in_dek
x50 VP gd 001 net3 f5 NAND_2in_dek
x34 VP gd net12 VCO3_5_sel net4 net13 net5 NAND_4in_dek
x35 net11 net12 VP gd inverter_dek
x39 net14 net15 VP gd inverter_dek
x1 VP gd net3 net11 net2 net1 NAND_3in_dek
x2 VP gd 011 net1 after_000111 after_001111_n NAND_3in_dek
x3 VP gd 100 net4 000000_n after_000111_n NAND_3in_dek
x4 VP gd 101 net13 after_000011_n NAND_2in_dek
x5 VP gd 110 net5 000000 NAND_2in_dek
x6 VP gd 000 net8 after_001111 NAND_2in_dek
x7 VP gd 100 net9 000000 NAND_2in_dek
x8 VP gd net8 net14 net7 NAND_2in_dek
x9 VP gd 001 net7 after_000111 f5_n NAND_3in_dek
x10 VP gd 010 net10 after_000011 after_000111_n NAND_3in_dek
x11 VP gd 011 net6 after_000111_n 000000_n NAND_3in_dek
x12 VP gd net15 VCO3_11_sel net10 net6 net9 NAND_4in_dek
.ends

* expanding   symbol:  /foss/designs/CHIP-PLL/PLL0663-main/schematic/xschem/divider/VCO5_selection.sym # of pins=7
** sym_path: /foss/designs/CHIP-PLL/PLL0663-main/schematic/xschem/divider/VCO5_selection.sym
** sch_path: /foss/designs/CHIP-PLL/PLL0663-main/schematic/xschem/divider/VCO5_selection.sch
.subckt VCO5_selection gd VP VCO5_11_sel 000 after_000011_n 010 000000
*.iopin gd
*.iopin VP
*.opin VCO5_11_sel
*.ipin 000
*.ipin after_000011_n
*.ipin 010
*.ipin 000000
x1 VP gd 010 net2 000000 NAND_2in_dek
x2 VP gd net1 VCO5_11_sel net2 NAND_2in_dek
x3 VP gd 000 net1 after_000011_n NAND_2in_dek
.ends

* expanding   symbol:  /foss/designs/CHIP-PLL/PLL0663-main/schematic/xschem/divider/NAND_3in_dek.sym # of pins=6
** sym_path: /foss/designs/CHIP-PLL/PLL0663-main/schematic/xschem/divider/NAND_3in_dek.sym
** sch_path: /foss/designs/CHIP-PLL/PLL0663-main/schematic/xschem/divider/NAND_3in_dek.sch
.subckt NAND_3in_dek VP GND a y b c
*.opin y
*.iopin GND
*.ipin a
*.iopin VP
*.ipin b
*.ipin c
XM1 y a net2 GND sg13_lv_nmos w=0.15u l=0.13u ng=1 m=1 mm_ok=1
XM3 net2 b net1 GND sg13_lv_nmos w=0.15u l=0.13u ng=1 m=1 mm_ok=1
XM4 net1 c GND GND sg13_lv_nmos w=0.15u l=0.13u ng=1 m=1 mm_ok=1
XM7 y c VP VP sg13_lv_pmos w=0.15u l=0.13u ng=1 m=1 mm_ok=1
XM2 y a VP VP sg13_lv_pmos w=0.15u l=0.13u ng=1 m=1 mm_ok=1
XM5 y b VP VP sg13_lv_pmos w=0.15u l=0.13u ng=1 m=1 mm_ok=1
.ends

* expanding   symbol:  /foss/designs/CHIP-PLL/PLL0663-main/schematic/xschem/divider/NOR_2in_dek.sym # of pins=5
** sym_path: /foss/designs/CHIP-PLL/PLL0663-main/schematic/xschem/divider/NOR_2in_dek.sym
** sch_path: /foss/designs/CHIP-PLL/PLL0663-main/schematic/xschem/divider/NOR_2in_dek.sch
.subckt NOR_2in_dek vp gd A Out B
*.opin Out
*.iopin gd
*.ipin A
*.iopin vp
*.ipin B
XM3 Out A gd gd sg13_lv_nmos w=0.15u l=0.13u ng=1 m=1 mm_ok=1
XM2 Out B net1 vp sg13_lv_pmos w=0.15u l=0.13u ng=1 m=1 mm_ok=1
XM4 net1 A vp vp sg13_lv_pmos w=0.15u l=0.13u ng=1 m=1 mm_ok=1
XM5 Out B gd gd sg13_lv_nmos w=0.15u l=0.13u ng=1 m=1 mm_ok=1
.ends

* expanding   symbol:  /foss/designs/CHIP-PLL/PLL0663-main/schematic/xschem/divider/NOR_3in_dek.sym # of pins=6
** sym_path: /foss/designs/CHIP-PLL/PLL0663-main/schematic/xschem/divider/NOR_3in_dek.sym
** sch_path: /foss/designs/CHIP-PLL/PLL0663-main/schematic/xschem/divider/NOR_3in_dek.sch
.subckt NOR_3in_dek VP GND a y b c
*.opin y
*.iopin GND
*.ipin a
*.iopin VP
*.ipin b
*.ipin c
XM3 y a GND GND sg13_lv_nmos w=0.15u l=0.13u ng=1 m=1 mm_ok=1
XM2 y b net2 VP sg13_lv_pmos w=0.15u l=0.13u ng=1 m=1 mm_ok=1
XM4 net1 a VP VP sg13_lv_pmos w=0.15u l=0.13u ng=1 m=1 mm_ok=1
XM5 y b GND GND sg13_lv_nmos w=0.15u l=0.13u ng=1 m=1 mm_ok=1
XM1 y c GND GND sg13_lv_nmos w=0.15u l=0.13u ng=1 m=1 mm_ok=1
XM6 net2 c net1 VP sg13_lv_pmos w=0.15u l=0.13u ng=1 m=1 mm_ok=1
.ends

* expanding   symbol:  /foss/designs/CHIP-PLL/PLL0663-main/schematic/xschem/divider/NAND_2in_dek.sym # of pins=5
** sym_path: /foss/designs/CHIP-PLL/PLL0663-main/schematic/xschem/divider/NAND_2in_dek.sym
** sch_path: /foss/designs/CHIP-PLL/PLL0663-main/schematic/xschem/divider/NAND_2in_dek.sch
.subckt NAND_2in_dek VP GND a y b
*.opin y
*.iopin GND
*.ipin a
*.iopin VP
*.ipin b
XM1 y a net1 GND sg13_lv_nmos w=0.15u l=0.13u ng=1 m=1 mm_ok=1
XM3 net1 b GND GND sg13_lv_nmos w=0.15u l=0.13u ng=1 m=1 mm_ok=1
XM2 y b VP VP sg13_lv_pmos w=0.15u l=0.13u ng=1 m=1 mm_ok=1
XM4 y a VP VP sg13_lv_pmos w=0.15u l=0.13u ng=1 m=1 mm_ok=1
.ends

* expanding   symbol:  /foss/designs/CHIP-PLL/PLL0663-main/schematic/xschem/divider/NAND_4in_dek.sym # of pins=7
** sym_path: /foss/designs/CHIP-PLL/PLL0663-main/schematic/xschem/divider/NAND_4in_dek.sym
** sch_path: /foss/designs/CHIP-PLL/PLL0663-main/schematic/xschem/divider/NAND_4in_dek.sch
.subckt NAND_4in_dek VP GND a y b c d
*.opin y
*.iopin GND
*.ipin a
*.iopin VP
*.ipin b
*.ipin c
*.ipin d
XM1 y a net2 GND sg13_lv_nmos w=0.15u l=0.13u ng=1 m=1 mm_ok=1
XM3 net3 c net1 GND sg13_lv_nmos w=0.15u l=0.13u ng=1 m=1 mm_ok=1
XM4 net1 d GND GND sg13_lv_nmos w=0.15u l=0.13u ng=1 m=1 mm_ok=1
XM7 y c VP VP sg13_lv_pmos w=0.15u l=0.13u ng=1 m=1 mm_ok=1
XM2 y a VP VP sg13_lv_pmos w=0.15u l=0.13u ng=1 m=1 mm_ok=1
XM5 y b VP VP sg13_lv_pmos w=0.15u l=0.13u ng=1 m=1 mm_ok=1
XM6 y d VP VP sg13_lv_pmos w=0.15u l=0.13u ng=1 m=1 mm_ok=1
XM8 net2 b net3 GND sg13_lv_nmos w=0.15u l=0.13u ng=1 m=1 mm_ok=1
.ends

.end
