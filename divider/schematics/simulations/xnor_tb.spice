** sch_path: /foss/designs/CHIP-PLL/divider/tb/xnor_tb.sch
**.subckt xnor_tb
V1 VP 0 1.2
V2 a 0 PULSE(0 1.2 0 10p 10p 3.335n 6.67n)
C2 y 0 10f
x1 VP 0 a y b XNOR
V3 b 0 PULSE(0 1.2 2n 10p 10p 3.335n 6.67n)
**** begin user architecture code
 .lib cornerMOSlv.lib mos_tt

.param temp=27
.control

op
print all
save all

tran 50p 200n
write xnor_tb.raw
set appendwrite
plot v(a) v(b) v(c)
plot v(y)
plot X1.VP
.endc

**** end user architecture code
**.ends

* expanding   symbol:  XNOR.sym # of pins=5
** sym_path: /foss/designs/CHIP-PLL/divider/schematics/XNOR.sym
** sch_path: /foss/designs/CHIP-PLL/divider/schematics/XNOR.sch
.subckt XNOR VP GND a y b
*.opin y
*.iopin GND
*.ipin a
*.iopin VP
*.ipin b
XM1 y a net1 GND sg13_lv_nmos w=0.15u l=0.13u ng=1
XM3 net1 _b GND GND sg13_lv_nmos w=0.15u l=0.13u ng=1
XM2 net2 a VP VP sg13_lv_pmos w=0.15u l=0.13u ng=1 m=4
XM4 net3 _a VP VP sg13_lv_pmos w=0.15u l=0.13u ng=1 m=4
XM5 y _a net4 GND sg13_lv_nmos w=0.15u l=0.13u ng=1
XM6 net4 b GND GND sg13_lv_nmos w=0.15u l=0.13u ng=1
XM7 y b net2 VP sg13_lv_pmos w=0.15u l=0.13u ng=1 m=4
XM8 y _b net3 VP sg13_lv_pmos w=0.15u l=0.13u ng=1 m=4
x2 a _a VP GND inverter
x1 b _b VP GND inverter
.ends

* expanding   symbol:  inverter.sym # of pins=4
** sym_path: /foss/designs/CHIP-PLL/divider/schematics/inverter.sym
** sch_path: /foss/designs/CHIP-PLL/divider/schematics/inverter.sch
.subckt inverter IN OUT VP GND
*.ipin IN
*.iopin VP
*.opin OUT
*.iopin GND
XM1 OUT IN GND GND sg13_lv_nmos w=0.15u l=0.13u ng=1
XM2 OUT IN VP VP sg13_lv_pmos w=0.15u l=0.13u ng=1
.ends

.end
