** sch_path: /foss/designs/CHIP-PLL/charge_pump/charge_pump_op_tb.sch
**.subckt charge_pump_op_tb
Vvp vp 0 1.2
C1 vout 0 5p
Vup2 up 0 1
Vdn2 dn 0 1
Vup1 vout 0 0.2
x1 vp up vout dn 0 charge_pump_cell
**** begin user architecture code

.temp -40

 .lib cornerMOSlv.lib mos_tt
.include /foss/pdks/ihp-sg13g2/libs.tech/ngspice/models/resistors_mod.lib

**** end user architecture code
**.ends

* expanding   symbol:  /foss/designs/CHIP-PLL/charge_pump/charge_pump_cell.sym # of pins=5
** sym_path: /foss/designs/CHIP-PLL/charge_pump/charge_pump_cell.sym
** sch_path: /foss/designs/CHIP-PLL/charge_pump/charge_pump_cell.sch
.subckt charge_pump_cell vp UP vout DN gd
*.iopin UP
*.iopin DN
*.iopin gd
*.iopin vp
*.opin vout
XM15 net13 bias net4 gd sg13_lv_nmos w=1.6u l=0.6u ng=1
XM16 net4 net1 gd gd sg13_lv_nmos w=1.6u l=0.6u ng=1
XM1 net15 bias net10 gd sg13_lv_nmos w=1.6u l=0.6u ng=1
XM6 net10 bias net7 gd sg13_lv_nmos w=1.6u l=0.6u ng=1
XM8 net7 net1 gd gd sg13_lv_nmos w=1.6u l=0.6u ng=1
XM9 net1 bias net2 gd sg13_lv_nmos w=4.8u l=0.6u ng=1
XM10 net2 net1 gd gd sg13_lv_nmos w=4.8u l=0.6u ng=1
Xq net15 bias net8 vp sg13_lv_pmos w=1.6u l=0.6u ng=1
XM7 net3 bias net5 vp sg13_lv_pmos w=2u l=0.6u ng=1 m=3
XM11 net5 net15 vp vp sg13_lv_pmos w=2u l=0.6u ng=1 m=3
XM2 net8 net15 vp vp sg13_lv_pmos w=5.6u l=0.6u ng=1
XM17 vout net9 net3 vp sg13_lv_pmos w=1u l=0.6u ng=1 m=3
XM18 vout DN net13 gd sg13_lv_nmos w=1u l=0.6u ng=1
XM3 net1 net6 vp vp sg13_lv_pmos w=1u l=0.6u ng=1
x2 vp net6 gd curr_source
x1 vp gd bias vbias
XM4 net9 UP vp vp sg13_lv_pmos w=1u l=0.8u ng=1 m=3
XM5 net9 UP gd gd sg13_lv_nmos w=1u l=0.6u ng=1
.ends

* expanding   symbol:  /foss/designs/CHIP-PLL/charge_pump/curr_source.sym # of pins=3
** sym_path: /foss/designs/CHIP-PLL/charge_pump/curr_source.sym
** sch_path: /foss/designs/CHIP-PLL/charge_pump/curr_source.sch
.subckt curr_source vp iref gd
*.iopin vp
*.iopin gd
*.opin iref
XM4 iref iref vp vp sg13_lv_pmos w=1.4u l=0.6u ng=1
XM5 net2 iref vp vp sg13_lv_pmos w=1.2u l=0.6u ng=1
XM6 net3 net3 gd gd sg13_lv_nmos w=1u l=0.6u ng=1
XM3 net2 net2 gd gd sg13_lv_nmos w=1.4u l=0.6u ng=1
XR2 net1 gd gd rppd w=1e-6 l=1.70e-6 m=1 b=0
XM1 iref net2 net1 gd sg13_lv_nmos w=1.2u l=0.6u ng=1
XM2 vp net3 iref gd sg13_lv_nmos w=1u l=0.6u ng=1
XM7 vp vp net3 gd sg13_lv_nmos w=1u l=0.6u ng=1
XM8 gd gd gd gd sg13_lv_nmos w=0.4u l=0.6u ng=1
.ends

* expanding   symbol:  /foss/designs/CHIP-PLL/charge_pump/vbias.sym # of pins=3
** sym_path: /foss/designs/CHIP-PLL/charge_pump/vbias.sym
** sch_path: /foss/designs/CHIP-PLL/charge_pump/vbias.sch
.subckt vbias vp gd vbias
*.opin vbias
*.iopin gd
*.iopin vp
XM2 net2 net2 gd gd sg13_lv_nmos w=1.2u l=0.6u ng=1
XM3 vbias net1 net2 gd sg13_lv_nmos w=3.6u l=0.6u ng=1
XM13 net1 iref vp vp sg13_lv_pmos w=1.2u l=0.6u ng=1
XR2 net1 vbias sub! rppd w=1e-6 l=1.70e-6 m=1 b=0
x1 vp iref gd curr_source
.ends

.end
.param rsh_rppd = 509
.control
save v(vout) v(x1.bias)
op
print v(vout)
print v(x1.bias)
print @n.x1.xm3.nsg13_lv_pmos[ids]
print @n.x1.xm17.nsg13_lv_pmos[ids]
print @n.x1.xm18.nsg13_lv_nmos[ids]
quit
.endc
