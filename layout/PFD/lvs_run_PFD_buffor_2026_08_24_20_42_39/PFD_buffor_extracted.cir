* Extracted by KLayout with SG13CMOS5L LVS runset on : 24/08/2026 20:42

.SUBCKT PFD_buffor gnd in out vp
M$1 gnd in \$3 \$1 sg13_lv_nmos L=0.5u W=0.4u AS=0.163p AD=0.118p PS=2.08u
+ PD=1.48u rfmode=0
M$3 gnd \$3 out \$1 sg13_lv_nmos L=0.5u W=0.4u AS=0.118p AD=0.163p PS=1.48u
+ PD=2.08u rfmode=0
M$5 vp in \$3 \$6 sg13_lv_pmos L=0.5u W=0.4u AS=0.163p AD=0.118p PS=2.08u
+ PD=1.48u rfmode=0
M$7 vp \$3 out \$6 sg13_lv_pmos L=0.5u W=0.4u AS=0.118p AD=0.163p PS=1.48u
+ PD=2.08u rfmode=0
R$9 vp \$6 ntap1 A=0.6084p P=3.12u
R$10 gnd \$1 ptap1 A=0.6084p P=3.12u
.ENDS PFD_buffor
