* Extracted by KLayout with SG13CMOS5L LVS runset on : 31/08/2026 08:54

.SUBCKT PFD_cell_2 DOWN UP cRef cVco flip_flop_reset gnd post_nand pre_down
+ pre_up rst vp
X$22 gnd cVco pre_up vp flip_flop_reset vp PFD_flip_flop
X$35 gnd cRef pre_down vp flip_flop_reset vp PFD_flip_flop
X$36 gnd vp \$47 post_nand inverter_x4
X$37 \$47 \$49 vp gnd PFD_buffor
X$38 gnd vp \$24 pre_up inverter_x4
X$39 gnd vp DOWN \$27 inverter_x4
X$42 pre_down post_nand pre_up vp gnd NAND_2in_x2
X$43 gnd vp UP \$24 inverter_x4
X$44 gnd vp \$28 rst inverter_x4
X$45 gnd vp \$27 pre_down inverter_x4
X$46 vp gnd flip_flop_reset \$49 rst \$28 PFD_passgate
X$47 vp gnd flip_flop_reset vp \$28 rst PFD_passgate
M$1 gnd rst DOWN gnd sg13_lv_nmos L=0.15u W=0.45u AS=0.153p AD=0.153p PS=1.58u
+ PD=1.58u rfmode=0
M$2 UP rst gnd gnd sg13_lv_nmos L=0.15u W=0.45u AS=0.153p AD=0.153p PS=1.58u
+ PD=1.58u rfmode=0
.ENDS PFD_cell_2

.SUBCKT NAND_2in_x2 a y b VP GND
M$1 GND b \$10 GND sg13_lv_nmos L=0.13u W=0.6u AS=0.204p AD=0.114p PS=1.88u
+ PD=0.98u rfmode=0
M$2 \$10 a y GND sg13_lv_nmos L=0.13u W=0.6u AS=0.114p AD=0.204p PS=0.98u
+ PD=1.88u rfmode=0
M$3 VP b y VP sg13_lv_pmos L=0.13u W=0.3u AS=0.102p AD=0.057p PS=1.28u PD=0.68u
+ rfmode=0
M$4 y a VP VP sg13_lv_pmos L=0.13u W=0.3u AS=0.057p AD=0.102p PS=0.68u PD=1.28u
+ rfmode=0
.ENDS NAND_2in_x2

.SUBCKT PFD_buffor in out vp gnd
M$1 \$10 in gnd gnd sg13_lv_nmos L=0.5u W=0.4u AS=0.136p AD=0.076p PS=1.48u
+ PD=0.78u rfmode=0
M$2 gnd \$10 out gnd sg13_lv_nmos L=0.5u W=0.4u AS=0.076p AD=0.136p PS=0.78u
+ PD=1.48u rfmode=0
M$3 \$10 in vp vp sg13_lv_pmos L=0.5u W=0.4u AS=0.136p AD=0.076p PS=1.48u
+ PD=0.78u rfmode=0
M$4 vp \$10 out vp sg13_lv_pmos L=0.5u W=0.4u AS=0.076p AD=0.136p PS=0.78u
+ PD=1.48u rfmode=0
.ENDS PFD_buffor

.SUBCKT PFD_flip_flop gd clk Q D rst vp
X$17 vp gd D 1 clk clk_n PFD_passgate
X$19 gd vp clk_n clk inverter_x4
X$20 vp gd \$21 1 clk_n clk PFD_passgate
X$22 vp gd 2 3 clk_n clk PFD_passgate
X$23 gd vp NQ Q inverter_x8
X$24 gd vp Q rst 3 PFD_NOR
X$25 vp gd NQ 3 clk clk_n PFD_passgate
X$26 gd vp \$21 rst 2 PFD_NOR
X$27 gd vp 2 1 inverter_x8
.ENDS PFD_flip_flop

.SUBCKT inverter_x4 GND VP OUT IN
M$1 VP IN OUT VP sg13_lv_pmos L=0.13u W=0.6u AS=0.204p AD=0.204p PS=1.88u
+ PD=1.88u rfmode=0
M$2 GND IN OUT GND sg13_lv_nmos L=0.13u W=0.6u AS=0.204p AD=0.204p PS=1.88u
+ PD=1.88u rfmode=0
.ENDS inverter_x4

.SUBCKT PFD_NOR gd vp Out A B
M$1 Out B gd gd sg13_lv_nmos L=0.15u W=0.3u AS=0.102p AD=0.057p PS=1.28u
+ PD=0.68u rfmode=0
M$2 gd A Out gd sg13_lv_nmos L=0.15u W=0.3u AS=0.057p AD=0.102p PS=0.68u
+ PD=1.28u rfmode=0
M$3 vp B \$12 vp sg13_lv_pmos L=0.15u W=0.3u AS=0.102p AD=0.057p PS=1.28u
+ PD=0.68u rfmode=0
M$4 \$12 A Out vp sg13_lv_pmos L=0.15u W=0.3u AS=0.057p AD=0.102p PS=0.68u
+ PD=1.28u rfmode=0
.ENDS PFD_NOR

.SUBCKT PFD_passgate vp gnd A B in_p in_n
M$1 A in_n B gnd sg13_lv_nmos L=0.15u W=0.3u AS=0.102p AD=0.102p PS=1.28u
+ PD=1.28u rfmode=0
M$2 A in_p B vp sg13_lv_pmos L=0.15u W=0.3u AS=0.102p AD=0.102p PS=1.28u
+ PD=1.28u rfmode=0
.ENDS PFD_passgate

.SUBCKT inverter_x8 GND VP OUT IN
M$1 VP IN OUT VP sg13_lv_pmos L=0.13u W=1.2u AS=0.408p AD=0.408p PS=3.08u
+ PD=3.08u rfmode=0
M$2 GND IN OUT GND sg13_lv_nmos L=0.13u W=1.2u AS=0.408p AD=0.408p PS=3.08u
+ PD=3.08u rfmode=0
.ENDS inverter_x8
