* Extracted by KLayout with SG13CMOS5L LVS runset on : 19/08/2026 22:24

.SUBCKT charge_pump_cell
X$4 \$9 gd \$9 gd gd \$17 \$17 \$17 nmos$13
X$5 gd \$5 gd \$5 nmos$18
X$6 \$37 gd gd \$17 nmos$8
X$10 \$96 \$43 vp \$7 pmos
X$11 \$71 \$84 vp \$7 pmos
X$12 \$84 vp vp \$43 pmos$7
X$14 vp \$17 vp \$79 pmos$6
X$15 vp \$96 vp \$43 pmos
X$17 vp \$44 vp UP pmos$6
X$18 vp \$5 vp \$5 pmos$8
X$20 \$71 vout vp \$44 pmos$6
X$24 \$44 gd gd UP nmos$12
X$31 gd \$38 gd \$17 nmos$8
X$59 \$5 vout gd rst nmos$16
X$63 \$49 \$38 gd \$7 nmos$8
X$64 \$37 \$48 gd \$7 nmos$8
X$65 \$43 \$49 gd \$7 nmos$8
X$69 \$9 \$17 \$9 \$17 gd \$7 \$7 \$7 nmos$13
X$81 \$48 vout gd DN nmos
X$96 gd \$79 vp curr_source
X$97 gd vp \$7 vbias
.ENDS charge_pump_cell

.SUBCKT nmos$16 \$1 \$2 \$3 \$5
M$1 \$1 \$5 \$2 \$3 sg13_lv_nmos L=1.8u W=0.6u AS=0.204p AD=0.204p PS=1.88u
+ PD=1.88u rfmode=0
.ENDS nmos$16

.SUBCKT nmos$18 \$1 \$2 \$3 \$5
M$1 \$1 \$5 \$2 \$3 sg13_lv_nmos L=0.6u W=1.8u AS=0.612p AD=0.612p PS=4.28u
+ PD=4.28u rfmode=0
.ENDS nmos$18

.SUBCKT pmos$8 \$1 \$2 \$3 \$6
M$1 \$1 \$6 \$2 \$3 sg13_lv_pmos L=1.8u W=1.8u AS=0.612p AD=0.612p PS=4.28u
+ PD=4.28u rfmode=0
.ENDS pmos$8

.SUBCKT pmos$7 \$1 \$2 \$3 \$6
M$1 \$1 \$6 \$2 \$3 sg13_lv_pmos L=0.6u W=1.65u AS=0.561p AD=0.561p PS=3.98u
+ PD=3.98u rfmode=0
.ENDS pmos$7

.SUBCKT pmos \$1 \$2 \$3 \$6
M$1 \$1 \$6 \$2 \$3 sg13_lv_pmos L=0.6u W=1.6u AS=0.544p AD=0.544p PS=3.88u
+ PD=3.88u rfmode=0
.ENDS pmos

.SUBCKT vbias gd vp vbias
X$2 vbias \$9 gd rppd
X$3 gd gd gd gd nmos$14
X$4 gd \$8 gd \$8 nmos$4
X$7 \$8 vbias gd \$9 nmos$5
X$8 gd \$14 vp curr_source
X$16 vp vp vp vp pmos$4
X$18 vp \$9 vp \$14 pmos$2
.ENDS vbias

.SUBCKT nmos \$1 \$2 \$3 \$5
M$1 \$1 \$5 \$2 \$3 sg13_lv_nmos L=0.6u W=1u AS=0.34p AD=0.34p PS=2.68u
+ PD=2.68u rfmode=0
.ENDS nmos

.SUBCKT nmos$13 \$1 \$2 \$3 \$4 \$5 \$7 \$8 \$9
M$1 \$1 \$7 \$2 \$5 sg13_lv_nmos L=0.6u W=1.6u AS=0.544p AD=0.304p PS=3.88u
+ PD=1.98u rfmode=0
M$2 \$2 \$8 \$3 \$5 sg13_lv_nmos L=0.6u W=1.6u AS=0.304p AD=0.304p PS=1.98u
+ PD=1.98u rfmode=0
M$3 \$3 \$9 \$4 \$5 sg13_lv_nmos L=0.6u W=1.6u AS=0.304p AD=0.544p PS=1.98u
+ PD=3.88u rfmode=0
.ENDS nmos$13

.SUBCKT pmos$6 \$1 \$2 \$3 \$6
M$1 \$1 \$6 \$2 \$3 sg13_lv_pmos L=0.6u W=1u AS=0.34p AD=0.34p PS=2.68u
+ PD=2.68u rfmode=0
.ENDS pmos$6

.SUBCKT nmos$8 \$1 \$2 \$3 \$5
M$1 \$1 \$5 \$2 \$3 sg13_lv_nmos L=0.6u W=1.6u AS=0.544p AD=0.544p PS=3.88u
+ PD=3.88u rfmode=0
.ENDS nmos$8

.SUBCKT nmos$12 \$1 \$2 \$3 \$5
M$1 \$1 \$5 \$2 \$3 sg13_lv_nmos L=0.6u W=1u AS=0.34p AD=0.34p PS=2.68u
+ PD=2.68u rfmode=0
.ENDS nmos$12

.SUBCKT nmos$5 \$1 \$2 \$3 \$5
M$1 \$1 \$5 \$2 \$3 sg13_lv_nmos L=0.6u W=3.6u AS=1.224p AD=1.224p PS=7.88u
+ PD=7.88u rfmode=0
.ENDS nmos$5

.SUBCKT nmos$4 \$1 \$2 \$3 \$5
M$1 \$1 \$5 \$2 \$3 sg13_lv_nmos L=0.6u W=1.2u AS=0.408p AD=0.408p PS=3.08u
+ PD=3.08u rfmode=0
.ENDS nmos$4

.SUBCKT rppd \$1 \$2 \$3
R$1 \$1 \$2 \$3 rppd w=1u l=1.7u ps=0u b=0 m=1
.ENDS rppd

.SUBCKT pmos$2 \$1 \$2 \$3 \$6
M$1 \$1 \$6 \$2 \$3 sg13_lv_pmos L=0.6u W=1.2u AS=0.408p AD=0.408p PS=3.08u
+ PD=3.08u rfmode=0
.ENDS pmos$2

.SUBCKT nmos$14 \$1 \$2 \$3 \$5
M$1 \$1 \$5 \$2 \$3 sg13_lv_nmos L=0.6u W=1.86u AS=0.6324p AD=0.6324p PS=4.4u
+ PD=4.4u rfmode=0
.ENDS nmos$14

.SUBCKT pmos$4 \$1 \$2 \$3 \$6
M$1 \$1 \$6 \$2 \$3 sg13_lv_pmos L=0.6u W=1.375u AS=0.4675p AD=0.4675p PS=3.43u
+ PD=3.43u rfmode=0
.ENDS pmos$4

.SUBCKT curr_source gd iref vp
X$2 gd \$6 gd \$6 nmos$1
X$3 gd \$16 gd rppd$1
X$4 gd \$10 gd \$10 nmos$2
X$5 gd gd gd gd nmos$3
X$8 iref vp vp iref pmos$1
X$9 vp \$10 vp iref pmos$3
X$11 iref \$16 gd \$10 nmos$6
X$22 vp iref gd \$6 nmos$1
X$23 vp \$6 gd vp nmos$1
.ENDS curr_source

.SUBCKT rppd$1 \$1 \$2 \$3
R$1 \$1 \$2 \$3 rppd w=1u l=1.7u ps=0u b=0 m=1
.ENDS rppd$1

.SUBCKT nmos$3 \$1 \$2 \$3 \$5
M$1 \$1 \$5 \$2 \$3 sg13_lv_nmos L=0.6u W=0.4u AS=0.136p AD=0.136p PS=1.48u
+ PD=1.48u rfmode=0
.ENDS nmos$3

.SUBCKT nmos$1 \$1 \$2 \$3 \$5
M$1 \$1 \$5 \$2 \$3 sg13_lv_nmos L=0.6u W=1u AS=0.34p AD=0.34p PS=2.68u
+ PD=2.68u rfmode=0
.ENDS nmos$1

.SUBCKT nmos$2 \$1 \$2 \$3 \$5
M$1 \$1 \$5 \$2 \$3 sg13_lv_nmos L=0.6u W=1.4u AS=0.476p AD=0.476p PS=3.48u
+ PD=3.48u rfmode=0
.ENDS nmos$2

.SUBCKT pmos$3 \$1 \$2 \$3 \$6
M$1 \$1 \$6 \$2 \$3 sg13_lv_pmos L=0.6u W=1.2u AS=0.408p AD=0.408p PS=3.08u
+ PD=3.08u rfmode=0
.ENDS pmos$3

.SUBCKT pmos$1 \$1 \$2 \$3 \$6
M$1 \$1 \$6 \$2 \$3 sg13_lv_pmos L=0.6u W=1.4u AS=0.476p AD=0.476p PS=3.48u
+ PD=3.48u rfmode=0
.ENDS pmos$1

.SUBCKT nmos$6 \$1 \$2 \$3 \$5
M$1 \$1 \$5 \$2 \$3 sg13_lv_nmos L=0.6u W=1.2u AS=0.408p AD=0.408p PS=3.08u
+ PD=3.08u rfmode=0
.ENDS nmos$6
