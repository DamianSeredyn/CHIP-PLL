* Extracted by KLayout with SG13G2 LVS runset on : 09/07/2026 23:18

.SUBCKT vbias iref vbias gd vp
X$1 gd iref vp curr_source
M$1 vp iref \$4 vp sg13_lv_pmos L=0.6u W=1.2u AS=0.408p AD=0.408p PS=3.08u
+ PD=3.08u
R$2 vbias \$4 rppd w=1u l=1.7u ps=0 b=0 m=1
M$3 gd \$6 \$6 gd sg13_lv_nmos L=0.6u W=1.2u AS=0.408p AD=0.408p PS=3.08u
+ PD=3.08u
M$4 \$6 \$4 vbias gd sg13_lv_nmos L=0.6u W=3.6u AS=1.224p AD=1.224p PS=7.88u
+ PD=7.88u
.ENDS vbias

.SUBCKT curr_source gd iref vp
M$1 gd gd gd gd sg13_lv_nmos L=0.6u W=0.4u AS=0.136p AD=0.136p PS=1.48u PD=1.48u
M$2 vp iref \$7 vp sg13_lv_pmos L=0.6u W=1.2u AS=0.408p AD=0.408p PS=3.08u
+ PD=3.08u
M$3 iref iref vp vp sg13_lv_pmos L=0.6u W=1.4u AS=0.476p AD=0.476p PS=3.48u
+ PD=3.48u
M$4 iref \$7 \$18 gd sg13_lv_nmos L=0.6u W=1.2u AS=0.408p AD=0.408p PS=3.08u
+ PD=3.08u
M$5 gd \$7 \$7 gd sg13_lv_nmos L=0.6u W=1.4u AS=0.476p AD=0.476p PS=3.48u
+ PD=3.48u
M$6 gd \$5 \$5 gd sg13_lv_nmos L=0.6u W=1u AS=0.34p AD=0.34p PS=2.68u PD=2.68u
M$7 vp \$5 iref gd sg13_lv_nmos L=0.6u W=1u AS=0.34p AD=0.34p PS=2.68u PD=2.68u
M$8 vp vp \$5 gd sg13_lv_nmos L=0.6u W=1u AS=0.34p AD=0.34p PS=2.68u PD=2.68u
R$9 gd \$18 rppd w=1u l=1.7u ps=0 b=0 m=1
.ENDS curr_source
