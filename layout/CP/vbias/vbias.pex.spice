* PEX produced on Thu Aug 13 10:26:10 PM CEST 2026 using /foss/tools/sak/sak-pex.sh with m=2 and s=1
* NGSPICE file created from vbias.ext - technology: ihp-sg13g2

.subckt vbias gd vp vbias
X0 a_2101_2290# a_2101_2290# gd gd sg13_lv_nmos ad=0.34p pd=2.68u as=0.34p ps=2.68u w=1u l=0.6u
X1 vp vp vp vp sg13_lv_pmos ad=0.4675p pd=3.43u as=6.3675p ps=40.68u w=1.375u l=0.6u
X2 a_1505_2320# a_1505_2320# gd gd sg13_lv_nmos ad=0.408p pd=3.08u as=0.408p ps=3.08u w=1.2u l=0.6u
X3 vbias a_1803_2320# gd rppd l=1.7u w=1u
X4 gd a_2487_1964# gd rppd l=1.7u w=1u
X5 a_2399_2478# a_2399_2478# gd gd sg13_lv_nmos ad=0.476p pd=3.48u as=0.476p ps=3.48u w=1.4u l=0.6u
X6 a_2399_2478# curr_source_0.iref vp vp sg13_lv_pmos ad=0.408p pd=3.08u as=0.408p ps=3.08u w=1.2u l=0.6u
X7 gd gd gd gd sg13_lv_nmos ad=0.136p pd=1.48u as=7.0876p ps=55.54u w=0.4u l=0.6u
X8 gd gd gd gd sg13_lv_nmos ad=0.6324p pd=4.4u as=0 ps=0 w=1.86u l=0.6u
X9 a_2487_1964# a_2399_2478# curr_source_0.iref gd sg13_lv_nmos ad=0.408p pd=3.08u as=0.408p ps=3.08u w=1.2u l=0.6u
X10 a_1803_2320# curr_source_0.iref vp vp sg13_lv_pmos ad=0.408p pd=3.08u as=0.408p ps=3.08u w=1.2u l=0.6u
X11 curr_source_0.iref a_2101_2290# vp gd sg13_lv_nmos ad=0.34p pd=2.68u as=0.34p ps=2.68u w=1u l=0.6u
X12 a_2101_2290# vp vp gd sg13_lv_nmos ad=0.34p pd=2.68u as=0.34p ps=2.68u w=1u l=0.6u
X13 vp curr_source_0.iref curr_source_0.iref vp sg13_lv_pmos ad=0.476p pd=3.48u as=0.476p ps=3.48u w=1.4u l=0.6u
X14 a_1505_2320# a_1803_2320# vbias gd sg13_lv_nmos ad=1.224p pd=7.88u as=1.224p ps=7.88u w=3.6u l=0.6u
C0 curr_source_0.iref a_2487_1964# 0.09912f
C1 curr_source_0.iref a_1505_2320# 0.01534f
C2 vbias vp 0.0119f
C3 a_2399_2478# vp 0.12745f
C4 a_2487_1964# a_2399_2478# 0.05712f
C5 a_1505_2320# vbias 0.35831f
C6 a_1505_2320# vp 0.26048f
C7 curr_source_0.iref a_1803_2320# 0.21643f
C8 curr_source_0.iref a_2101_2290# 0.20908f
C9 vbias a_1501_1964# 0.12714f
C10 a_1803_2320# vbias 0.23594f
C11 a_1803_2320# vp 0.14436f
C12 a_2101_2290# vp 0.24215f
C13 a_2101_2290# a_2487_1964# 0.03881f
C14 a_1505_2320# a_1501_1964# 0.03158f
C15 a_2101_2290# a_1505_2320# 0.03339f
C16 a_1803_2320# a_1505_2320# 0.19129f
C17 a_2101_2290# a_2147_1964# 0.0268f
C18 curr_source_0.iref a_2399_2478# 0.16523f
C19 curr_source_0.iref vp 1.35334f
C20 a_1803_2320# a_1501_1964# 0.02412f
C21 a_1803_2320# a_2101_2290# 0.01389f
C22 vbias gd 1.25062f
C23 a_2487_1964# gd 1.3474f
C24 a_2101_2290# gd 0.22527f
C25 a_1505_2320# gd 0.40391f
.ends
