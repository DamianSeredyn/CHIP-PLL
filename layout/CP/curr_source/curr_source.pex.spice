* PEX produced on Thu Aug 13 05:16:35 PM CEST 2026 using /foss/tools/sak/sak-pex.sh with m=2 and s=1
* NGSPICE file created from curr_source.ext - technology: ihp-sg13g2

.subckt curr_source gd vp iref
X0 a_827_n219# a_739_295# iref gd sg13_lv_nmos ad=0.408p pd=3.08u as=0.408p ps=3.08u w=1.2u l=0.6u
X1 gd gd gd gd sg13_lv_nmos ad=0.136p pd=1.48u as=3.9722p ps=32.83u w=0.4u l=0.6u
X2 iref a_441_107# vp gd sg13_lv_nmos ad=0.34p pd=2.68u as=0.34p ps=2.68u w=1u l=0.6u
X3 gd a_827_n219# gd rppd l=1.7u w=1u
X4 a_441_107# vp vp gd sg13_lv_nmos ad=0.34p pd=2.68u as=0.34p ps=2.68u w=1u l=0.6u
X5 vp iref iref vp sg13_lv_pmos ad=0.476p pd=3.48u as=0.476p ps=3.48u w=1.4u l=0.6u
X6 a_441_107# a_441_107# gd gd sg13_lv_nmos ad=0.34p pd=2.68u as=0.34p ps=2.68u w=1u l=0.6u
X7 a_739_295# a_739_295# gd gd sg13_lv_nmos ad=0.476p pd=3.48u as=0.476p ps=3.48u w=1.4u l=0.6u
X8 a_739_295# iref vp vp sg13_lv_pmos ad=0.408p pd=3.08u as=0.408p ps=3.08u w=1.2u l=0.6u
C0 iref a_739_295# 0.16523f
C1 a_441_107# a_487_n219# 0.0268f
C2 a_441_107# vp 0.24215f
C3 a_441_107# a_827_n219# 0.03881f
C4 iref vp 0.98487f
C5 iref a_441_107# 0.20908f
C6 a_739_295# vp 0.12745f
C7 iref a_827_n219# 0.09912f
C8 a_739_295# a_827_n219# 0.05712f
C9 vp gd 0.7708f
C10 a_827_n219# gd 1.53713f
.ends
