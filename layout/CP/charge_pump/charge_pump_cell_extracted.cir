* Extracted by KLayout with SG13G2 LVS runset on : 15/07/2026 00:22

.SUBCKT charge_pump_cell gd DN UP vout vp
X$150 \$15 vp gd vbias
M$1 gd UP \$28 gd sg13_lv_nmos L=0.6u W=1u AS=0.34p AD=0.34p PS=2.68u PD=2.68u
M$2 \$41 DN vout gd sg13_lv_nmos L=0.6u W=1u AS=0.34p AD=0.34p PS=2.68u PD=2.68u
M$3 \$33 \$12 gd gd sg13_lv_nmos L=0.6u W=1.6u AS=0.544p AD=0.544p PS=3.88u
+ PD=3.88u
M$4 gd \$12 \$31 gd sg13_lv_nmos L=0.6u W=1.6u AS=0.544p AD=0.544p PS=3.88u
+ PD=3.88u
M$5 \$32 \$15 \$40 gd sg13_lv_nmos L=0.6u W=1.6u AS=0.544p AD=0.544p PS=3.88u
+ PD=3.88u
M$6 \$40 \$15 \$31 gd sg13_lv_nmos L=0.6u W=1.6u AS=0.544p AD=0.544p PS=3.88u
+ PD=3.88u
M$7 \$33 \$15 \$41 gd sg13_lv_nmos L=0.6u W=1.6u AS=0.544p AD=0.544p PS=3.88u
+ PD=3.88u
M$8 \$47 \$28 vout vp sg13_lv_pmos L=0.6u W=3u AS=0.795p AD=0.795p PS=5.56u
+ PD=5.56u
M$10 \$32 \$15 \$80 vp sg13_lv_pmos L=0.6u W=1.6u AS=0.544p AD=0.544p PS=3.88u
+ PD=3.88u
M$11 \$81 \$15 \$47 vp sg13_lv_pmos L=0.6u W=4.8u AS=1.152p AD=1.152p PS=7.84u
+ PD=7.84u
M$14 vp \$32 \$81 vp sg13_lv_pmos L=0.6u W=4.8u AS=1.092p AD=1.092p PS=7.82u
+ PD=7.82u
M$18 vp UP \$28 vp sg13_lv_pmos L=0.8u W=3u AS=0.795p AD=0.795p PS=5.56u
+ PD=5.56u
M$20 vp \$54 \$12 vp sg13_lv_pmos L=0.6u W=1u AS=0.34p AD=0.34p PS=2.68u
+ PD=2.68u
M$21 \$4 \$12 gd gd sg13_lv_nmos L=0.6u W=4.8u AS=1.152p AD=1.152p PS=7.84u
+ PD=7.84u
M$24 \$4 \$15 \$12 gd sg13_lv_nmos L=0.6u W=4.8u AS=1.152p AD=1.152p PS=7.84u
+ PD=7.84u
M$27 vp \$32 \$80 vp sg13_lv_pmos L=0.6u W=5.2u AS=1.183p AD=1.183p PS=8.32u
+ PD=8.32u
M$31 gd gd gd gd sg13_lv_nmos L=0.6u W=0.4u AS=0.136p AD=0.136p PS=1.48u
+ PD=1.48u
M$32 vp \$54 \$I303 vp sg13_lv_pmos L=0.6u W=1.2u AS=0.408p AD=0.408p PS=3.08u
+ PD=3.08u
M$33 \$54 \$54 vp vp sg13_lv_pmos L=0.6u W=1.4u AS=0.476p AD=0.476p PS=3.48u
+ PD=3.48u
M$34 \$54 \$I303 \$I304 gd sg13_lv_nmos L=0.6u W=1.2u AS=0.408p AD=0.408p
+ PS=3.08u PD=3.08u
M$35 gd \$I303 \$I303 gd sg13_lv_nmos L=0.6u W=1.4u AS=0.476p AD=0.476p
+ PS=3.48u PD=3.48u
M$36 gd \$I302 \$I302 gd sg13_lv_nmos L=0.6u W=1u AS=0.34p AD=0.34p PS=2.68u
+ PD=2.68u
M$37 vp \$I302 \$54 gd sg13_lv_nmos L=0.6u W=1u AS=0.34p AD=0.34p PS=2.68u
+ PD=2.68u
M$38 vp vp \$I302 gd sg13_lv_nmos L=0.6u W=1u AS=0.34p AD=0.34p PS=2.68u
+ PD=2.68u
R$39 gd \$I304 rppd w=1u l=1.7u ps=0 b=0 m=1
.ENDS charge_pump_cell

.SUBCKT vbias vbias vp gd
M$1 gd gd gd gd sg13_lv_nmos L=0.6u W=2.26u AS=0.7684p AD=0.7684p PS=5.88u
+ PD=5.88u
M$2 vp vp vp vp sg13_lv_pmos L=0.6u W=1.375u AS=0.4675p AD=0.4675p PS=3.43u
+ PD=3.43u
M$3 vp iref \$7 vp sg13_lv_pmos L=0.6u W=1.2u AS=0.408p AD=0.408p PS=3.08u
+ PD=3.08u
R$4 vbias \$7 rppd w=1u l=1.7u ps=0 b=0 m=1
M$5 gd \$5 \$5 gd sg13_lv_nmos L=0.6u W=1.2u AS=0.408p AD=0.408p PS=3.08u
+ PD=3.08u
M$6 gd \$I48 \$I48 gd sg13_lv_nmos L=0.6u W=1.4u AS=0.476p AD=0.476p PS=3.48u
+ PD=3.48u
M$7 vp vp \$I47 gd sg13_lv_nmos L=0.6u W=1u AS=0.34p AD=0.34p PS=2.68u PD=2.68u
M$8 vp \$I47 iref gd sg13_lv_nmos L=0.6u W=1u AS=0.34p AD=0.34p PS=2.68u
+ PD=2.68u
M$9 iref \$I48 \$I46 gd sg13_lv_nmos L=0.6u W=1.2u AS=0.408p AD=0.408p PS=3.08u
+ PD=3.08u
M$10 gd \$I47 \$I47 gd sg13_lv_nmos L=0.6u W=1u AS=0.34p AD=0.34p PS=2.68u
+ PD=2.68u
M$12 iref iref vp vp sg13_lv_pmos L=0.6u W=1.4u AS=0.476p AD=0.476p PS=3.48u
+ PD=3.48u
M$13 vp iref \$I48 vp sg13_lv_pmos L=0.6u W=1.2u AS=0.408p AD=0.408p PS=3.08u
+ PD=3.08u
R$14 gd \$I46 rppd w=1u l=1.7u ps=0 b=0 m=1
M$15 \$5 \$7 vbias gd sg13_lv_nmos L=0.6u W=3.6u AS=1.224p AD=1.224p PS=7.88u
+ PD=7.88u
.ENDS vbias
