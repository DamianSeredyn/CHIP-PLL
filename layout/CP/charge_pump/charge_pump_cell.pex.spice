* PEX produced on Sun Aug 23 09:44:47 PM CEST 2026 using /foss/tools/sak/sak-pex.sh with m=2 and s=1
* NGSPICE file created from charge_pump_cell.ext - technology: ihp-sg13g2

.subckt charge_pump_cell gd vp rst DN UP
X0 net8 net15 vp vp sg13_lv_pmos ad=0.544p pd=3.88u as=0.544p ps=3.88u w=1.6u l=0.6u
X1 net1 bias net2 gd sg13_lv_nmos ad=0.544p pd=3.88u as=0.304p ps=1.98u w=1.6u l=0.6u
X2 gd net1 net2 gd sg13_lv_nmos ad=0.544p pd=3.88u as=0.304p ps=1.98u w=1.6u l=0.6u
X3 a_193_4470# a_491_4470# bias gd sg13_lv_nmos ad=1.224p pd=7.88u as=1.224p ps=7.88u w=3.6u l=0.6u
X4 bias a_491_4470# gd rppd l=1.7u w=1u
X5 curr_source_0.iref a_1435_4440# vp gd sg13_lv_nmos ad=0.34p pd=2.68u as=0.34p ps=2.68u w=1u l=0.6u
X6 gd gd gd gd sg13_lv_nmos ad=0.544p pd=3.88u as=22.195p ps=0.14917m w=1.6u l=0.6u
X7 gd gd gd gd sg13_lv_nmos ad=0.6324p pd=4.4u as=0 ps=0 w=1.86u l=0.6u
X8 gd UP a_3659_5090# gd sg13_lv_nmos ad=0.34p pd=2.68u as=0.34p ps=2.68u w=1u l=0.6u
X9 a_491_4470# vbias_0.curr_source_0.iref vp vp sg13_lv_pmos ad=0.408p pd=3.08u as=0.408p ps=3.08u w=1.2u l=0.6u
X10 vp net15 net5 vp sg13_lv_pmos ad=0.561p pd=3.98u as=0.561p ps=3.98u w=1.65u l=0.6u
X11 net1 bias net2 gd sg13_lv_nmos ad=0.304p pd=1.98u as=0.544p ps=3.88u w=1.6u l=0.6u
X12 gd net1 net2 gd sg13_lv_nmos ad=0.304p pd=1.98u as=0.544p ps=3.88u w=1.6u l=0.6u
X13 net1 curr_source_0.iref vp vp sg13_lv_pmos ad=0.34p pd=2.68u as=0.34p ps=2.68u w=1u l=0.6u
X14 a_1733_4628# curr_source_0.iref vp vp sg13_lv_pmos ad=0.408p pd=3.08u as=0.408p ps=3.08u w=1.2u l=0.6u
X15 a_193_4470# a_193_4470# gd gd sg13_lv_nmos ad=0.408p pd=3.08u as=0.408p ps=3.08u w=1.2u l=0.6u
X16 a_1435_4440# vp vp gd sg13_lv_nmos ad=0.34p pd=2.68u as=0.34p ps=2.68u w=1u l=0.6u
X17 vout DN net13 gd sg13_lv_nmos ad=0.34p pd=2.68u as=0.34p ps=2.68u w=1u l=0.6u
X18 gd gd gd gd sg13_lv_nmos ad=0.136p pd=1.48u as=0 ps=0 w=0.4u l=0.6u
X19 vbias_0.curr_source_0.iref a_789_4440# vp gd sg13_lv_nmos ad=0.34p pd=2.68u as=0.34p ps=2.68u w=1u l=0.6u
X20 a_1821_4114# a_1733_4628# curr_source_0.iref gd sg13_lv_nmos ad=0.408p pd=3.08u as=0.408p ps=3.08u w=1.2u l=0.6u
X21 vp vp vp vp sg13_lv_pmos ad=0.4675p pd=3.43u as=21.7691p ps=0.11984m w=1.375u l=0.6u
X22 net5 bias a_2995_5126# vp sg13_lv_pmos ad=0.544p pd=3.88u as=0.544p ps=3.88u w=1.6u l=0.6u
X23 a_1087_4628# vbias_0.curr_source_0.iref vp vp sg13_lv_pmos ad=0.408p pd=3.08u as=0.408p ps=3.08u w=1.2u l=0.6u
X24 a_789_4440# vp vp gd sg13_lv_nmos ad=0.34p pd=2.68u as=0.34p ps=2.68u w=1u l=0.6u
X25 vp curr_source_0.iref curr_source_0.iref vp sg13_lv_pmos ad=0.476p pd=3.48u as=0.476p ps=3.48u w=1.4u l=0.6u
X26 a_3659_5090# UP vp vp sg13_lv_pmos ad=0.34p pd=2.68u as=0.34p ps=2.68u w=1u l=0.6u
X27 gd gd gd gd sg13_lv_nmos ad=0.136p pd=1.48u as=0 ps=0 w=0.4u l=0.6u
X28 a_1175_4114# a_1087_4628# vbias_0.curr_source_0.iref gd sg13_lv_nmos ad=0.408p pd=3.08u as=0.408p ps=3.08u w=1.2u l=0.6u
X29 a_1435_4440# a_1435_4440# gd gd sg13_lv_nmos ad=0.34p pd=2.68u as=0.34p ps=2.68u w=1u l=0.6u
X30 vtest vtest vp vp sg13_lv_pmos ad=0.612p pd=4.28u as=0.612p ps=4.28u w=1.8u l=1.8u
X31 a_1733_4628# a_1733_4628# gd gd sg13_lv_nmos ad=0.476p pd=3.48u as=0.476p ps=3.48u w=1.4u l=0.6u
X32 net13 bias a_3385_4115# gd sg13_lv_nmos ad=0.544p pd=3.88u as=0.544p ps=3.88u w=1.6u l=0.6u
X33 gd net1 a_3385_4115# gd sg13_lv_nmos ad=0.544p pd=3.88u as=0.544p ps=3.88u w=1.6u l=0.6u
X34 vp vbias_0.curr_source_0.iref vbias_0.curr_source_0.iref vp sg13_lv_pmos ad=0.476p pd=3.48u as=0.476p ps=3.48u w=1.4u l=0.6u
X35 vout a_3659_5090# a_2995_5126# vp sg13_lv_pmos ad=0.34p pd=2.68u as=0.34p ps=2.68u w=1u l=0.6u
X36 vtest rst vout vp sg13_lv_pmos ad=0.612p pd=4.28u as=0.612p ps=4.28u w=1.8u l=0.6u
X37 net2 bias net1 gd sg13_lv_nmos ad=0.304p pd=1.98u as=0.304p ps=1.98u w=1.6u l=0.6u
X38 a_789_4440# a_789_4440# gd gd sg13_lv_nmos ad=0.34p pd=2.68u as=0.34p ps=2.68u w=1u l=0.6u
X39 net2 net1 gd gd sg13_lv_nmos ad=0.304p pd=1.98u as=0.304p ps=1.98u w=1.6u l=0.6u
X40 net15 bias net8 vp sg13_lv_pmos ad=0.544p pd=3.88u as=0.544p ps=3.88u w=1.6u l=0.6u
X41 net10 bias net15 gd sg13_lv_nmos ad=0.544p pd=3.88u as=0.544p ps=3.88u w=1.6u l=0.6u
X42 a_1087_4628# a_1087_4628# gd gd sg13_lv_nmos ad=0.476p pd=3.48u as=0.476p ps=3.48u w=1.4u l=0.6u
X43 vtest vtest gd gd sg13_lv_nmos ad=0.204p pd=1.88u as=0.204p ps=1.88u w=0.6u l=1.8u
X44 net7 bias net10 gd sg13_lv_nmos ad=0.544p pd=3.88u as=0.544p ps=3.88u w=1.6u l=0.6u
X45 gd a_1175_4114# gd rppd l=1.7u w=1u
X46 net7 net1 gd gd sg13_lv_nmos ad=0.544p pd=3.88u as=0.544p ps=3.88u w=1.6u l=0.6u
X47 gd a_1821_4114# gd rppd l=1.7u w=1u
C0 net1 net15 0.25883f
C1 vtest vout 0.57856f
C2 vout net1 0.31494f
C3 bias a_3385_4115# 0.08532f
C4 a_2995_5126# net13 0.02064f
C5 bias a_1175_4114# 0.06536f
C6 vtest a_3659_5090# 0.02022f
C7 a_1821_4114# net2 0.029f
C8 a_1087_4628# vout 0.13485f
C9 vtest rst 0.13534f
C10 a_835_4114# a_789_4440# 0.03029f
C11 vout vbias_0.curr_source_0.iref 0.08426f
C12 net7 net1 0.16255f
C13 UP vout 0.16366f
C14 bias curr_source_0.iref 0.07099f
C15 a_1481_4114# bias 0.02654f
C16 vp a_789_4440# 0.19881f
C17 vtest net1 0.02818f
C18 a_193_4470# a_491_4470# 0.18526f
C19 vout net13 0.04642f
C20 bias a_2995_5126# 0.69304f
C21 a_1733_4628# bias 0.02173f
C22 vout a_491_4470# 0.03095f
C23 vbias_0.curr_source_0.iref a_1435_4440# 0.03845f
C24 UP a_3659_5090# 1.09022f
C25 DN vp 0.01234f
C26 net5 vp 0.1183f
C27 a_1175_4114# a_789_4440# 0.03845f
C28 a_3659_5090# net13 0.02113f
C29 bias net8 0.07477f
C30 a_193_4470# a_189_4114# 0.02542f
C31 UP rst 0.03141f
C32 bias a_193_4470# 0.45689f
C33 a_1821_4114# a_1175_4114# 0.01382f
C34 bias net15 0.91158f
C35 bias vout 0.34327f
C36 a_2995_5126# net10 0.03395f
C37 UP vtest 0.18973f
C38 a_1821_4114# curr_source_0.iref 0.18558f
C39 bias a_3659_5090# 0.04181f
C40 bias a_1435_4440# 0.05557f
C41 a_1733_4628# a_1821_4114# 0.05661f
C42 net10 net15 0.0759f
C43 a_1087_4628# vbias_0.curr_source_0.iref 0.19026f
C44 a_1175_4114# vp 0.05433f
C45 bias net7 0.0917f
C46 net5 a_2995_5126# 0.05657f
C47 bias net1 1.39744f
C48 a_193_4470# a_789_4440# 0.02955f
C49 vout a_789_4440# 0.12658f
C50 vbias_0.curr_source_0.iref a_491_4470# 0.23282f
C51 a_1821_4114# net15 0.01356f
C52 curr_source_0.iref vp 1.92579f
C53 a_1821_4114# vout 0.0113f
C54 a_2995_5126# vp 0.23404f
C55 a_1733_4628# vp 0.18617f
C56 DN vout 0.1295f
C57 net7 net10 0.05215f
C58 net2 net15 0.01606f
C59 net5 net15 0.084f
C60 a_1435_4440# a_789_4440# 0.01f
C61 net5 vout 0.04385f
C62 net10 net1 0.02038f
C63 a_1821_4114# a_1435_4440# 0.03845f
C64 bias vbias_0.curr_source_0.iref 0.01985f
C65 a_1175_4114# curr_source_0.iref 0.01786f
C66 bias UP 0.01091f
C67 net8 vp 0.12143f
C68 a_189_4114# a_491_4470# 0.02412f
C69 a_193_4470# vp 0.25345f
C70 bias net13 0.07893f
C71 DN a_3659_5090# 0.03587f
C72 vp net15 1.18063f
C73 bias a_491_4470# 0.26105f
C74 vout vp 0.767f
C75 a_1821_4114# net1 0.03015f
C76 a_1733_4628# curr_source_0.iref 0.32279f
C77 DN vtest 0.78535f
C78 a_3659_5090# vp 0.5541f
C79 bias a_189_4114# 0.14506f
C80 a_1435_4440# vp 0.19889f
C81 net2 net1 0.69877f
C82 a_1175_4114# vout 0.0113f
C83 a_1087_4628# a_789_4440# 0.01202f
C84 rst vp 0.21489f
C85 vbias_0.curr_source_0.iref a_789_4440# 0.30204f
C86 curr_source_0.iref net15 0.05219f
C87 vtest vp 1.0918f
C88 vp net1 0.22341f
C89 vout curr_source_0.iref 0.15463f
C90 a_3385_4115# net7 0.39335f
C91 a_789_4440# a_491_4470# 0.0153f
C92 a_1175_4114# a_1435_4440# 0.0721f
C93 a_2995_5126# net15 0.16684f
C94 vout a_2995_5126# 0.52051f
C95 a_3385_4115# net1 0.14877f
C96 a_1733_4628# vout 0.1359f
C97 DN UP 1.1817f
C98 bias net10 0.18589f
C99 DN net13 0.0409f
C100 curr_source_0.iref a_1435_4440# 0.30208f
C101 a_1481_4114# a_1435_4440# 0.03029f
C102 a_1087_4628# vp 0.26177f
C103 net8 net15 0.1375f
C104 a_3659_5090# a_2995_5126# 0.06098f
C105 net8 vout 0.04344f
C106 bias a_789_4440# 0.05752f
C107 a_1733_4628# a_1435_4440# 0.01202f
C108 vbias_0.curr_source_0.iref vp 1.56339f
C109 a_193_4470# vout 0.05495f
C110 vout net15 0.14466f
C111 UP vp 0.41036f
C112 bias a_1821_4114# 0.29254f
C113 curr_source_0.iref net1 0.06699f
C114 vp a_491_4470# 0.12813f
C115 DN bias 0.0101f
C116 a_1087_4628# a_1175_4114# 0.05661f
C117 a_2995_5126# net1 0.01454f
C118 a_1733_4628# net1 0.01096f
C119 bias net2 0.60993f
C120 net5 bias 0.11517f
C121 a_3385_4115# net13 0.05215f
C122 a_3659_5090# net15 0.01912f
C123 a_1175_4114# vbias_0.curr_source_0.iref 0.18554f
C124 a_3659_5090# vout 0.40993f
C125 vout a_1435_4440# 0.12658f
C126 bias a_835_4114# 0.02366f
C127 vout rst 0.13504f
C128 a_1087_4628# curr_source_0.iref 0.07172f
C129 net8 net1 0.08623f
C130 bias vp 0.60776f
C131 vbias_0.curr_source_0.iref curr_source_0.iref 0.10847f
C132 vp gd 1.00065f
C133 net13 gd 0.2366f
C134 a_3385_4115# gd 0.32022f
C135 net7 gd 0.09987f
C136 net10 gd 0.04973f
C137 net2 gd 3.90317f
C138 a_1821_4114# gd 1.32775f
C139 a_1175_4114# gd 1.54611f
C140 vout gd 1.09277f
C141 a_2995_5126# gd 0.30242f
C142 net8 gd 0.10994f
C143 a_491_4470# gd 0.4349f
.ends
