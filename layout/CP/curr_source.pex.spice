* PEX produced on Tue Jul  7 09:01:24 PM CEST 2026 using /foss/tools/sak/sak-pex.sh with m=3 and s=1
* NGSPICE file created from curr_source.ext - technology: ihp-sg13g2

.subckt curr_source gd vp iref
X0 a_827_n219.t0 a_739_295.t0 iref.t0 gd.t2 sg13_lv_nmos ad=0.408p pd=3.08u as=0.408p ps=3.08u w=1.2u l=0.6u
X1 iref.t3 a_441_107.t1 vp.t5 gd.t4 sg13_lv_nmos ad=0.34p pd=2.68u as=0.34p ps=2.68u w=1u l=0.6u
X2 gd.t8 a_827_n219.t1 gd.t7 rppd l=1.7u w=1u
X3 a_441_107.t0 vp.t0 vp.t1 gd.t3 sg13_lv_nmos ad=0.34p pd=2.68u as=0.34p ps=2.68u w=1u l=0.6u
X4 vp.t3 iref.t1 iref.t2 vp.t2 sg13_lv_pmos ad=0.476p pd=3.48u as=0.476p ps=3.48u w=1.4u l=0.6u
X5 a_441_107.t2 a_441_107.t1 gd.t6 gd.t5 sg13_lv_nmos ad=0.34p pd=2.68u as=0.34p ps=2.68u w=1u l=0.6u
X6 a_739_295.t1 a_739_295.t0 gd.t1 gd.t0 sg13_lv_nmos ad=0.476p pd=3.48u as=0.476p ps=3.48u w=1.4u l=0.6u
X7 a_739_295.t2 iref.t4 vp.t4 vp.t2 sg13_lv_pmos ad=0.408p pd=3.08u as=0.408p ps=3.08u w=1.2u l=0.6u
R0 iref.n1 iref.n0 29.9973
R1 iref.n1 iref.t4 24.0005
R2 iref.n2 iref.t1 15.0005
R3 iref.n3 iref.n2 9.0005
R4 iref.n0 iref.t3 6.20378
R5 iref.n0 iref.t0 5.60148
R6 iref.n2 iref.t2 5.01607
R7 iref.n3 iref.n1 0.6605
R8 iref iref.n3 0.4295
R9 vp.n5 vp.n4 18.7081
R10 vp.t4 vp.n2 17.0005
R11 vp.n7 vp.t4 17.0005
R12 vp.t4 vp.n6 17.0005
R13 vp.n9 vp.t3 17.0005
R14 vp.t3 vp.n3 17.0005
R15 vp.n5 vp.t0 15.0005
R16 vp.n1 vp.n0 8.5005
R17 vp.t3 vp.n8 8.48605
R18 vp.n4 vp.t5 6.61647
R19 vp.n4 vp.t1 5.56245
R20 vp.n13 vp.n12 2.80799
R21 vp.n12 vp.t2 2.126
R22 vp.n11 vp.n10 1.79696
R23 vp.t2 vp.n11 1.70305
R24 vp.n6 vp.n5 0.591097
R25 vp.n10 vp.n9 0.492627
R26 vp.n13 vp.n0 0.126463
R27 vp vp.n13 0.0782853
R28 vp.n7 vp.n3 0.0464701
R29 vp.n8 vp.n7 0.0448652
R30 vp.n10 vp.n0 0.04175
R31 vp.n9 vp.n2 0.0333358
R32 vp.n8 vp.n6 0.03091
R33 vp.n3 vp.n2 0.0284104
R34 vp.n11 vp.n1 0.00315277
R35 vp.n12 vp.n1 0.00175
R36 gd.t7 gd.t5 1489.71
R37 gd.t4 gd.t0 1102.88
R38 gd.n7 gd.t7 1037.04
R39 gd.t5 gd.t2 855.967
R40 gd.t0 gd.t3 164.609
R41 gd.t2 gd.t4 139.918
R42 gd.n10 gd.n9 17.0005
R43 gd.n12 gd.t1 8.71299
R44 gd.n11 gd.n10 8.59439
R45 gd.n7 gd.n6 8.501
R46 gd.n7 gd.n5 8.501
R47 gd.n7 gd.n4 8.501
R48 gd.n9 gd.n2 8.5005
R49 gd.n9 gd.n3 8.5005
R50 gd.n0 gd.t6 6.61656
R51 gd.n8 gd.n7 5.47466
R52 gd.n0 gd.t8 5.0005
R53 gd.n13 gd.n2 4.23547
R54 gd.n11 gd.n3 4.23547
R55 gd.n9 gd.n8 4.10551
R56 gd.n14 gd.n1 2.08773
R57 gd.n15 gd.n0 0.590078
R58 gd.n14 gd.n13 0.18804
R59 gd.n15 gd.n14 0.0992176
R60 gd.n8 gd.n1 0.0842818
R61 gd.n13 gd.n12 0.0815528
R62 gd.n12 gd.n11 0.0448861
R63 gd gd.n15 0.0115
R64 gd.n10 gd.n4 0.001
R65 gd.n5 gd.n3 0.001
R66 gd.n6 gd.n2 0.001
R67 gd.n6 gd.n1 0.001
R68 gd.n5 gd.n2 0.001
R69 gd.n4 gd.n3 0.001
R70 a_827_n219.t1 a_827_n219.t0 12.3336
R71 a_441_107.t2 a_441_107.n0 6.33368
R72 a_441_107.n0 a_441_107.t1 15.0005
R73 a_441_107.n0 a_441_107.t0 43.5164
R74 a_739_295.t2 a_739_295.n0 6.27106
R75 a_739_295.n0 a_739_295.t1 4.72314
R76 a_739_295.n0 a_739_295.t0 33.2091
C0 vp iref 0.91237f
C1 iref gd 0.82921f
C2 vp gd 0.49112f
C3 a_487_n219# gd 0.40132f $ **FLOATING
C4 a_739_295.t2 gd 0.03691f
C5 a_739_295.n0 gd 0.05529f
C6 a_739_295.t0 gd 0.15842f
C7 a_739_295.t1 gd 0.04298f
C8 a_441_107.t2 gd 0.04371f
C9 a_441_107.t1 gd 0.16905f
C10 a_441_107.n0 gd 0.10667f
C11 a_441_107.t0 gd 0.12328f
C12 a_827_n219.t1 gd 0.02788f
C13 a_827_n219.t0 gd 0.02533f
C14 vp.n0 gd 0.01868f
C15 vp.n1 gd 0.05062f
C16 vp.t5 gd 0.02265f
C17 vp.t1 gd 0.02068f
C18 vp.n4 gd 0.03246f
C19 vp.t0 gd 0.0407f
C20 vp.n5 gd 0.0144f
C21 vp.n6 gd 0.01797f
C22 vp.t4 gd 0.02482f
C23 vp.n7 gd 0.01372f
C24 vp.t3 gd 0.02896f
C25 vp.n9 gd 0.01318f
C26 vp.n10 gd 0.06156f
C27 vp.n11 gd 0.05141f
C28 vp.t2 gd 0.73242f
C29 vp.n12 gd 0.05076f
C30 vp.n13 gd 0.01453f
C31 iref.t0 gd 0.08734f
C32 iref.t3 gd 0.07685f
C33 iref.n0 gd 0.20559f
C34 iref.t4 gd 0.20165f
C35 iref.n1 gd 0.22529f
C36 iref.t1 gd 0.19443f
C37 iref.t2 gd 0.11024f
C38 iref.n2 gd 0.07355f
C39 iref.n3 gd 0.05294f
.ends
