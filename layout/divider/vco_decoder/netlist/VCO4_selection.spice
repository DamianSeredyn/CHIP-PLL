** sch_path: /foss/designs/CHIP-PLL/schematics/divider/schematics/VCO4_selection.sch
.subckt VCO4_selection gd VP 000000 000 000000_n after_001111_n 010 after_000011_n 011 001 after_000011 after_000111_n VCO4_11_sel
+ VCO4_5_sel
*.PININFO gd:B VP:B 000000_n:I VCO4_5_sel:O VCO4_11_sel:O 000:I 000000:I after_001111_n:I 010:I after_000011_n:I 011:I 001:I
*+ after_000011:I after_000111_n:I
x80 VP gd 000 net1 after_000011 after_001111_n NAND_3in
x82 VP gd 010 net2 after_000011_n 000000_n NAND_3in
x86 VP gd 001 net4 after_000111_n after_000011 NAND_3in
x91 net5 VCO4_11_sel VP gd inverter
x40 VP gd 001 net5 after_000011_n NAND_2in
x42 VP gd net1 VCO4_5_sel net4 net2 net3 NAND_4in
x46 VP gd 011 net3 000000 NAND_2in
.ends

* expanding   symbol:  NAND_3in.sym # of pins=6
** sym_path: /foss/designs/CHIP-PLL/schematics/divider/schematics/NAND_3in.sym
** sch_path: /foss/designs/CHIP-PLL/schematics/divider/schematics/NAND_3in.sch
.subckt NAND_3in VP GND a y b c
*.PININFO y:O GND:B a:I VP:B b:I c:I
MM1 y a net2 GND sg13_lv_nmos w=0.15u l=0.13u ng=1
MM3 net2 b net1 GND sg13_lv_nmos w=0.15u l=0.13u ng=1
MM4 net1 c GND GND sg13_lv_nmos w=0.15u l=0.13u ng=1
MM7 y c VP VP sg13_lv_pmos w=0.15u l=0.13u ng=1
MM2 y a VP VP sg13_lv_pmos w=0.15u l=0.13u ng=1
MM5 y b VP VP sg13_lv_pmos w=0.15u l=0.13u ng=1
.ends

* expanding   symbol:  inverter.sym # of pins=4
** sym_path: /foss/designs/CHIP-PLL/schematics/divider/schematics/inverter.sym
** sch_path: /foss/designs/CHIP-PLL/schematics/divider/schematics/inverter.sch
.subckt inverter IN OUT VP GND
*.PININFO IN:I VP:B OUT:O GND:B
MM1 OUT IN GND GND sg13_lv_nmos w=0.15u l=0.13u ng=1
MM2 OUT IN VP VP sg13_lv_pmos w=0.15u l=0.13u ng=1
.ends

* expanding   symbol:  NAND_2in.sym # of pins=5
** sym_path: /foss/designs/CHIP-PLL/schematics/divider/schematics/NAND_2in.sym
** sch_path: /foss/designs/CHIP-PLL/schematics/divider/schematics/NAND_2in.sch
.subckt NAND_2in VP GND a y b
*.PININFO y:O GND:B a:I VP:B b:I
MM1 y a net1 GND sg13_lv_nmos w=0.15u l=0.13u ng=1
MM3 net1 b GND GND sg13_lv_nmos w=0.15u l=0.13u ng=1
MM2 y b VP VP sg13_lv_pmos w=0.15u l=0.13u ng=1
MM4 y a VP VP sg13_lv_pmos w=0.15u l=0.13u ng=1
.ends

* expanding   symbol:  NAND_4in.sym # of pins=7
** sym_path: /foss/designs/CHIP-PLL/schematics/divider/schematics/NAND_4in.sym
** sch_path: /foss/designs/CHIP-PLL/schematics/divider/schematics/NAND_4in.sch
.subckt NAND_4in VP GND a y b c d
*.PININFO y:O GND:B a:I VP:B b:I c:I d:I
MM1 y a net2 GND sg13_lv_nmos w=0.15u l=0.13u ng=1
MM3 net3 c net1 GND sg13_lv_nmos w=0.15u l=0.13u ng=1
MM4 net1 d GND GND sg13_lv_nmos w=0.15u l=0.13u ng=1
MM7 y c VP VP sg13_lv_pmos w=0.15u l=0.13u ng=1
MM2 y a VP VP sg13_lv_pmos w=0.15u l=0.13u ng=1
MM5 y b VP VP sg13_lv_pmos w=0.15u l=0.13u ng=1
MM6 y d VP VP sg13_lv_pmos w=0.15u l=0.13u ng=1
MM8 net2 b net3 GND sg13_lv_nmos w=0.15u l=0.13u ng=1
.ends
