** sch_path: /foss/designs/CHIP-PLL/schematics/divider/schematics/test/VCO4_selection.sch
.subckt VCO4_selection gd VP f0 f1 VCO4_5_sel VCO4_11_sel 000 after_000111 after_001111_n 010 after_000011_n 011 001 after_000011
+ after_000111_n
*.PININFO gd:B VP:B f0:I f1:I VCO4_5_sel:O VCO4_11_sel:O 000:I after_000111:I after_001111_n:I 010:I after_000011_n:I 011:I 001:I
*+ after_000011:I after_000111_n:I
x80 VP gd 000 net1 after_000111 after_001111_n NAND_3in
x81 net1 net2 VP gd inverter
x82 VP gd 010 net3 after_000011_n f1 NAND_3in
x83 net3 net4 VP gd inverter
x84 VP gd 011 net5 net18 after_000011_n NAND_3in
x85 net5 net6 VP gd inverter
x86 VP gd 001 net7 net17 after_000011_n NAND_3in
x87 net7 net14 VP gd inverter
x88 VP gd 001 net8 after_000011 after_000111_n NAND_3in
x89 net8 net15 VP gd inverter
x90 VP gd 000 net9 after_000011 after_000111_n NAND_3in
x91 net9 VCO4_11_sel VP gd inverter
x92 VP gd net2 net10 net4 NOR_2in
x93 VP gd net10 VCO4_5_sel net11 NAND_2in
x94 VP gd net6 net11 net12 NOR_2in
x97 VP gd net14 net13 net15 NOR_2in
x98 net13 net12 VP gd inverter
x96 VP gd f0 net17 f1 XNOR
x99 net16 net18 VP gd inverter
x42 VP gd f0 net16 f1 XNOR
.ends

* expanding   symbol:  NAND_3in.sym # of pins=6
** sym_path: /foss/designs/CHIP-PLL/schematics/divider/schematics/NAND_3in.sym
** sch_path: /foss/designs/CHIP-PLL/schematics/divider/schematics/NAND_3in.sch
.subckt NAND_3in VP GND a y b c
*.PININFO y:O GND:B a:I VP:B b:I c:I
MM1 y a net2 GND sg13_lv_nmos w=0.15u l=0.13u ng=1
MM3 net2 b net1 GND sg13_lv_nmos w=0.15u l=0.13u ng=1
MM4 net1 c GND GND sg13_lv_nmos w=0.15u l=0.13u ng=1
MM7 y c VP VP sg13_lv_pmos w=0.15u l=0.13u ng=1
MM2 y a VP VP sg13_lv_pmos w=0.15u l=0.13u ng=1
MM5 y b VP VP sg13_lv_pmos w=0.15u l=0.13u ng=1
.ends

* expanding   symbol:  inverter.sym # of pins=4
** sym_path: /foss/designs/CHIP-PLL/schematics/divider/schematics/inverter.sym
** sch_path: /foss/designs/CHIP-PLL/schematics/divider/schematics/inverter.sch
.subckt inverter IN OUT VP GND
*.PININFO IN:I VP:B OUT:O GND:B
MM1 OUT IN GND GND sg13_lv_nmos w=0.15u l=0.13u ng=1
MM2 OUT IN VP VP sg13_lv_pmos w=0.15u l=0.13u ng=1
.ends

* expanding   symbol:  NOR_2in.sym # of pins=5
** sym_path: /foss/designs/CHIP-PLL/schematics/divider/schematics/NOR_2in.sym
** sch_path: /foss/designs/CHIP-PLL/schematics/divider/schematics/NOR_2in.sch
.subckt NOR_2in VP GND a y b
*.PININFO y:O GND:B a:I VP:B b:I
MM3 y a GND GND sg13_lv_nmos w=0.15u l=0.13u ng=1
MM2 y b net1 VP sg13_lv_pmos w=0.15u l=0.13u ng=1
MM4 net1 a VP VP sg13_lv_pmos w=0.15u l=0.13u ng=1
MM5 y b GND GND sg13_lv_nmos w=0.15u l=0.13u ng=1
.ends

* expanding   symbol:  NAND_2in.sym # of pins=5
** sym_path: /foss/designs/CHIP-PLL/schematics/divider/schematics/NAND_2in.sym
** sch_path: /foss/designs/CHIP-PLL/schematics/divider/schematics/NAND_2in.sch
.subckt NAND_2in VP GND a y b
*.PININFO y:O GND:B a:I VP:B b:I
MM1 y a net1 GND sg13_lv_nmos w=0.15u l=0.13u ng=1
MM3 net1 b GND GND sg13_lv_nmos w=0.15u l=0.13u ng=1
MM2 y b VP VP sg13_lv_pmos w=0.15u l=0.13u ng=1
MM4 y a VP VP sg13_lv_pmos w=0.15u l=0.13u ng=1
.ends

* expanding   symbol:  XNOR.sym # of pins=5
** sym_path: /foss/designs/CHIP-PLL/schematics/divider/schematics/XNOR.sym
** sch_path: /foss/designs/CHIP-PLL/schematics/divider/schematics/XNOR.sch
.subckt XNOR VP GND a y b
*.PININFO y:O GND:B a:I VP:B b:I
MM1 y a net1 GND sg13_lv_nmos w=0.15u l=0.13u ng=1
MM3 net1 _b GND GND sg13_lv_nmos w=0.15u l=0.13u ng=1
MM2 net2 a VP VP sg13_lv_pmos w=0.15u l=0.13u ng=1 m=4
MM4 net3 _a VP VP sg13_lv_pmos w=0.15u l=0.13u ng=1 m=4
MM5 y _a net4 GND sg13_lv_nmos w=0.15u l=0.13u ng=1
MM6 net4 b GND GND sg13_lv_nmos w=0.15u l=0.13u ng=1
MM7 y b net2 VP sg13_lv_pmos w=0.15u l=0.13u ng=1 m=4
MM8 y _b net3 VP sg13_lv_pmos w=0.15u l=0.13u ng=1 m=4
x1 a _a VP GND inverter
x2 b _b VP GND inverter
.ends
