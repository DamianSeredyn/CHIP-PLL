** sch_path: /foss/designs/CHIP-PLL/schematics/divider/schematics/inverter.sch
.subckt inverter IN OUT VP GND
*.PININFO IN:I VP:B OUT:O GND:B
MM1 OUT IN GND GND sg13_lv_nmos w=0.15u l=0.13u ng=1
MM2 OUT IN VP VP sg13_lv_pmos w=0.15u l=0.13u ng=1
.ends
