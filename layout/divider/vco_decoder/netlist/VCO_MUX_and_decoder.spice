** sch_path: /foss/designs/CHIP-PLL/schematics/divider/schematics/VCO_MUX_and_decoder.sch
.subckt VCO_MUX_and_decoder gd VP c0 c1 c2 f0 f1 f2 f3 f4 f5 VCO_in VCO2_in VCO3_in VCO4_in VCO5_in VCO2_11_sel VCO2_5_sel
+ VCO3_11_sel VCO3_5_sel VCO4_11_sel VCO4_5_sel out
*.PININFO gd:B VP:B c1:I c2:I f0:I f1:I c0:I VCO2_11_sel:O VCO2_5_sel:O VCO3_11_sel:O VCO3_5_sel:O VCO4_11_sel:O VCO4_5_sel:O f2:I
*+ f3:I f4:I f5:I VCO_in:I VCO2_in:I VCO3_in:I VCO4_in:I VCO5_in:I out:O
x1 gd VP c0 c1 c2 f0 f1 f2 f3 f4 f5 VCO_sel VCO2_11_sel VCO2_5_sel VCO3_11_sel VCO3_5_sel VCO4_11_sel VCO4_5_sel VCO5_11_sel
+ VCO_decoder
x2 gd VP VCO_in VCO2_in VCO3_in VCO4_in VCO5_in VCO_sel VCO2_sel VCO3_sel VCO4_sel VCO5_11_sel out VCO_MUX
x4 VP gd VCO2_11_sel net1 VCO2_5_sel NOR_2in
x5 net1 VCO2_sel VP gd inverter
x6 VP gd VCO3_11_sel net2 VCO3_5_sel NOR_2in
x7 net2 VCO3_sel VP gd inverter
x8 VP gd VCO4_11_sel net3 VCO4_5_sel NOR_2in
x9 net3 VCO4_sel VP gd inverter
.ends

* expanding   symbol:  VCO_decoder.sym # of pins=19
** sym_path: /foss/designs/CHIP-PLL/schematics/divider/schematics/VCO_decoder.sym
** sch_path: /foss/designs/CHIP-PLL/schematics/divider/schematics/VCO_decoder.sch
.subckt VCO_decoder gd VP c0 c1 c2 f0 f1 f2 f3 f4 f5 VCO_sel VCO2_11_sel VCO2_5_sel VCO3_11_sel VCO3_5_sel VCO4_11_sel VCO4_5_sel
+ VCO5_11_sel
*.PININFO gd:B VP:B c1:I c2:I f0:I f1:I c0:I VCO2_11_sel:O VCO2_5_sel:O VCO_sel:O VCO3_11_sel:O VCO3_5_sel:O VCO4_11_sel:O
*+ VCO4_5_sel:O VCO5_11_sel:O f2:I f3:I f4:I f5:I
x1001 gd VP c0 c1 c2 000 001 010 011 100 101 110 111 3bit_to_8_outs
x2 VP gd f2 net1 f3 NOR_2in
x3 VP gd f4 net2 f5 NOR_2in
x4 VP gd f3 after_000111_n f4 f5 NOR_3in
x5 VP gd f4 after_001111_n f5 NOR_2in
x6 VP gd net1 after_000011 net2 NAND_2in
x7 after_000111_n after_000111 VP gd inverter
x8 after_001111_n after_001111 VP gd inverter
x9 after_000011 after_000011_n VP gd inverter
x10 f5 f5_n VP gd inverter
x11 VP gd after_000111 net3 111 NAND_2in
x12 VP gd after_001111 net4 110 NAND_2in
x13 VP gd 101 net5 f5 NAND_2in
x14 VP gd net3 VCO_sel net4 net5 NAND_3in
x15 VP gd 110 net6 after_001111_n after_000111 NAND_3in
x16 VP gd 100 net8 f5 NAND_2in
x17 VP gd 101 net7 after_000111 f5_n NAND_3in
x18 VP gd 111 net9 after_000011 after_000111_n NAND_3in
x19 VP gd net6 VCO2_5_sel net7 net8 net9 NAND_4in
x20 VP gd net35 net14 net11 net10 NAND_3in
x24 VP gd 100 net10 after_000111 f5_n NAND_3in
x25 VP gd 011 net11 after_001111 NAND_2in
x28 VP gd 010 net35 f5 NAND_2in
x30 VP gd 111 net12 after_000011_n NAND_2in
x32 VP gd 101 net13 after_000011 after_000111_n NAND_3in
x43 VP gd 010 net42 000000 NAND_2in
x45 VP gd 011 net15 after_000111 after_001111_n NAND_3in
x47 VP gd 010 net16 after_000111 f5_n NAND_3in
x50 VP gd 001 net17 f5 NAND_2in
x52 VP gd 101 net39 after_000011_n NAND_2in
x53 VP gd 100 net18 000000_n after_000111_n NAND_3in
x63 VP gd 011 net20 after_000111_n 000000_n NAND_3in
x70 VP gd 001 net21 after_000111 f5_n NAND_3in
x73 VP gd 000 net22 after_001111 NAND_2in
x75 VP gd 100 net23 000000 NAND_2in
x76 VP gd 010 net24 after_000011 after_000111_n NAND_3in
x80 VP gd 000 net25 after_000011 after_001111_n NAND_3in
x82 VP gd 010 net26 after_000011_n 000000_n NAND_3in
x86 VP gd 001 net28 after_000111_n after_000011 NAND_3in
x91 net29 VCO4_11_sel VP gd inverter
x106 VP gd net30 VCO5_11_sel net42 NAND_2in
x26 VP gd 110 net36 after_000111_n 000000_n NAND_3in
x1 VP gd f2 net31 f3 NOR_2in
x27 VP gd f4 net32 f5 NOR_2in
x29 VP gd f1 net33 f0 NOR_2in
x31 VP gd net31 000000_n net32 net33 NAND_3in
x33 000000_n 000000 VP gd inverter
x21 VP gd net34 VCO2_11_sel net13 net36 net12 NAND_4in
x22 net14 net34 VP gd inverter
x23 VP gd net17 net37 net16 net15 NAND_3in
x34 VP gd net38 VCO3_5_sel net18 net39 net19 NAND_4in
x35 net37 net38 VP gd inverter
x36 VP gd 110 net19 000000 NAND_2in
x38 VP gd net41 VCO3_11_sel net24 net20 net23 NAND_4in
x39 net40 net41 VP gd inverter
x37 VP gd net22 net40 net21 NAND_2in
x40 VP gd 001 net29 after_000011_n NAND_2in
x42 VP gd net25 VCO4_5_sel net28 net26 net27 NAND_4in
x46 VP gd 011 net27 000000 NAND_2in
x41 VP gd 000 net30 after_000011_n NAND_2in
.ends

* expanding   symbol:  VCO_MUX.sym # of pins=13
** sym_path: /foss/designs/CHIP-PLL/schematics/divider/schematics/VCO_MUX.sym
** sch_path: /foss/designs/CHIP-PLL/schematics/divider/schematics/VCO_MUX.sch
.subckt VCO_MUX gd VP VCO_in VCO2_in VCO3_in VCO4_in VCO5_in VCO_sel VCO2_sel VCO3_sel VCO4_sel VCO5_sel out
*.PININFO gd:B VP:B VCO2_in:I VCO3_in:I VCO4_in:I VCO5_in:I out:O VCO_in:I VCO2_sel:I VCO3_sel:I VCO_sel:I VCO4_sel:I VCO5_sel:I
x1 net1 VP gd VCO_sel VCO_in out passgate_scaled
x2 VCO_sel net1 VP gd inverter
x3 net2 VP gd VCO2_sel VCO2_in out passgate_scaled
x4 VCO2_sel net2 VP gd inverter
x5 net3 VP gd VCO3_sel VCO3_in out passgate_scaled
x6 VCO3_sel net3 VP gd inverter
x7 net4 VP gd VCO4_sel VCO4_in out passgate_scaled
x8 VCO4_sel net4 VP gd inverter
x9 net5 VP gd VCO5_sel VCO5_in out passgate_scaled
x10 VCO5_sel net5 VP gd inverter
.ends

* expanding   symbol:  NOR_2in.sym # of pins=5
** sym_path: /foss/designs/CHIP-PLL/schematics/divider/schematics/NOR_2in.sym
** sch_path: /foss/designs/CHIP-PLL/schematics/divider/schematics/NOR_2in.sch
.subckt NOR_2in VP GND a y b
*.PININFO y:O GND:B a:I VP:B b:I
MM3 y a GND GND sg13_lv_nmos w=0.15u l=0.13u ng=1
MM2 y b net1 VP sg13_lv_pmos w=0.15u l=0.13u ng=1
MM4 net1 a VP VP sg13_lv_pmos w=0.15u l=0.13u ng=1
MM5 y b GND GND sg13_lv_nmos w=0.15u l=0.13u ng=1
.ends

* expanding   symbol:  inverter.sym # of pins=4
** sym_path: /foss/designs/CHIP-PLL/schematics/divider/schematics/inverter.sym
** sch_path: /foss/designs/CHIP-PLL/schematics/divider/schematics/inverter.sch
.subckt inverter IN OUT VP GND
*.PININFO IN:I VP:B OUT:O GND:B
MM1 OUT IN GND GND sg13_lv_nmos w=0.15u l=0.13u ng=1
MM2 OUT IN VP VP sg13_lv_pmos w=0.15u l=0.13u ng=1
.ends

* expanding   symbol:  3bit_to_8_outs.sym # of pins=13
** sym_path: /foss/designs/CHIP-PLL/schematics/divider/schematics/3bit_to_8_outs.sym
** sch_path: /foss/designs/CHIP-PLL/schematics/divider/schematics/3bit_to_8_outs.sch
.subckt 3bit_to_8_outs gd VP c0 c1 c2 coarse_0 coarse_1 coarse_2 coarse_3 coarse_4 coarse_5 coarse_6 coarse_7
*.PININFO gd:B VP:B c1:I c2:I c0:I coarse_1:O coarse_2:O coarse_0:O coarse_3:O coarse_4:O coarse_5:O coarse_6:O coarse_7:O
x1 c0 c0_n VP gd inverter
x2 c1 c1_n VP gd inverter
x3 c2 c2_n VP gd inverter
x4 VP gd c0_n net1 c1_n c2_n NAND_3in
x5 VP gd c0 net2 c1_n c2_n NAND_3in
x12 net1 coarse_0 VP gd inverter
x13 net2 coarse_1 VP gd inverter
x14 VP gd c0_n net3 c1 c2_n NAND_3in
x15 net3 coarse_2 VP gd inverter
x6 VP gd c0 net4 c1 c2_n NAND_3in
x16 net4 coarse_3 VP gd inverter
x7 VP gd c0_n net5 c1_n c2 NAND_3in
x17 VP gd c0 net6 c1_n c2 NAND_3in
x18 net5 coarse_4 VP gd inverter
x19 net6 coarse_5 VP gd inverter
x20 VP gd c0_n net7 c1 c2 NAND_3in
x21 net7 coarse_6 VP gd inverter
x22 VP gd c0 net8 c1 c2 NAND_3in
x23 net8 coarse_7 VP gd inverter
.ends

* expanding   symbol:  NOR_3in.sym # of pins=6
** sym_path: /foss/designs/CHIP-PLL/schematics/divider/schematics/NOR_3in.sym
** sch_path: /foss/designs/CHIP-PLL/schematics/divider/schematics/NOR_3in.sch
.subckt NOR_3in VP GND a y b c
*.PININFO y:O GND:B a:I VP:B b:I c:I
MM3 y a GND GND sg13_lv_nmos w=0.15u l=0.13u ng=1
MM2 y b net2 VP sg13_lv_pmos w=0.15u l=0.13u ng=1
MM4 net1 a VP VP sg13_lv_pmos w=0.15u l=0.13u ng=1
MM5 y b GND GND sg13_lv_nmos w=0.15u l=0.13u ng=1
MM1 y c GND GND sg13_lv_nmos w=0.15u l=0.13u ng=1
MM6 net2 c net1 VP sg13_lv_pmos w=0.15u l=0.13u ng=1
.ends

* expanding   symbol:  NAND_2in.sym # of pins=5
** sym_path: /foss/designs/CHIP-PLL/schematics/divider/schematics/NAND_2in.sym
** sch_path: /foss/designs/CHIP-PLL/schematics/divider/schematics/NAND_2in.sch
.subckt NAND_2in VP GND a y b
*.PININFO y:O GND:B a:I VP:B b:I
MM1 y a net1 GND sg13_lv_nmos w=0.15u l=0.13u ng=1
MM3 net1 b GND GND sg13_lv_nmos w=0.15u l=0.13u ng=1
MM2 y b VP VP sg13_lv_pmos w=0.15u l=0.13u ng=1
MM4 y a VP VP sg13_lv_pmos w=0.15u l=0.13u ng=1
.ends

* expanding   symbol:  NAND_3in.sym # of pins=6
** sym_path: /foss/designs/CHIP-PLL/schematics/divider/schematics/NAND_3in.sym
** sch_path: /foss/designs/CHIP-PLL/schematics/divider/schematics/NAND_3in.sch
.subckt NAND_3in VP GND a y b c
*.PININFO y:O GND:B a:I VP:B b:I c:I
MM1 y a net2 GND sg13_lv_nmos w=0.15u l=0.13u ng=1
MM3 net2 b net1 GND sg13_lv_nmos w=0.15u l=0.13u ng=1
MM4 net1 c GND GND sg13_lv_nmos w=0.15u l=0.13u ng=1
MM7 y c VP VP sg13_lv_pmos w=0.15u l=0.13u ng=1
MM2 y a VP VP sg13_lv_pmos w=0.15u l=0.13u ng=1
MM5 y b VP VP sg13_lv_pmos w=0.15u l=0.13u ng=1
.ends

* expanding   symbol:  NAND_4in.sym # of pins=7
** sym_path: /foss/designs/CHIP-PLL/schematics/divider/schematics/NAND_4in.sym
** sch_path: /foss/designs/CHIP-PLL/schematics/divider/schematics/NAND_4in.sch
.subckt NAND_4in VP GND a y b c d
*.PININFO y:O GND:B a:I VP:B b:I c:I d:I
MM1 y a net2 GND sg13_lv_nmos w=0.15u l=0.13u ng=1
MM3 net3 c net1 GND sg13_lv_nmos w=0.15u l=0.13u ng=1
MM4 net1 d GND GND sg13_lv_nmos w=0.15u l=0.13u ng=1
MM7 y c VP VP sg13_lv_pmos w=0.15u l=0.13u ng=1
MM2 y a VP VP sg13_lv_pmos w=0.15u l=0.13u ng=1
MM5 y b VP VP sg13_lv_pmos w=0.15u l=0.13u ng=1
MM6 y d VP VP sg13_lv_pmos w=0.15u l=0.13u ng=1
MM8 net2 b net3 GND sg13_lv_nmos w=0.15u l=0.13u ng=1
.ends

* expanding   symbol:  passgate_scaled.sym # of pins=6
** sym_path: /foss/designs/CHIP-PLL/schematics/divider/schematics/passgate_scaled.sym
** sch_path: /foss/designs/CHIP-PLL/schematics/divider/schematics/passgate_scaled.sch
.subckt passgate_scaled en_ VP GND en IO OI
*.PININFO OI:B IO:B VP:B GND:B en_:I en:I
MM1 IO en OI GND sg13_lv_nmos w=0.15u l=0.13u ng=1
MM2 IO en_ OI VP sg13_lv_pmos w=0.15u l=0.13u ng=1
.ends
