** sch_path: /foss/designs/CHIP-PLL/schematics/divider/schematics/3bit_to_8_outs.sch
.subckt 3bit_to_8_outs gd VP c0 c1 c2 coarse_0 coarse_1 coarse_2 coarse_3 coarse_4 coarse_5 coarse_6 coarse_7
*.PININFO gd:B VP:B c1:I c2:I c0:I coarse_1:O coarse_2:O coarse_0:O coarse_3:O coarse_4:O coarse_5:O coarse_6:O coarse_7:O
x1 c0 c0_n VP gd inverter
x2 c1 c1_n VP gd inverter
x3 c2 c2_n VP gd inverter
x4 VP gd c0_n net1 c1_n c2_n NAND_3in
x5 VP gd c0 net2 c1_n c2_n NAND_3in
x12 net1 coarse_0 VP gd inverter
x13 net2 coarse_1 VP gd inverter
x14 VP gd c0_n net3 c1 c2_n NAND_3in
x15 net3 coarse_2 VP gd inverter
x6 VP gd c0 net4 c1 c2_n NAND_3in
x16 net4 coarse_3 VP gd inverter
x7 VP gd c0_n net5 c1_n c2 NAND_3in
x17 VP gd c0 net6 c1_n c2 NAND_3in
x18 net5 coarse_4 VP gd inverter
x19 net6 coarse_5 VP gd inverter
x20 VP gd c0_n net7 c1 c2 NAND_3in
x21 net7 coarse_6 VP gd inverter
x22 VP gd c0 net8 c1 c2 NAND_3in
x23 net8 coarse_7 VP gd inverter
.ends

* expanding   symbol:  inverter.sym # of pins=4
** sym_path: /foss/designs/CHIP-PLL/schematics/divider/schematics/inverter.sym
** sch_path: /foss/designs/CHIP-PLL/schematics/divider/schematics/inverter.sch
.subckt inverter IN OUT VP GND
*.PININFO IN:I VP:B OUT:O GND:B
MM1 OUT IN GND GND sg13_lv_nmos w=0.15u l=0.13u ng=1
MM2 OUT IN VP VP sg13_lv_pmos w=0.15u l=0.13u ng=1
.ends

* expanding   symbol:  NAND_3in.sym # of pins=6
** sym_path: /foss/designs/CHIP-PLL/schematics/divider/schematics/NAND_3in.sym
** sch_path: /foss/designs/CHIP-PLL/schematics/divider/schematics/NAND_3in.sch
.subckt NAND_3in VP GND a y b c
*.PININFO y:O GND:B a:I VP:B b:I c:I
MM1 y a net2 GND sg13_lv_nmos w=0.15u l=0.13u ng=1
MM3 net2 b net1 GND sg13_lv_nmos w=0.15u l=0.13u ng=1
MM4 net1 c GND GND sg13_lv_nmos w=0.15u l=0.13u ng=1
MM7 y c VP VP sg13_lv_pmos w=0.15u l=0.13u ng=1
MM2 y a VP VP sg13_lv_pmos w=0.15u l=0.13u ng=1
MM5 y b VP VP sg13_lv_pmos w=0.15u l=0.13u ng=1
.ends
