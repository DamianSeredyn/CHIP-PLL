** sch_path: /foss/designs/CHIP-PLL/schematics/divider/schematics/3bit_to_8_outs.sch
.subckt 3bit_to_8_outs gd VP c0 c1 c2 coarse_0 coarse_1 coarse_2 coarse_3 coarse_4 coarse_5 coarse_6 coarse_7
*.PININFO gd:B VP:B c1:I c2:I c0:I coarse_1:O coarse_2:O coarse_0:O coarse_3:O coarse_4:O coarse_5:O coarse_6:O coarse_7:O
x1 c0 c0_n VP gd inverter_dek
x4 VP gd c0_n net1 c1_n c2_n NAND_3in_dek
x2 c1 c1_n VP gd inverter_dek
x3 c2 c2_n VP gd inverter_dek
x8 net4 coarse_3 VP gd inverter_dek
x9 net3 coarse_2 VP gd inverter_dek
x10 net2 coarse_1 VP gd inverter_dek
x11 net1 coarse_0 VP gd inverter_dek
x12 net5 coarse_4 VP gd inverter_dek
x13 net6 coarse_5 VP gd inverter_dek
x15 net7 coarse_6 VP gd inverter_dek
x16 net8 coarse_7 VP gd inverter_dek
x5 VP gd c0 net2 c1_n c2_n NAND_3in_dek
x6 VP gd c0_n net3 c1 c2_n NAND_3in_dek
x7 VP gd c0 net4 c1 c2_n NAND_3in_dek
x14 VP gd c0 net8 c1 c2 NAND_3in_dek
x17 VP gd c0_n net7 c1 c2 NAND_3in_dek
x18 VP gd c0 net6 c1_n c2 NAND_3in_dek
x19 VP gd c0_n net5 c1_n c2 NAND_3in_dek
.ends

* expanding   symbol:  inverter_dek.sym # of pins=4
** sym_path: /foss/designs/CHIP-PLL/schematics/divider/schematics/inverter_dek.sym
** sch_path: /foss/designs/CHIP-PLL/schematics/divider/schematics/inverter_dek.sch
.subckt inverter_dek IN OUT VP GND
*.PININFO IN:I VP:B OUT:O GND:B
MM1 OUT IN GND GND sg13_lv_nmos w=0.15u l=0.13u ng=1
MM2 OUT IN VP VP sg13_lv_pmos w=0.15u l=0.13u ng=1
.ends

* expanding   symbol:  NAND_3in_dek.sym # of pins=6
** sym_path: /foss/designs/CHIP-PLL/schematics/divider/schematics/NAND_3in_dek.sym
** sch_path: /foss/designs/CHIP-PLL/schematics/divider/schematics/NAND_3in_dek.sch
.subckt NAND_3in_dek VP GND a y b c
*.PININFO y:O GND:B a:I VP:B b:I c:I
MM1 y a net2 GND sg13_lv_nmos w=0.15u l=0.13u ng=1
MM3 net2 b net1 GND sg13_lv_nmos w=0.15u l=0.13u ng=1
MM4 net1 c GND GND sg13_lv_nmos w=0.15u l=0.13u ng=1
MM7 y c VP VP sg13_lv_pmos w=0.15u l=0.13u ng=1
MM2 y a VP VP sg13_lv_pmos w=0.15u l=0.13u ng=1
MM5 y b VP VP sg13_lv_pmos w=0.15u l=0.13u ng=1
.ends
