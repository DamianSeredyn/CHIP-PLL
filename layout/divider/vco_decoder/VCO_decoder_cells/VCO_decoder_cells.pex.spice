* PEX produced on Sun Sep 20 09:12:16 PM CEST 2026 using /foss/tools/sak/sak-pex.sh with m=2 and s=1
* NGSPICE file created from VCO_decoder_cells.ext - technology: ihp-sg13g2

.subckt VCO_decoder_cells c0 c1 c2 f3 f4 f5 f1 f2 f0 VCO_sel VCO4_11_sel VCO4_5_sel
+ VCO3_5_sel VCO3_11_sel VCO2_11_sel VCO2_5_sel VCO5_11_sel gd vp
X0 VCO4_selection_0.NAND_3in_1.y row_section_decoding_0.after_000111_n vp vp sg13_lv_pmos ad=0.1005p pd=1.34u as=0.1005p ps=1.34u w=0.15u l=0.13u
X1 vp 3bit_to_8_outs_0.coarse_0 VCO3_selection_0.inverter_4.in vp sg13_lv_pmos ad=0.1005p pd=1.34u as=0.1005p ps=1.34u w=0.15u l=0.13u
X2 a_33476_38120# VCO3_selection_0.NAND_3in_0.c gd gd sg13_lv_nmos ad=0.1005p pd=1.34u as=0.1005p ps=1.34u w=0.15u l=0.13u
X3 VCO3_selection_0.NAND_3in_7.y VCO3_selection_0.NAND_3in_7.c vp vp sg13_lv_pmos ad=0.1005p pd=1.34u as=0.1005p ps=1.34u w=0.15u l=0.13u
X4 vp row_section_decoding_0.after_000011 VCO2_selection_0.NAND_3in_7.y vp sg13_lv_pmos ad=0.1005p pd=1.34u as=0.1005p ps=1.34u w=0.15u l=0.13u
X5 vp row_section_decoding_0.after_000011 VCO2_selection_0.NAND_3in_4.y vp sg13_lv_pmos ad=0.1005p pd=1.34u as=0.1005p ps=1.34u w=0.15u l=0.13u
X6 a_32306_26498# c1 a_32090_26498# gd sg13_lv_nmos ad=0.1005p pd=1.34u as=0.1005p ps=1.34u w=0.15u l=0.13u
X7 VCO3_selection_0.inverter_0.out VCO3_selection_0.NAND_3in_7.y vp vp sg13_lv_pmos ad=0.1005p pd=1.34u as=0.1005p ps=1.34u w=0.15u l=0.13u
X8 VCO3_5_sel VCO3_selection_0.NAND_3in_6.a a_33561_40066# gd sg13_lv_nmos ad=0.1005p pd=1.34u as=0.1005p ps=1.34u w=0.15u l=0.13u
X9 VCO3_selection_0.NAND_3in_5.y 3bit_to_8_outs_0.coarse_3 vp vp sg13_lv_pmos ad=0.1005p pd=1.34u as=0.1005p ps=1.34u w=0.15u l=0.13u
X10 row_section_decoding_0.after_000111_n f3 gd gd sg13_lv_nmos ad=0.1005p pd=1.34u as=0.1005p ps=1.34u w=0.15u l=0.13u
X11 VCO5_selection_0.NAND_2in_0.b row_section_decoding_0.f1_n vp vp sg13_lv_pmos ad=0.1005p pd=1.34u as=0.1005p ps=1.34u w=0.15u l=0.13u
X12 a_31572_40540# row_section_decoding_0.after_000111_n gd gd sg13_lv_nmos ad=0.1005p pd=1.34u as=0.1005p ps=1.34u w=0.15u l=0.13u
X13 a_32090_25172# 3bit_to_8_outs_0.c0_n 3bit_to_8_outs_0.inverter_6.in gd sg13_lv_nmos ad=0.1005p pd=1.34u as=0.1005p ps=1.34u w=0.15u l=0.13u
X14 a_31060_46420# row_section_decoding_0.after_000011_n gd gd sg13_lv_nmos ad=0.1005p pd=1.34u as=0.1005p ps=1.34u w=0.15u l=0.13u
X15 a_32468_42496# row_section_decoding_0.after_000111 a_32252_42496# gd sg13_lv_nmos ad=0.1005p pd=1.34u as=0.1005p ps=1.34u w=0.15u l=0.13u
X16 a_32090_26816# 3bit_to_8_outs_0.c0_n 3bit_to_8_outs_0.inverter_8.in gd sg13_lv_nmos ad=0.1005p pd=1.34u as=0.1005p ps=1.34u w=0.15u l=0.13u
X17 VCO2_5_sel VCO2_selection_0.NAND_4in_0.a a_33260_32714# gd sg13_lv_nmos ad=0.1005p pd=1.34u as=0.1005p ps=1.34u w=0.15u l=0.13u
X18 VCO2_selection_0.NAND_4in_0.a row_section_decoding_0.after_000111 vp vp sg13_lv_pmos ad=0.1005p pd=1.34u as=0.1005p ps=1.34u w=0.15u l=0.13u
X19 a_32258_36638# row_section_decoding_0.after_001111 gd gd sg13_lv_nmos ad=0.1005p pd=1.34u as=0.1005p ps=1.34u w=0.15u l=0.13u
X20 a_33317_29780# VCO2_selection_0.NOR_2in_0.a vp vp sg13_lv_pmos ad=0.1005p pd=1.34u as=0.1005p ps=1.34u w=0.15u l=0.13u
X21 VCO3_selection_0.NAND_3in_6.b VCO3_selection_0.NOR_2in_4.b a_33068_41518# vp sg13_lv_pmos ad=0.1005p pd=1.34u as=0.1005p ps=1.34u w=0.15u l=0.13u
X22 a_32903_35174# VCO2_selection_0.NOR_2in_2.a vp vp sg13_lv_pmos ad=0.1005p pd=1.34u as=0.1005p ps=1.34u w=0.15u l=0.13u
X23 VCO_selection_0.NAND_2in_0.y 110 vp vp sg13_lv_pmos ad=0.1005p pd=1.34u as=0.1005p ps=1.34u w=0.15u l=0.13u
X24 VCO2_selection_0.inverter_4.out VCO2_selection_0.NOR_2in_0.y gd gd sg13_lv_nmos ad=0.1005p pd=1.34u as=0.1005p ps=1.34u w=0.15u l=0.13u
X25 VCO4_5_sel VCO4_selection_0.NAND_2in_0.b vp vp sg13_lv_pmos ad=0.1005p pd=1.34u as=0.1005p ps=1.34u w=0.15u l=0.13u
X26 row_section_decoding_0.f5_n f5 gd gd sg13_lv_nmos ad=0.1005p pd=1.34u as=0.1005p ps=1.34u w=0.15u l=0.13u
X27 a_32110_40066# VCO3_selection_0.XNOR_1._b gd gd sg13_lv_nmos ad=0.1005p pd=1.34u as=0.1005p ps=1.34u w=0.15u l=0.13u
X28 vp 100 VCO2_selection_0.NAND_4in_0.c vp sg13_lv_pmos ad=0.1005p pd=1.34u as=0.1005p ps=1.34u w=0.15u l=0.13u
X29 VCO3_selection_0.NAND_3in_6.c VCO3_selection_0.inverter_8.out a_33486_41044# vp sg13_lv_pmos ad=0.1005p pd=1.34u as=0.1005p ps=1.34u w=0.15u l=0.13u
X30 vp row_section_decoding_0.after_000111 VCO3_selection_0.NAND_3in_2.y vp sg13_lv_pmos ad=0.1005p pd=1.34u as=0.1005p ps=1.34u w=0.15u l=0.13u
X31 VCO3_selection_0.NAND_3in_8.y 110 a_32468_40540# gd sg13_lv_nmos ad=0.1005p pd=1.34u as=0.1005p ps=1.34u w=0.15u l=0.13u
X32 VCO4_selection_0.NAND_3in_2.y 3bit_to_8_outs_0.coarse_3 a_31956_46420# gd sg13_lv_nmos ad=0.1005p pd=1.34u as=0.1005p ps=1.34u w=0.15u l=0.13u
X33 VCO4_selection_0.inverter_2.in row_section_decoding_0.after_001111_n vp vp sg13_lv_pmos ad=0.1005p pd=1.34u as=0.1005p ps=1.34u w=0.15u l=0.13u
X34 VCO3_selection_0.NAND_3in_5.y 3bit_to_8_outs_0.coarse_3 a_31788_42496# gd sg13_lv_nmos ad=0.1005p pd=1.34u as=0.1005p ps=1.34u w=0.15u l=0.13u
X35 VCO2_selection_0.inverter_2.in f5 vp vp sg13_lv_pmos ad=0.1005p pd=1.34u as=0.1005p ps=1.34u w=0.15u l=0.13u
X36 VCO2_selection_0.inverter_3.in 111 a_31883_34670# gd sg13_lv_nmos ad=0.1005p pd=1.34u as=0.1005p ps=1.34u w=0.15u l=0.13u
X37 VCO3_selection_0.NAND_3in_0.c VCO3_selection_0.inverter_5.out a_33085_39098# vp sg13_lv_pmos ad=0.1005p pd=1.34u as=0.1005p ps=1.34u w=0.15u l=0.13u
X38 VCO5_selection_0.inverter_1.in row_section_decoding_0.after_000011_n vp vp sg13_lv_pmos ad=0.1005p pd=1.34u as=0.1005p ps=1.34u w=0.15u l=0.13u
X39 VCO4_selection_0.inverter_2.out VCO4_selection_0.inverter_2.in vp vp sg13_lv_pmos ad=0.1005p pd=1.34u as=0.1005p ps=1.34u w=0.15u l=0.13u
X40 VCO2_selection_0.NAND_3in_3.c f1 a_31939_31170# vp sg13_lv_pmos ad=0.204p pd=1.88u as=0.204p ps=1.88u w=0.6u l=0.13u
X41 VCO3_selection_0.NAND_3in_1.y 3bit_to_8_outs_0.coarse_2 vp vp sg13_lv_pmos ad=0.1005p pd=1.34u as=0.1005p ps=1.34u w=0.15u l=0.13u
X42 VCO3_selection_0.NAND_2in_1.y 100 a_32258_36164# gd sg13_lv_nmos ad=0.1005p pd=1.34u as=0.1005p ps=1.34u w=0.15u l=0.13u
X43 VCO5_selection_0.XNOR_0._b f1 vp vp sg13_lv_pmos ad=0.1005p pd=1.34u as=0.1005p ps=1.34u w=0.15u l=0.13u
X44 VCO4_selection_0.XNOR_0.y VCO4_selection_0.XNOR_0._b a_32052_48788# vp sg13_lv_pmos ad=0.204p pd=1.88u as=0.204p ps=1.88u w=0.6u l=0.13u
X45 a_32093_34196# row_section_decoding_0.after_001111 gd gd sg13_lv_nmos ad=0.1005p pd=1.34u as=0.1005p ps=1.34u w=0.15u l=0.13u
X46 vp row_section_decoding_0.after_000111 VCO2_selection_0.inverter_1.in vp sg13_lv_pmos ad=0.1005p pd=1.34u as=0.1005p ps=1.34u w=0.15u l=0.13u
X47 VCO_selection_0.NAND_2in_1.y row_section_decoding_0.after_000111 a_31266_50186# gd sg13_lv_nmos ad=0.1005p pd=1.34u as=0.1005p ps=1.34u w=0.15u l=0.13u
X48 VCO3_selection_0.XNOR_1.y VCO3_selection_0.XNOR_1._a a_32570_40066# gd sg13_lv_nmos ad=0.1005p pd=1.34u as=0.1005p ps=1.34u w=0.15u l=0.13u
X49 VCO2_selection_0.NOR_2in_0.b VCO2_selection_0.NAND_3in_7.y gd gd sg13_lv_nmos ad=0.1005p pd=1.34u as=0.1005p ps=1.34u w=0.15u l=0.13u
X50 VCO4_selection_0.inverter_5.in VCO4_selection_0.XNOR_1._a a_32058_47902# gd sg13_lv_nmos ad=0.1005p pd=1.34u as=0.1005p ps=1.34u w=0.15u l=0.13u
X51 vp 3bit_to_8_outs_0.NAND_3in_0.y 111 vp sg13_lv_pmos ad=0.1005p pd=1.34u as=0.1005p ps=1.34u w=0.15u l=0.13u
X52 VCO5_selection_0.inverter_2.out VCO5_selection_0.inverter_2.in vp vp sg13_lv_pmos ad=0.1005p pd=1.34u as=0.1005p ps=1.34u w=0.15u l=0.13u
X53 vp c2 3bit_to_8_outs_0.c2_n vp sg13_lv_pmos ad=0.1005p pd=1.34u as=0.1005p ps=1.34u w=0.15u l=0.13u
X54 a_31945_30758# VCO2_selection_0.XNOR_0._b gd gd sg13_lv_nmos ad=0.1005p pd=1.34u as=0.1005p ps=1.34u w=0.15u l=0.13u
X55 gd c2 a_31626_24854# gd sg13_lv_nmos ad=0.1005p pd=1.34u as=0.1005p ps=1.34u w=0.15u l=0.13u
X56 VCO5_selection_0.inverter_0.in 3bit_to_8_outs_0.coarse_1 vp vp sg13_lv_pmos ad=0.1005p pd=1.34u as=0.1005p ps=1.34u w=0.15u l=0.13u
X57 vp VCO3_selection_0.NAND_3in_6.b VCO3_5_sel vp sg13_lv_pmos ad=0.1005p pd=1.34u as=0.1005p ps=1.34u w=0.15u l=0.13u
X58 gd 3bit_to_8_outs_0.NAND_3in_3.y 101 gd sg13_lv_nmos ad=0.1005p pd=1.34u as=0.1005p ps=1.34u w=0.15u l=0.13u
X59 VCO5_11_sel VCO5_selection_0.NAND_2in_0.b vp vp sg13_lv_pmos ad=0.1005p pd=1.34u as=0.1005p ps=1.34u w=0.15u l=0.13u
X60 VCO4_selection_0.XNOR_0.y VCO4_selection_0.XNOR_0._a a_32058_48376# gd sg13_lv_nmos ad=0.1005p pd=1.34u as=0.1005p ps=1.34u w=0.15u l=0.13u
X61 VCO4_selection_0.inverter_5.out VCO4_selection_0.inverter_5.in gd gd sg13_lv_nmos ad=0.1005p pd=1.34u as=0.1005p ps=1.34u w=0.15u l=0.13u
X62 a_32303_30284# row_section_decoding_0.after_000011_n a_32087_30284# gd sg13_lv_nmos ad=0.1005p pd=1.34u as=0.1005p ps=1.34u w=0.15u l=0.13u
X63 gd 3bit_to_8_outs_0.NAND_3in_2.y 3bit_to_8_outs_0.coarse_1 gd sg13_lv_nmos ad=0.1005p pd=1.34u as=0.1005p ps=1.34u w=0.15u l=0.13u
X64 VCO2_selection_0.inverter_1.out VCO2_selection_0.inverter_1.in gd gd sg13_lv_nmos ad=0.1005p pd=1.34u as=0.1005p ps=1.34u w=0.15u l=0.13u
X65 a_32494_43990# VCO4_selection_0.NAND_2in_0.b gd gd sg13_lv_nmos ad=0.1005p pd=1.34u as=0.1005p ps=1.34u w=0.15u l=0.13u
X66 vp 3bit_to_8_outs_0.c2_n 3bit_to_8_outs_0.NAND_3in_2.y vp sg13_lv_pmos ad=0.1005p pd=1.34u as=0.1005p ps=1.34u w=0.15u l=0.13u
X67 VCO4_selection_0.NOR_2in_1.a VCO4_selection_0.inverter_4.in vp vp sg13_lv_pmos ad=0.1005p pd=1.34u as=0.1005p ps=1.34u w=0.15u l=0.13u
X68 vp c0 3bit_to_8_outs_0.NAND_3in_3.y vp sg13_lv_pmos ad=0.1005p pd=1.34u as=0.1005p ps=1.34u w=0.15u l=0.13u
X69 VCO3_selection_0.XNOR_0._a f0 vp vp sg13_lv_pmos ad=0.1005p pd=1.34u as=0.1005p ps=1.34u w=0.15u l=0.13u
X70 VCO5_selection_0.inverter_2.in f1 a_31315_29201# vp sg13_lv_pmos ad=0.204p pd=1.88u as=0.204p ps=1.88u w=0.6u l=0.13u
X71 a_31788_36164# row_section_decoding_0.after_000011 a_31572_36164# gd sg13_lv_nmos ad=0.1005p pd=1.34u as=0.1005p ps=1.34u w=0.15u l=0.13u
X72 a_31407_32714# row_section_decoding_0.after_000111 gd gd sg13_lv_nmos ad=0.1005p pd=1.34u as=0.1005p ps=1.34u w=0.15u l=0.13u
X73 a_31407_34196# row_section_decoding_0.f5_n gd gd sg13_lv_nmos ad=0.1005p pd=1.34u as=0.1005p ps=1.34u w=0.15u l=0.13u
X74 a_32252_38120# VCO3_selection_0.NAND_3in_7.c gd gd sg13_lv_nmos ad=0.1005p pd=1.34u as=0.1005p ps=1.34u w=0.15u l=0.13u
X75 a_32779_32240# row_section_decoding_0.after_000011 a_32563_32240# gd sg13_lv_nmos ad=0.1005p pd=1.34u as=0.1005p ps=1.34u w=0.15u l=0.13u
X76 VCO2_selection_0.NOR_2in_2.y VCO2_selection_0.NOR_2in_2.a gd gd sg13_lv_nmos ad=0.1005p pd=1.34u as=0.1005p ps=1.34u w=0.15u l=0.13u
X77 a_31592_48788# f0 vp vp sg13_lv_pmos ad=0.204p pd=1.88u as=0.204p ps=1.88u w=0.6u l=0.13u
X78 VCO3_selection_0.inverter_0.out VCO3_selection_0.NAND_3in_7.y gd gd sg13_lv_nmos ad=0.1005p pd=1.34u as=0.1005p ps=1.34u w=0.15u l=0.13u
X79 VCO2_selection_0.NAND_4in_0.b row_section_decoding_0.f5_n vp vp sg13_lv_pmos ad=0.1005p pd=1.34u as=0.1005p ps=1.34u w=0.15u l=0.13u
X80 VCO4_selection_0.inverter_3.in row_section_decoding_0.after_000111_n vp vp sg13_lv_pmos ad=0.1005p pd=1.34u as=0.1005p ps=1.34u w=0.15u l=0.13u
X81 a_31626_25172# 3bit_to_8_outs_0.c1_n a_31410_25172# gd sg13_lv_nmos ad=0.1005p pd=1.34u as=0.1005p ps=1.34u w=0.15u l=0.13u
X82 VCO2_selection_0.NOR_2in_0.y VCO2_selection_0.NOR_2in_0.b a_33317_29780# vp sg13_lv_pmos ad=0.1005p pd=1.34u as=0.1005p ps=1.34u w=0.15u l=0.13u
X83 gd VCO3_selection_0.inverter_8.out VCO3_selection_0.NAND_3in_6.c gd sg13_lv_nmos ad=0.1005p pd=1.34u as=0.1005p ps=1.34u w=0.15u l=0.13u
X84 a_31626_26816# 3bit_to_8_outs_0.c1_n a_31410_26816# gd sg13_lv_nmos ad=0.1005p pd=1.34u as=0.1005p ps=1.34u w=0.15u l=0.13u
X85 VCO5_selection_0.inverter_0.out VCO5_selection_0.inverter_0.in gd gd sg13_lv_nmos ad=0.1005p pd=1.34u as=0.1005p ps=1.34u w=0.15u l=0.13u
X86 a_32405_30758# f1 gd gd sg13_lv_nmos ad=0.1005p pd=1.34u as=0.1005p ps=1.34u w=0.15u l=0.13u
X87 VCO3_selection_0.inverter_5.out VCO3_selection_0.NAND_3in_3.y vp vp sg13_lv_pmos ad=0.1005p pd=1.34u as=0.1005p ps=1.34u w=0.15u l=0.13u
X88 gd VCO3_selection_0.NOR_2in_4.b VCO3_selection_0.NAND_3in_6.b gd sg13_lv_nmos ad=0.1005p pd=1.34u as=0.1005p ps=1.34u w=0.15u l=0.13u
X89 gd 3bit_to_8_outs_0.inverter_10.in 3bit_to_8_outs_0.coarse_3 gd sg13_lv_nmos ad=0.1005p pd=1.34u as=0.1005p ps=1.34u w=0.15u l=0.13u
X90 vp c2 3bit_to_8_outs_0.inverter_6.in vp sg13_lv_pmos ad=0.1005p pd=1.34u as=0.1005p ps=1.34u w=0.15u l=0.13u
X91 a_31407_34670# f5 gd gd sg13_lv_nmos ad=0.1005p pd=1.34u as=0.1005p ps=1.34u w=0.15u l=0.13u
X92 VCO3_selection_0.inverter_3.out VCO3_selection_0.NAND_3in_2.y vp vp sg13_lv_pmos ad=0.1005p pd=1.34u as=0.1005p ps=1.34u w=0.15u l=0.13u
X93 VCO4_selection_0.inverter_4.in 3bit_to_8_outs_0.coarse_1 vp vp sg13_lv_pmos ad=0.1005p pd=1.34u as=0.1005p ps=1.34u w=0.15u l=0.13u
X94 3bit_to_8_outs_0.inverter_10.in c1 vp vp sg13_lv_pmos ad=0.1005p pd=1.34u as=0.1005p ps=1.34u w=0.15u l=0.13u
X95 VCO3_11_sel VCO3_selection_0.NOR_2in_0.y vp vp sg13_lv_pmos ad=0.1005p pd=1.34u as=0.1005p ps=1.34u w=0.15u l=0.13u
X96 vp 3bit_to_8_outs_0.coarse_1 VCO3_selection_0.NAND_2in_0.y vp sg13_lv_pmos ad=0.1005p pd=1.34u as=0.1005p ps=1.34u w=0.15u l=0.13u
X97 row_section_decoding_0.NAND_2in_0.a f3 a_30774_23859# vp sg13_lv_pmos ad=0.1005p pd=1.34u as=0.1005p ps=1.34u w=0.15u l=0.13u
X98 gd VCO3_selection_0.inverter_5.out VCO3_selection_0.NAND_3in_0.c gd sg13_lv_nmos ad=0.1005p pd=1.34u as=0.1005p ps=1.34u w=0.15u l=0.13u
X99 vp row_section_decoding_0.after_000011_n VCO3_selection_0.NAND_3in_8.y vp sg13_lv_pmos ad=0.1005p pd=1.34u as=0.1005p ps=1.34u w=0.15u l=0.13u
X100 VCO2_selection_0.NAND_4in_0.c 100 a_31407_32240# gd sg13_lv_nmos ad=0.1005p pd=1.34u as=0.1005p ps=1.34u w=0.15u l=0.13u
X101 a_32090_24854# c0 3bit_to_8_outs_0.NAND_3in_0.y gd sg13_lv_nmos ad=0.1005p pd=1.34u as=0.1005p ps=1.34u w=0.15u l=0.13u
X102 a_30790_50186# f5 gd gd sg13_lv_nmos ad=0.1005p pd=1.34u as=0.1005p ps=1.34u w=0.15u l=0.13u
X103 row_section_decoding_0.after_000011_n row_section_decoding_0.after_000011 vp vp sg13_lv_pmos ad=0.1005p pd=1.34u as=0.1005p ps=1.34u w=0.15u l=0.13u
X104 VCO2_selection_0.XNOR_0._a f0 gd gd sg13_lv_nmos ad=0.1005p pd=1.34u as=0.1005p ps=1.34u w=0.15u l=0.13u
X105 VCO3_selection_0.NOR_2in_4.b VCO3_selection_0.NAND_2in_3.y vp vp sg13_lv_pmos ad=0.1005p pd=1.34u as=0.1005p ps=1.34u w=0.15u l=0.13u
X106 VCO4_selection_0.NAND_3in_1.y 3bit_to_8_outs_0.coarse_0 vp vp sg13_lv_pmos ad=0.1005p pd=1.34u as=0.1005p ps=1.34u w=0.15u l=0.13u
X107 VCO2_5_sel VCO2_selection_0.NAND_4in_0.d vp vp sg13_lv_pmos ad=0.1005p pd=1.34u as=0.1005p ps=1.34u w=0.15u l=0.13u
X108 VCO2_11_sel VCO2_selection_0.NAND_3in_5.c vp vp sg13_lv_pmos ad=0.1005p pd=1.34u as=0.1005p ps=1.34u w=0.15u l=0.13u
X109 VCO_sel VCO_selection_0.NAND_2in_2.y vp vp sg13_lv_pmos ad=0.1005p pd=1.34u as=0.1005p ps=1.34u w=0.15u l=0.13u
X110 VCO4_selection_0.inverter_3.out VCO4_selection_0.inverter_3.in gd gd sg13_lv_nmos ad=0.1005p pd=1.34u as=0.1005p ps=1.34u w=0.15u l=0.13u
X111 vp row_section_decoding_0.after_000011 VCO2_selection_0.NAND_4in_0.d vp sg13_lv_pmos ad=0.1005p pd=1.34u as=0.1005p ps=1.34u w=0.15u l=0.13u
X112 row_section_decoding_0.after_001111 row_section_decoding_0.after_001111_n vp vp sg13_lv_pmos ad=0.1005p pd=1.34u as=0.1005p ps=1.34u w=0.15u l=0.13u
X113 vp 3bit_to_8_outs_0.c0_n 3bit_to_8_outs_0.inverter_8.in vp sg13_lv_pmos ad=0.1005p pd=1.34u as=0.1005p ps=1.34u w=0.15u l=0.13u
X114 VCO3_selection_0.NAND_3in_4.y 100 vp vp sg13_lv_pmos ad=0.1005p pd=1.34u as=0.1005p ps=1.34u w=0.15u l=0.13u
X115 VCO3_selection_0.inverter_4.in row_section_decoding_0.after_001111 vp vp sg13_lv_pmos ad=0.1005p pd=1.34u as=0.1005p ps=1.34u w=0.15u l=0.13u
X116 a_31060_44464# row_section_decoding_0.after_001111_n gd gd sg13_lv_nmos ad=0.1005p pd=1.34u as=0.1005p ps=1.34u w=0.15u l=0.13u
X117 VCO4_selection_0.NOR_2in_0.b VCO4_selection_0.inverter_1.in vp vp sg13_lv_pmos ad=0.1005p pd=1.34u as=0.1005p ps=1.34u w=0.15u l=0.13u
X118 vp row_section_decoding_0.after_000111 VCO_selection_0.NAND_2in_1.y vp sg13_lv_pmos ad=0.1005p pd=1.34u as=0.1005p ps=1.34u w=0.15u l=0.13u
X119 VCO2_selection_0.NAND_3in_7.y row_section_decoding_0.after_000111_n vp vp sg13_lv_pmos ad=0.1005p pd=1.34u as=0.1005p ps=1.34u w=0.15u l=0.13u
X120 VCO4_selection_0.inverter_2.out VCO4_selection_0.inverter_2.in gd gd sg13_lv_nmos ad=0.1005p pd=1.34u as=0.1005p ps=1.34u w=0.15u l=0.13u
X121 VCO2_selection_0.inverter_4.out VCO2_selection_0.NOR_2in_0.y vp vp sg13_lv_pmos ad=0.1005p pd=1.34u as=0.1005p ps=1.34u w=0.15u l=0.13u
X122 VCO3_selection_0.XNOR_0._a f0 gd gd sg13_lv_nmos ad=0.1005p pd=1.34u as=0.1005p ps=1.34u w=0.15u l=0.13u
X123 vp row_section_decoding_0.after_000111 VCO3_selection_0.NAND_3in_5.y vp sg13_lv_pmos ad=0.1005p pd=1.34u as=0.1005p ps=1.34u w=0.15u l=0.13u
X124 vp 100 VCO3_selection_0.NAND_2in_1.y vp sg13_lv_pmos ad=0.1005p pd=1.34u as=0.1005p ps=1.34u w=0.15u l=0.13u
X125 vp VCO4_selection_0.inverter_5.out VCO4_selection_0.NAND_3in_2.y vp sg13_lv_pmos ad=0.1005p pd=1.34u as=0.1005p ps=1.34u w=0.15u l=0.13u
X126 VCO2_selection_0.NAND_2in_0.y row_section_decoding_0.after_001111 vp vp sg13_lv_pmos ad=0.1005p pd=1.34u as=0.1005p ps=1.34u w=0.15u l=0.13u
X127 VCO4_selection_0.inverter_3.in 3bit_to_8_outs_0.coarse_1 a_31276_45946# gd sg13_lv_nmos ad=0.1005p pd=1.34u as=0.1005p ps=1.34u w=0.15u l=0.13u
X128 VCO3_selection_0.inverter_1.out VCO3_selection_0.NAND_2in_1.y gd gd sg13_lv_nmos ad=0.1005p pd=1.34u as=0.1005p ps=1.34u w=0.15u l=0.13u
X129 VCO2_selection_0.NAND_3in_7.y 110 a_31623_30284# gd sg13_lv_nmos ad=0.1005p pd=1.34u as=0.1005p ps=1.34u w=0.15u l=0.13u
X130 a_32052_47400# VCO4_selection_0.XNOR_1._a vp vp sg13_lv_pmos ad=0.204p pd=1.88u as=0.204p ps=1.88u w=0.6u l=0.13u
X131 VCO2_selection_0.NAND_3in_3.c VCO2_selection_0.XNOR_0._b a_32399_31170# vp sg13_lv_pmos ad=0.204p pd=1.88u as=0.204p ps=1.88u w=0.6u l=0.13u
X132 VCO3_selection_0.inverter_12.out VCO3_selection_0.XNOR_1.y gd gd sg13_lv_nmos ad=0.1005p pd=1.34u as=0.1005p ps=1.34u w=0.15u l=0.13u
X133 a_33068_41518# VCO3_selection_0.NOR_2in_4.a vp vp sg13_lv_pmos ad=0.1005p pd=1.34u as=0.1005p ps=1.34u w=0.15u l=0.13u
X134 gd c2 3bit_to_8_outs_0.c2_n gd sg13_lv_nmos ad=0.1005p pd=1.34u as=0.1005p ps=1.34u w=0.15u l=0.13u
X135 a_32152_32714# row_section_decoding_0.f5_n gd gd sg13_lv_nmos ad=0.1005p pd=1.34u as=0.1005p ps=1.34u w=0.15u l=0.13u
X136 gd c0 3bit_to_8_outs_0.c0_n gd sg13_lv_nmos ad=0.1005p pd=1.34u as=0.1005p ps=1.34u w=0.15u l=0.13u
X137 a_31315_29201# f0 vp vp sg13_lv_pmos ad=0.204p pd=1.88u as=0.204p ps=1.88u w=0.6u l=0.13u
X138 VCO2_selection_0.NAND_4in_0.c f5 vp vp sg13_lv_pmos ad=0.1005p pd=1.34u as=0.1005p ps=1.34u w=0.15u l=0.13u
X139 VCO3_selection_0.NAND_3in_3.y row_section_decoding_0.after_000111_n vp vp sg13_lv_pmos ad=0.1005p pd=1.34u as=0.1005p ps=1.34u w=0.15u l=0.13u
X140 a_33486_41044# VCO3_selection_0.inverter_7.out vp vp sg13_lv_pmos ad=0.1005p pd=1.34u as=0.1005p ps=1.34u w=0.15u l=0.13u
X141 VCO3_selection_0.XNOR_0._b f1 vp vp sg13_lv_pmos ad=0.1005p pd=1.34u as=0.1005p ps=1.34u w=0.15u l=0.13u
X142 VCO4_selection_0.inverter_5.out VCO4_selection_0.inverter_5.in vp vp sg13_lv_pmos ad=0.1005p pd=1.34u as=0.1005p ps=1.34u w=0.15u l=0.13u
X143 VCO2_selection_0.NAND_3in_3.y 110 vp vp sg13_lv_pmos ad=0.1005p pd=1.34u as=0.1005p ps=1.34u w=0.15u l=0.13u
X144 row_section_decoding_0.NAND_2in_0.b f5 a_31510_22377# vp sg13_lv_pmos ad=0.1005p pd=1.34u as=0.1005p ps=1.34u w=0.15u l=0.13u
X145 VCO2_selection_0.inverter_1.out VCO2_selection_0.inverter_1.in vp vp sg13_lv_pmos ad=0.1005p pd=1.34u as=0.1005p ps=1.34u w=0.15u l=0.13u
X146 a_32468_40540# row_section_decoding_0.after_000011_n a_32252_40540# gd sg13_lv_nmos ad=0.1005p pd=1.34u as=0.1005p ps=1.34u w=0.15u l=0.13u
X147 VCO4_selection_0.inverter_1.in VCO4_selection_0.inverter_3.out a_32494_44968# vp sg13_lv_pmos ad=0.1005p pd=1.34u as=0.1005p ps=1.34u w=0.15u l=0.13u
X148 a_31410_25172# c0 3bit_to_8_outs_0.NAND_3in_3.y gd sg13_lv_nmos ad=0.1005p pd=1.34u as=0.1005p ps=1.34u w=0.15u l=0.13u
X149 VCO4_selection_0.NOR_2in_1.a VCO4_selection_0.inverter_4.in gd gd sg13_lv_nmos ad=0.1005p pd=1.34u as=0.1005p ps=1.34u w=0.15u l=0.13u
X150 a_31788_42496# row_section_decoding_0.after_000111 a_31572_42496# gd sg13_lv_nmos ad=0.1005p pd=1.34u as=0.1005p ps=1.34u w=0.15u l=0.13u
X151 gd 3bit_to_8_outs_0.inverter_1.in 110 gd sg13_lv_nmos ad=0.1005p pd=1.34u as=0.1005p ps=1.34u w=0.15u l=0.13u
X152 a_31410_26816# c0 3bit_to_8_outs_0.NAND_3in_2.y gd sg13_lv_nmos ad=0.1005p pd=1.34u as=0.1005p ps=1.34u w=0.15u l=0.13u
X153 vp row_section_decoding_0.NAND_2in_0.a row_section_decoding_0.after_000011 vp sg13_lv_pmos ad=0.1005p pd=1.34u as=0.1005p ps=1.34u w=0.15u l=0.13u
X154 a_32258_36164# row_section_decoding_0.after_000011_n gd gd sg13_lv_nmos ad=0.1005p pd=1.34u as=0.1005p ps=1.34u w=0.15u l=0.13u
X155 vp row_section_decoding_0.after_000011 VCO3_selection_0.NAND_3in_1.y vp sg13_lv_pmos ad=0.1005p pd=1.34u as=0.1005p ps=1.34u w=0.15u l=0.13u
X156 VCO_sel VCO_selection_0.NAND_2in_1.y a_31476_49868# gd sg13_lv_nmos ad=0.1005p pd=1.34u as=0.1005p ps=1.34u w=0.15u l=0.13u
X157 VCO2_selection_0.inverter_1.in row_section_decoding_0.f5_n vp vp sg13_lv_pmos ad=0.1005p pd=1.34u as=0.1005p ps=1.34u w=0.15u l=0.13u
X158 gd VCO3_selection_0.inverter_4.out VCO3_selection_0.NOR_2in_0.y gd sg13_lv_nmos ad=0.1005p pd=1.34u as=0.1005p ps=1.34u w=0.15u l=0.13u
X159 VCO3_selection_0.inverter_5.out VCO3_selection_0.NAND_3in_3.y gd gd sg13_lv_nmos ad=0.1005p pd=1.34u as=0.1005p ps=1.34u w=0.15u l=0.13u
X160 row_section_decoding_0.after_001111_n f5 a_31986_22377# vp sg13_lv_pmos ad=0.1005p pd=1.34u as=0.1005p ps=1.34u w=0.15u l=0.13u
X161 a_32828_32714# VCO2_selection_0.NAND_4in_0.d gd gd sg13_lv_nmos ad=0.1005p pd=1.34u as=0.1005p ps=1.34u w=0.15u l=0.13u
X162 a_33373_34670# VCO2_selection_0.NAND_3in_5.c gd gd sg13_lv_nmos ad=0.1005p pd=1.34u as=0.1005p ps=1.34u w=0.15u l=0.13u
X163 VCO3_selection_0.NAND_3in_7.c f0 a_32110_38594# gd sg13_lv_nmos ad=0.1005p pd=1.34u as=0.1005p ps=1.34u w=0.15u l=0.13u
X164 a_31266_50186# 111 gd gd sg13_lv_nmos ad=0.1005p pd=1.34u as=0.1005p ps=1.34u w=0.15u l=0.13u
X165 VCO4_selection_0.NOR_2in_0.b VCO4_selection_0.inverter_1.in gd gd sg13_lv_nmos ad=0.1005p pd=1.34u as=0.1005p ps=1.34u w=0.15u l=0.13u
X166 VCO5_selection_0.inverter_2.in VCO5_selection_0.XNOR_0._b a_31775_29201# vp sg13_lv_pmos ad=0.204p pd=1.88u as=0.204p ps=1.88u w=0.6u l=0.13u
X167 VCO3_11_sel VCO3_selection_0.NOR_2in_0.y a_33692_38120# gd sg13_lv_nmos ad=0.1005p pd=1.34u as=0.1005p ps=1.34u w=0.15u l=0.13u
X168 VCO3_selection_0.NAND_2in_0.y 3bit_to_8_outs_0.coarse_1 a_31572_42022# gd sg13_lv_nmos ad=0.1005p pd=1.34u as=0.1005p ps=1.34u w=0.15u l=0.13u
X169 vp 3bit_to_8_outs_0.NAND_3in_2.y 3bit_to_8_outs_0.coarse_1 vp sg13_lv_pmos ad=0.1005p pd=1.34u as=0.1005p ps=1.34u w=0.15u l=0.13u
X170 VCO3_selection_0.NAND_3in_7.y 3bit_to_8_outs_0.coarse_3 vp vp sg13_lv_pmos ad=0.1005p pd=1.34u as=0.1005p ps=1.34u w=0.15u l=0.13u
X171 a_32058_47902# f1 gd gd sg13_lv_nmos ad=0.1005p pd=1.34u as=0.1005p ps=1.34u w=0.15u l=0.13u
X172 vp c2 3bit_to_8_outs_0.inverter_1.in vp sg13_lv_pmos ad=0.1005p pd=1.34u as=0.1005p ps=1.34u w=0.15u l=0.13u
X173 a_31956_45946# row_section_decoding_0.after_000011 a_31740_45946# gd sg13_lv_nmos ad=0.1005p pd=1.34u as=0.1005p ps=1.34u w=0.15u l=0.13u
X174 a_31626_24854# c1 a_31410_24854# gd sg13_lv_nmos ad=0.1005p pd=1.34u as=0.1005p ps=1.34u w=0.15u l=0.13u
X175 VCO5_selection_0.inverter_0.out VCO5_selection_0.inverter_0.in vp vp sg13_lv_pmos ad=0.1005p pd=1.34u as=0.1005p ps=1.34u w=0.15u l=0.13u
X176 VCO3_selection_0.NAND_3in_4.y 100 a_31788_40540# gd sg13_lv_nmos ad=0.1005p pd=1.34u as=0.1005p ps=1.34u w=0.15u l=0.13u
X177 VCO3_selection_0.NOR_2in_4.b VCO3_selection_0.NAND_2in_3.y gd gd sg13_lv_nmos ad=0.1005p pd=1.34u as=0.1005p ps=1.34u w=0.15u l=0.13u
X178 gd c2 a_32306_25172# gd sg13_lv_nmos ad=0.1005p pd=1.34u as=0.1005p ps=1.34u w=0.15u l=0.13u
X179 VCO4_selection_0.inverter_4.in 3bit_to_8_outs_0.coarse_1 a_31276_46420# gd sg13_lv_nmos ad=0.1005p pd=1.34u as=0.1005p ps=1.34u w=0.15u l=0.13u
X180 VCO_selection_0.NAND_2in_2.y f5 vp vp sg13_lv_pmos ad=0.1005p pd=1.34u as=0.1005p ps=1.34u w=0.15u l=0.13u
X181 gd 3bit_to_8_outs_0.c2_n a_32306_26816# gd sg13_lv_nmos ad=0.1005p pd=1.34u as=0.1005p ps=1.34u w=0.15u l=0.13u
X182 gd f3 row_section_decoding_0.NAND_2in_0.a gd sg13_lv_nmos ad=0.1005p pd=1.34u as=0.1005p ps=1.34u w=0.15u l=0.13u
X183 vp 3bit_to_8_outs_0.inverter_10.in 3bit_to_8_outs_0.coarse_3 vp sg13_lv_pmos ad=0.1005p pd=1.34u as=0.1005p ps=1.34u w=0.15u l=0.13u
X184 VCO2_selection_0.XNOR_0._b f1 gd gd sg13_lv_nmos ad=0.1005p pd=1.34u as=0.1005p ps=1.34u w=0.15u l=0.13u
X185 a_32058_48376# f1 gd gd sg13_lv_nmos ad=0.1005p pd=1.34u as=0.1005p ps=1.34u w=0.15u l=0.13u
X186 a_32087_30284# VCO2_selection_0.NAND_3in_3.c gd gd sg13_lv_nmos ad=0.1005p pd=1.34u as=0.1005p ps=1.34u w=0.15u l=0.13u
X187 a_32093_32240# row_section_decoding_0.after_000011 a_31877_32240# gd sg13_lv_nmos ad=0.1005p pd=1.34u as=0.1005p ps=1.34u w=0.15u l=0.13u
X188 a_31572_36638# row_section_decoding_0.f5_n gd gd sg13_lv_nmos ad=0.1005p pd=1.34u as=0.1005p ps=1.34u w=0.15u l=0.13u
X189 3bit_to_8_outs_0.NAND_3in_2.y 3bit_to_8_outs_0.c1_n vp vp sg13_lv_pmos ad=0.1005p pd=1.34u as=0.1005p ps=1.34u w=0.15u l=0.13u
X190 VCO2_selection_0.NOR_2in_0.a VCO2_selection_0.NAND_3in_3.y gd gd sg13_lv_nmos ad=0.1005p pd=1.34u as=0.1005p ps=1.34u w=0.15u l=0.13u
X191 VCO4_selection_0.NAND_3in_0.y f1 vp vp sg13_lv_pmos ad=0.1005p pd=1.34u as=0.1005p ps=1.34u w=0.15u l=0.13u
X192 row_section_decoding_0.after_000011_n row_section_decoding_0.after_000011 gd gd sg13_lv_nmos ad=0.1005p pd=1.34u as=0.1005p ps=1.34u w=0.15u l=0.13u
X193 VCO_selection_0.NAND_2in_0.y row_section_decoding_0.after_001111 a_30790_49868# gd sg13_lv_nmos ad=0.1005p pd=1.34u as=0.1005p ps=1.34u w=0.15u l=0.13u
X194 VCO4_selection_0.inverter_0.out VCO4_selection_0.NAND_3in_0.y vp vp sg13_lv_pmos ad=0.1005p pd=1.34u as=0.1005p ps=1.34u w=0.15u l=0.13u
X195 gd f5 row_section_decoding_0.NAND_2in_0.b gd sg13_lv_nmos ad=0.1005p pd=1.34u as=0.1005p ps=1.34u w=0.15u l=0.13u
X196 row_section_decoding_0.after_001111 row_section_decoding_0.after_001111_n gd gd sg13_lv_nmos ad=0.1005p pd=1.34u as=0.1005p ps=1.34u w=0.15u l=0.13u
X197 VCO3_selection_0.NAND_3in_6.c VCO3_selection_0.inverter_7.out gd gd sg13_lv_nmos ad=0.1005p pd=1.34u as=0.1005p ps=1.34u w=0.15u l=0.13u
X198 VCO2_selection_0.inverter_6.out VCO2_selection_0.NAND_3in_4.y vp vp sg13_lv_pmos ad=0.1005p pd=1.34u as=0.1005p ps=1.34u w=0.15u l=0.13u
X199 VCO4_selection_0.inverter_5.in f1 a_31592_47400# vp sg13_lv_pmos ad=0.204p pd=1.88u as=0.204p ps=1.88u w=0.6u l=0.13u
X200 VCO4_selection_0.inverter_2.in 3bit_to_8_outs_0.coarse_0 vp vp sg13_lv_pmos ad=0.1005p pd=1.34u as=0.1005p ps=1.34u w=0.15u l=0.13u
X201 VCO3_selection_0.XNOR_0._b f1 gd gd sg13_lv_nmos ad=0.1005p pd=1.34u as=0.1005p ps=1.34u w=0.15u l=0.13u
X202 a_31623_30284# row_section_decoding_0.after_000011 a_31407_30284# gd sg13_lv_nmos ad=0.1005p pd=1.34u as=0.1005p ps=1.34u w=0.15u l=0.13u
X203 a_32772_28789# VCO5_selection_0.inverter_2.out a_32556_28789# gd sg13_lv_nmos ad=0.1005p pd=1.34u as=0.1005p ps=1.34u w=0.15u l=0.13u
X204 a_31519_28315# row_section_decoding_0.after_000011_n a_31303_28315# gd sg13_lv_nmos ad=0.1005p pd=1.34u as=0.1005p ps=1.34u w=0.15u l=0.13u
X205 VCO2_selection_0.XNOR_0._a f0 vp vp sg13_lv_pmos ad=0.1005p pd=1.34u as=0.1005p ps=1.34u w=0.15u l=0.13u
X206 gd f5 row_section_decoding_0.after_001111_n gd sg13_lv_nmos ad=0.1005p pd=1.34u as=0.1005p ps=1.34u w=0.15u l=0.13u
X207 a_32018_44968# VCO4_selection_0.inverter_2.out vp vp sg13_lv_pmos ad=0.1005p pd=1.34u as=0.1005p ps=1.34u w=0.15u l=0.13u
X208 VCO3_selection_0.NAND_3in_6.b VCO3_selection_0.NOR_2in_4.a gd gd sg13_lv_nmos ad=0.1005p pd=1.34u as=0.1005p ps=1.34u w=0.15u l=0.13u
X209 3bit_to_8_outs_0.inverter_6.in 3bit_to_8_outs_0.c1_n vp vp sg13_lv_pmos ad=0.1005p pd=1.34u as=0.1005p ps=1.34u w=0.15u l=0.13u
X210 VCO2_5_sel VCO2_selection_0.NAND_4in_0.b vp vp sg13_lv_pmos ad=0.1005p pd=1.34u as=0.1005p ps=1.34u w=0.15u l=0.13u
X211 vp VCO4_selection_0.XNOR_0.y VCO4_selection_0.inverter_4.in vp sg13_lv_pmos ad=0.1005p pd=1.34u as=0.1005p ps=1.34u w=0.15u l=0.13u
X212 gd 3bit_to_8_outs_0.c2_n a_31626_26498# gd sg13_lv_nmos ad=0.1005p pd=1.34u as=0.1005p ps=1.34u w=0.15u l=0.13u
X213 VCO4_selection_0.NAND_2in_0.a VCO4_selection_0.inverter_0.out a_32018_44968# vp sg13_lv_pmos ad=0.1005p pd=1.34u as=0.1005p ps=1.34u w=0.15u l=0.13u
X214 a_32104_39564# f0 vp vp sg13_lv_pmos ad=0.204p pd=1.88u as=0.204p ps=1.88u w=0.6u l=0.13u
X215 a_31407_32240# f5 gd gd sg13_lv_nmos ad=0.1005p pd=1.34u as=0.1005p ps=1.34u w=0.15u l=0.13u
X216 a_31956_46420# VCO4_selection_0.inverter_5.out a_31740_46420# gd sg13_lv_nmos ad=0.1005p pd=1.34u as=0.1005p ps=1.34u w=0.15u l=0.13u
X217 vp c0 3bit_to_8_outs_0.NAND_3in_0.y vp sg13_lv_pmos ad=0.1005p pd=1.34u as=0.1005p ps=1.34u w=0.15u l=0.13u
X218 a_31572_38120# row_section_decoding_0.after_000111_n gd gd sg13_lv_nmos ad=0.1005p pd=1.34u as=0.1005p ps=1.34u w=0.15u l=0.13u
X219 VCO2_selection_0.NOR_2in_0.y VCO2_selection_0.NOR_2in_0.a gd gd sg13_lv_nmos ad=0.1005p pd=1.34u as=0.1005p ps=1.34u w=0.15u l=0.13u
X220 a_31510_22377# f4 vp vp sg13_lv_pmos ad=0.1005p pd=1.34u as=0.1005p ps=1.34u w=0.15u l=0.13u
X221 a_31939_31170# f0 vp vp sg13_lv_pmos ad=0.204p pd=1.88u as=0.204p ps=1.88u w=0.6u l=0.13u
X222 VCO3_selection_0.inverter_1.out VCO3_selection_0.NAND_2in_1.y vp vp sg13_lv_pmos ad=0.1005p pd=1.34u as=0.1005p ps=1.34u w=0.15u l=0.13u
X223 VCO4_selection_0.inverter_3.out VCO4_selection_0.inverter_3.in vp vp sg13_lv_pmos ad=0.1005p pd=1.34u as=0.1005p ps=1.34u w=0.15u l=0.13u
X224 VCO5_selection_0.inverter_1.out VCO5_selection_0.inverter_1.in gd gd sg13_lv_nmos ad=0.1005p pd=1.34u as=0.1005p ps=1.34u w=0.15u l=0.13u
X225 a_32110_38594# VCO3_selection_0.XNOR_0._b gd gd sg13_lv_nmos ad=0.1005p pd=1.34u as=0.1005p ps=1.34u w=0.15u l=0.13u
X226 a_31060_43990# f1 gd gd sg13_lv_nmos ad=0.1005p pd=1.34u as=0.1005p ps=1.34u w=0.15u l=0.13u
X227 VCO5_selection_0.inverter_1.in 3bit_to_8_outs_0.coarse_0 a_30783_28315# gd sg13_lv_nmos ad=0.1005p pd=1.34u as=0.1005p ps=1.34u w=0.15u l=0.13u
X228 gd VCO4_selection_0.inverter_3.out VCO4_selection_0.inverter_1.in gd sg13_lv_nmos ad=0.1005p pd=1.34u as=0.1005p ps=1.34u w=0.15u l=0.13u
X229 gd VCO2_selection_0.inverter_0.out VCO2_selection_0.NOR_2in_1.y gd sg13_lv_nmos ad=0.1005p pd=1.34u as=0.1005p ps=1.34u w=0.15u l=0.13u
X230 vp row_section_decoding_0.after_000011 VCO3_selection_0.NAND_3in_4.y vp sg13_lv_pmos ad=0.1005p pd=1.34u as=0.1005p ps=1.34u w=0.15u l=0.13u
X231 VCO3_selection_0.NAND_3in_6.a VCO3_selection_0.inverter_10.out a_33484_43000# vp sg13_lv_pmos ad=0.1005p pd=1.34u as=0.1005p ps=1.34u w=0.15u l=0.13u
X232 VCO3_selection_0.XNOR_1.y VCO3_selection_0.XNOR_1._b a_32564_39564# vp sg13_lv_pmos ad=0.204p pd=1.88u as=0.204p ps=1.88u w=0.6u l=0.13u
X233 VCO3_selection_0.NAND_3in_9.y row_section_decoding_0.f5_n vp vp sg13_lv_pmos ad=0.1005p pd=1.34u as=0.1005p ps=1.34u w=0.15u l=0.13u
X234 VCO4_selection_0.inverter_0.out VCO4_selection_0.NAND_3in_0.y gd gd sg13_lv_nmos ad=0.1005p pd=1.34u as=0.1005p ps=1.34u w=0.15u l=0.13u
X235 VCO_selection_0.NAND_2in_1.y 111 vp vp sg13_lv_pmos ad=0.1005p pd=1.34u as=0.1005p ps=1.34u w=0.15u l=0.13u
X236 row_section_decoding_0.after_000011 row_section_decoding_0.NAND_2in_0.a a_31250_23355# gd sg13_lv_nmos ad=0.1005p pd=1.34u as=0.1005p ps=1.34u w=0.15u l=0.13u
X237 VCO3_selection_0.NAND_3in_7.y 3bit_to_8_outs_0.coarse_3 a_32468_38120# gd sg13_lv_nmos ad=0.1005p pd=1.34u as=0.1005p ps=1.34u w=0.15u l=0.13u
X238 vp c0 3bit_to_8_outs_0.c0_n vp sg13_lv_pmos ad=0.1005p pd=1.34u as=0.1005p ps=1.34u w=0.15u l=0.13u
X239 VCO3_selection_0.inverter_10.out VCO3_selection_0.NAND_3in_9.y vp vp sg13_lv_pmos ad=0.1005p pd=1.34u as=0.1005p ps=1.34u w=0.15u l=0.13u
X240 a_31410_24854# 3bit_to_8_outs_0.c0_n 3bit_to_8_outs_0.inverter_1.in gd sg13_lv_nmos ad=0.1005p pd=1.34u as=0.1005p ps=1.34u w=0.15u l=0.13u
X241 VCO2_selection_0.NOR_2in_2.y VCO2_selection_0.NOR_2in_2.b a_32903_35174# vp sg13_lv_pmos ad=0.1005p pd=1.34u as=0.1005p ps=1.34u w=0.15u l=0.13u
X242 VCO3_selection_0.NAND_2in_1.y row_section_decoding_0.after_000011_n vp vp sg13_lv_pmos ad=0.1005p pd=1.34u as=0.1005p ps=1.34u w=0.15u l=0.13u
X243 VCO2_selection_0.NAND_4in_0.b 101 vp vp sg13_lv_pmos ad=0.1005p pd=1.34u as=0.1005p ps=1.34u w=0.15u l=0.13u
X244 VCO4_selection_0.inverter_3.in 3bit_to_8_outs_0.coarse_1 vp vp sg13_lv_pmos ad=0.1005p pd=1.34u as=0.1005p ps=1.34u w=0.15u l=0.13u
X245 a_32104_39006# f0 vp vp sg13_lv_pmos ad=0.204p pd=1.88u as=0.204p ps=1.88u w=0.6u l=0.13u
X246 a_30990_22377# f5 a_30774_22377# vp sg13_lv_pmos ad=0.1005p pd=1.34u as=0.1005p ps=1.34u w=0.15u l=0.13u
X247 a_31781_28789# f1 gd gd sg13_lv_nmos ad=0.1005p pd=1.34u as=0.1005p ps=1.34u w=0.15u l=0.13u
X248 VCO3_selection_0.inverter_4.out VCO3_selection_0.inverter_4.in gd gd sg13_lv_nmos ad=0.1005p pd=1.34u as=0.1005p ps=1.34u w=0.15u l=0.13u
X249 a_31276_45946# row_section_decoding_0.after_000011 a_31060_45946# gd sg13_lv_nmos ad=0.1005p pd=1.34u as=0.1005p ps=1.34u w=0.15u l=0.13u
X250 VCO3_selection_0.XNOR_1._a f0 vp vp sg13_lv_pmos ad=0.1005p pd=1.34u as=0.1005p ps=1.34u w=0.15u l=0.13u
X251 VCO2_selection_0.NOR_2in_2.a VCO2_selection_0.inverter_2.in vp vp sg13_lv_pmos ad=0.1005p pd=1.34u as=0.1005p ps=1.34u w=0.15u l=0.13u
X252 a_32399_31170# VCO2_selection_0.XNOR_0._a vp vp sg13_lv_pmos ad=0.204p pd=1.88u as=0.204p ps=1.88u w=0.6u l=0.13u
X253 gd VCO2_selection_0.inverter_4.out VCO2_selection_0.NAND_3in_5.c gd sg13_lv_nmos ad=0.1005p pd=1.34u as=0.1005p ps=1.34u w=0.15u l=0.13u
X254 vp c0 3bit_to_8_outs_0.NAND_3in_2.y vp sg13_lv_pmos ad=0.1005p pd=1.34u as=0.1005p ps=1.34u w=0.15u l=0.13u
X255 VCO2_selection_0.NAND_3in_4.y row_section_decoding_0.after_000111_n vp vp sg13_lv_pmos ad=0.1005p pd=1.34u as=0.1005p ps=1.34u w=0.15u l=0.13u
X256 a_33561_40066# VCO3_selection_0.NAND_3in_6.b a_33345_40066# gd sg13_lv_nmos ad=0.1005p pd=1.34u as=0.1005p ps=1.34u w=0.15u l=0.13u
X257 a_32090_26498# c0 3bit_to_8_outs_0.inverter_10.in gd sg13_lv_nmos ad=0.1005p pd=1.34u as=0.1005p ps=1.34u w=0.15u l=0.13u
X258 VCO3_selection_0.NAND_3in_7.c VCO3_selection_0.XNOR_0._a a_32570_38594# gd sg13_lv_nmos ad=0.1005p pd=1.34u as=0.1005p ps=1.34u w=0.15u l=0.13u
X259 gd VCO3_selection_0.inverter_10.out VCO3_selection_0.NAND_3in_6.a gd sg13_lv_nmos ad=0.1005p pd=1.34u as=0.1005p ps=1.34u w=0.15u l=0.13u
X260 row_section_decoding_0.NAND_2in_0.b f4 gd gd sg13_lv_nmos ad=0.1005p pd=1.34u as=0.1005p ps=1.34u w=0.15u l=0.13u
X261 VCO3_selection_0.NOR_2in_0.y VCO3_selection_0.inverter_4.out a_33278_37142# vp sg13_lv_pmos ad=0.1005p pd=1.34u as=0.1005p ps=1.34u w=0.15u l=0.13u
X262 a_32252_42496# row_section_decoding_0.f5_n gd gd sg13_lv_nmos ad=0.1005p pd=1.34u as=0.1005p ps=1.34u w=0.15u l=0.13u
X263 gd c2 a_32306_24854# gd sg13_lv_nmos ad=0.1005p pd=1.34u as=0.1005p ps=1.34u w=0.15u l=0.13u
X264 vp 3bit_to_8_outs_0.inverter_1.in 110 vp sg13_lv_pmos ad=0.1005p pd=1.34u as=0.1005p ps=1.34u w=0.15u l=0.13u
X265 a_33260_32714# VCO2_selection_0.NAND_4in_0.b a_33044_32714# gd sg13_lv_nmos ad=0.1005p pd=1.34u as=0.1005p ps=1.34u w=0.15u l=0.13u
X266 VCO3_selection_0.inverter_10.out VCO3_selection_0.NAND_3in_9.y gd gd sg13_lv_nmos ad=0.1005p pd=1.34u as=0.1005p ps=1.34u w=0.15u l=0.13u
X267 VCO5_selection_0.NAND_2in_0.b 3bit_to_8_outs_0.coarse_2 a_31519_28315# gd sg13_lv_nmos ad=0.1005p pd=1.34u as=0.1005p ps=1.34u w=0.15u l=0.13u
X268 VCO3_selection_0.NAND_3in_7.c VCO3_selection_0.XNOR_0._b a_32564_39006# vp sg13_lv_pmos ad=0.204p pd=1.88u as=0.204p ps=1.88u w=0.6u l=0.13u
X269 VCO2_11_sel VCO2_selection_0.NOR_2in_1.y vp vp sg13_lv_pmos ad=0.1005p pd=1.34u as=0.1005p ps=1.34u w=0.15u l=0.13u
X270 VCO_sel VCO_selection_0.NAND_2in_1.y vp vp sg13_lv_pmos ad=0.1005p pd=1.34u as=0.1005p ps=1.34u w=0.15u l=0.13u
X271 VCO2_selection_0.inverter_6.out VCO2_selection_0.NAND_3in_4.y gd gd sg13_lv_nmos ad=0.1005p pd=1.34u as=0.1005p ps=1.34u w=0.15u l=0.13u
X272 VCO2_selection_0.NAND_3in_3.c f0 a_31945_30758# gd sg13_lv_nmos ad=0.1005p pd=1.34u as=0.1005p ps=1.34u w=0.15u l=0.13u
X273 VCO2_selection_0.inverter_0.out VCO2_selection_0.NAND_2in_0.y gd gd sg13_lv_nmos ad=0.1005p pd=1.34u as=0.1005p ps=1.34u w=0.15u l=0.13u
X274 a_31476_49868# VCO_selection_0.NAND_2in_0.y a_31260_49868# gd sg13_lv_nmos ad=0.1005p pd=1.34u as=0.1005p ps=1.34u w=0.15u l=0.13u
X275 VCO3_selection_0.NOR_2in_0.y VCO3_selection_0.inverter_3.out gd gd sg13_lv_nmos ad=0.1005p pd=1.34u as=0.1005p ps=1.34u w=0.15u l=0.13u
X276 vp 3bit_to_8_outs_0.c2_n 3bit_to_8_outs_0.inverter_8.in vp sg13_lv_pmos ad=0.1005p pd=1.34u as=0.1005p ps=1.34u w=0.15u l=0.13u
X277 gd VCO2_selection_0.NOR_2in_0.b VCO2_selection_0.NOR_2in_0.y gd sg13_lv_nmos ad=0.1005p pd=1.34u as=0.1005p ps=1.34u w=0.15u l=0.13u
X278 VCO2_selection_0.XNOR_0._b f1 vp vp sg13_lv_pmos ad=0.1005p pd=1.34u as=0.1005p ps=1.34u w=0.15u l=0.13u
X279 vp row_section_decoding_0.after_000011 VCO4_selection_0.NAND_3in_1.y vp sg13_lv_pmos ad=0.1005p pd=1.34u as=0.1005p ps=1.34u w=0.15u l=0.13u
X280 VCO3_selection_0.NAND_3in_2.y row_section_decoding_0.f5_n vp vp sg13_lv_pmos ad=0.1005p pd=1.34u as=0.1005p ps=1.34u w=0.15u l=0.13u
X281 3bit_to_8_outs_0.inverter_1.in c1 vp vp sg13_lv_pmos ad=0.1005p pd=1.34u as=0.1005p ps=1.34u w=0.15u l=0.13u
X282 vp row_section_decoding_0.after_000011_n VCO3_selection_0.NAND_3in_7.y vp sg13_lv_pmos ad=0.1005p pd=1.34u as=0.1005p ps=1.34u w=0.15u l=0.13u
X283 VCO4_selection_0.inverter_2.in 3bit_to_8_outs_0.coarse_0 a_31276_44464# gd sg13_lv_nmos ad=0.1005p pd=1.34u as=0.1005p ps=1.34u w=0.15u l=0.13u
X284 VCO2_selection_0.NAND_4in_0.d row_section_decoding_0.after_000111_n vp vp sg13_lv_pmos ad=0.1005p pd=1.34u as=0.1005p ps=1.34u w=0.15u l=0.13u
X285 a_33085_39098# VCO3_selection_0.inverter_0.out vp vp sg13_lv_pmos ad=0.1005p pd=1.34u as=0.1005p ps=1.34u w=0.15u l=0.13u
X286 vp 101 VCO3_selection_0.NAND_2in_3.y vp sg13_lv_pmos ad=0.1005p pd=1.34u as=0.1005p ps=1.34u w=0.15u l=0.13u
X287 VCO4_selection_0.NAND_2in_0.a VCO4_selection_0.inverter_2.out gd gd sg13_lv_nmos ad=0.1005p pd=1.34u as=0.1005p ps=1.34u w=0.15u l=0.13u
X288 VCO2_selection_0.inverter_3.in row_section_decoding_0.after_000011_n vp vp sg13_lv_pmos ad=0.1005p pd=1.34u as=0.1005p ps=1.34u w=0.15u l=0.13u
X289 a_31788_40540# row_section_decoding_0.after_000011 a_31572_40540# gd sg13_lv_nmos ad=0.1005p pd=1.34u as=0.1005p ps=1.34u w=0.15u l=0.13u
X290 gd f5 row_section_decoding_0.after_000111_n gd sg13_lv_nmos ad=0.1005p pd=1.34u as=0.1005p ps=1.34u w=0.15u l=0.13u
X291 vp row_section_decoding_0.after_000011_n VCO5_selection_0.NAND_2in_0.b vp sg13_lv_pmos ad=0.1005p pd=1.34u as=0.1005p ps=1.34u w=0.15u l=0.13u
X292 a_32306_25172# 3bit_to_8_outs_0.c1_n a_32090_25172# gd sg13_lv_nmos ad=0.1005p pd=1.34u as=0.1005p ps=1.34u w=0.15u l=0.13u
X293 a_32052_48788# VCO4_selection_0.XNOR_0._a vp vp sg13_lv_pmos ad=0.204p pd=1.88u as=0.204p ps=1.88u w=0.6u l=0.13u
X294 a_31276_46420# VCO4_selection_0.XNOR_0.y a_31060_46420# gd sg13_lv_nmos ad=0.1005p pd=1.34u as=0.1005p ps=1.34u w=0.15u l=0.13u
X295 gd VCO4_selection_0.inverter_0.out VCO4_selection_0.NAND_2in_0.a gd sg13_lv_nmos ad=0.1005p pd=1.34u as=0.1005p ps=1.34u w=0.15u l=0.13u
X296 a_32306_26816# 3bit_to_8_outs_0.c1_n a_32090_26816# gd sg13_lv_nmos ad=0.1005p pd=1.34u as=0.1005p ps=1.34u w=0.15u l=0.13u
X297 vp 3bit_to_8_outs_0.inverter_6.in 100 vp sg13_lv_pmos ad=0.1005p pd=1.34u as=0.1005p ps=1.34u w=0.15u l=0.13u
X298 vp 3bit_to_8_outs_0.c2_n 3bit_to_8_outs_0.NAND_3in_6.y vp sg13_lv_pmos ad=0.1005p pd=1.34u as=0.1005p ps=1.34u w=0.15u l=0.13u
X299 gd VCO2_selection_0.NOR_2in_2.b VCO2_selection_0.NOR_2in_2.y gd sg13_lv_nmos ad=0.1005p pd=1.34u as=0.1005p ps=1.34u w=0.15u l=0.13u
X300 a_32570_40066# f1 gd gd sg13_lv_nmos ad=0.1005p pd=1.34u as=0.1005p ps=1.34u w=0.15u l=0.13u
X301 VCO2_selection_0.NAND_4in_0.b 101 a_32368_32714# gd sg13_lv_nmos ad=0.1005p pd=1.34u as=0.1005p ps=1.34u w=0.15u l=0.13u
X302 gd VCO3_selection_0.inverter_2.out VCO3_selection_0.NOR_2in_1.y gd sg13_lv_nmos ad=0.1005p pd=1.34u as=0.1005p ps=1.34u w=0.15u l=0.13u
X303 vp row_section_decoding_0.after_001111 VCO_selection_0.NAND_2in_0.y vp sg13_lv_pmos ad=0.1005p pd=1.34u as=0.1005p ps=1.34u w=0.15u l=0.13u
X304 vp VCO4_selection_0.NAND_2in_0.a VCO4_5_sel vp sg13_lv_pmos ad=0.1005p pd=1.34u as=0.1005p ps=1.34u w=0.15u l=0.13u
X305 vp VCO5_selection_0.inverter_2.out VCO5_selection_0.inverter_0.in vp sg13_lv_pmos ad=0.1005p pd=1.34u as=0.1005p ps=1.34u w=0.15u l=0.13u
X306 VCO2_selection_0.NOR_2in_1.y VCO2_selection_0.inverter_1.out gd gd sg13_lv_nmos ad=0.1005p pd=1.34u as=0.1005p ps=1.34u w=0.15u l=0.13u
X307 VCO3_selection_0.NAND_3in_3.y 3bit_to_8_outs_0.coarse_3 vp vp sg13_lv_pmos ad=0.1005p pd=1.34u as=0.1005p ps=1.34u w=0.15u l=0.13u
X308 gd 3bit_to_8_outs_0.NAND_3in_6.y 3bit_to_8_outs_0.coarse_2 gd sg13_lv_nmos ad=0.1005p pd=1.34u as=0.1005p ps=1.34u w=0.15u l=0.13u
X309 VCO5_selection_0.inverter_1.out VCO5_selection_0.inverter_1.in vp vp sg13_lv_pmos ad=0.1005p pd=1.34u as=0.1005p ps=1.34u w=0.15u l=0.13u
X310 VCO2_selection_0.NOR_2in_2.a VCO2_selection_0.inverter_2.in gd gd sg13_lv_nmos ad=0.1005p pd=1.34u as=0.1005p ps=1.34u w=0.15u l=0.13u
X311 VCO3_5_sel VCO3_selection_0.NAND_3in_6.c vp vp sg13_lv_pmos ad=0.1005p pd=1.34u as=0.1005p ps=1.34u w=0.15u l=0.13u
X312 VCO4_selection_0.XNOR_1._a f0 gd gd sg13_lv_nmos ad=0.1005p pd=1.34u as=0.1005p ps=1.34u w=0.15u l=0.13u
X313 gd VCO5_selection_0.inverter_1.out VCO5_selection_0.NOR_2in_0.y gd sg13_lv_nmos ad=0.1005p pd=1.34u as=0.1005p ps=1.34u w=0.15u l=0.13u
X314 vp row_section_decoding_0.after_000111 VCO4_selection_0.inverter_2.in vp sg13_lv_pmos ad=0.1005p pd=1.34u as=0.1005p ps=1.34u w=0.15u l=0.13u
X315 vp 3bit_to_8_outs_0.coarse_0 VCO5_selection_0.inverter_1.in vp sg13_lv_pmos ad=0.1005p pd=1.34u as=0.1005p ps=1.34u w=0.15u l=0.13u
X316 a_32556_28789# row_section_decoding_0.after_000011_n gd gd sg13_lv_nmos ad=0.1005p pd=1.34u as=0.1005p ps=1.34u w=0.15u l=0.13u
X317 a_31407_30284# row_section_decoding_0.after_000111_n gd gd sg13_lv_nmos ad=0.1005p pd=1.34u as=0.1005p ps=1.34u w=0.15u l=0.13u
X318 VCO2_selection_0.NOR_2in_1.y VCO2_selection_0.inverter_0.out a_33113_33692# vp sg13_lv_pmos ad=0.1005p pd=1.34u as=0.1005p ps=1.34u w=0.15u l=0.13u
X319 a_31572_36164# row_section_decoding_0.after_000111_n gd gd sg13_lv_nmos ad=0.1005p pd=1.34u as=0.1005p ps=1.34u w=0.15u l=0.13u
X320 VCO3_selection_0.inverter_11.out VCO3_selection_0.NAND_3in_5.y vp vp sg13_lv_pmos ad=0.1005p pd=1.34u as=0.1005p ps=1.34u w=0.15u l=0.13u
X321 VCO4_selection_0.NOR_2in_0.a VCO4_selection_0.NAND_3in_2.y vp vp sg13_lv_pmos ad=0.1005p pd=1.34u as=0.1005p ps=1.34u w=0.15u l=0.13u
X322 VCO2_selection_0.NAND_2in_0.y 3bit_to_8_outs_0.coarse_3 a_32093_34196# gd sg13_lv_nmos ad=0.1005p pd=1.34u as=0.1005p ps=1.34u w=0.15u l=0.13u
X323 VCO3_selection_0.XNOR_1._b f1 vp vp sg13_lv_pmos ad=0.1005p pd=1.34u as=0.1005p ps=1.34u w=0.15u l=0.13u
X324 a_31626_26498# c1 a_31410_26498# gd sg13_lv_nmos ad=0.1005p pd=1.34u as=0.1005p ps=1.34u w=0.15u l=0.13u
X325 a_32563_32240# row_section_decoding_0.after_000111_n gd gd sg13_lv_nmos ad=0.1005p pd=1.34u as=0.1005p ps=1.34u w=0.15u l=0.13u
X326 VCO2_11_sel VCO2_selection_0.NOR_2in_1.y a_33589_34670# gd sg13_lv_nmos ad=0.1005p pd=1.34u as=0.1005p ps=1.34u w=0.15u l=0.13u
X327 VCO4_selection_0.XNOR_0._a f0 gd gd sg13_lv_nmos ad=0.1005p pd=1.34u as=0.1005p ps=1.34u w=0.15u l=0.13u
X328 VCO5_selection_0.XNOR_0._a f0 gd gd sg13_lv_nmos ad=0.1005p pd=1.34u as=0.1005p ps=1.34u w=0.15u l=0.13u
X329 a_31986_22377# f4 vp vp sg13_lv_pmos ad=0.1005p pd=1.34u as=0.1005p ps=1.34u w=0.15u l=0.13u
X330 VCO3_5_sel VCO3_selection_0.NAND_3in_6.a vp vp sg13_lv_pmos ad=0.1005p pd=1.34u as=0.1005p ps=1.34u w=0.15u l=0.13u
X331 vp c0 3bit_to_8_outs_0.inverter_10.in vp sg13_lv_pmos ad=0.1005p pd=1.34u as=0.1005p ps=1.34u w=0.15u l=0.13u
X332 vp VCO3_selection_0.NOR_2in_1.y VCO3_11_sel vp sg13_lv_pmos ad=0.1005p pd=1.34u as=0.1005p ps=1.34u w=0.15u l=0.13u
X333 a_30774_23859# f2 vp vp sg13_lv_pmos ad=0.1005p pd=1.34u as=0.1005p ps=1.34u w=0.15u l=0.13u
X334 VCO2_selection_0.NAND_3in_3.y 110 a_32303_30284# gd sg13_lv_nmos ad=0.1005p pd=1.34u as=0.1005p ps=1.34u w=0.15u l=0.13u
X335 VCO3_selection_0.NAND_3in_0.c VCO3_selection_0.inverter_0.out gd gd sg13_lv_nmos ad=0.1005p pd=1.34u as=0.1005p ps=1.34u w=0.15u l=0.13u
X336 VCO3_selection_0.NAND_3in_8.y VCO3_selection_0.inverter_12.out vp vp sg13_lv_pmos ad=0.1005p pd=1.34u as=0.1005p ps=1.34u w=0.15u l=0.13u
X337 VCO3_selection_0.NAND_2in_0.y f5 vp vp sg13_lv_pmos ad=0.1005p pd=1.34u as=0.1005p ps=1.34u w=0.15u l=0.13u
X338 VCO3_selection_0.NAND_3in_2.y 3bit_to_8_outs_0.coarse_1 a_31788_36638# gd sg13_lv_nmos ad=0.1005p pd=1.34u as=0.1005p ps=1.34u w=0.15u l=0.13u
X339 a_31883_34670# row_section_decoding_0.after_000011_n gd gd sg13_lv_nmos ad=0.1005p pd=1.34u as=0.1005p ps=1.34u w=0.15u l=0.13u
X340 VCO3_selection_0.inverter_4.out VCO3_selection_0.inverter_4.in vp vp sg13_lv_pmos ad=0.1005p pd=1.34u as=0.1005p ps=1.34u w=0.15u l=0.13u
X341 VCO4_5_sel VCO4_selection_0.NAND_2in_0.a a_32494_43990# gd sg13_lv_nmos ad=0.1005p pd=1.34u as=0.1005p ps=1.34u w=0.15u l=0.13u
X342 VCO3_selection_0.inverter_8.out VCO3_selection_0.NAND_3in_8.y vp vp sg13_lv_pmos ad=0.1005p pd=1.34u as=0.1005p ps=1.34u w=0.15u l=0.13u
X343 VCO3_selection_0.inverter_11.out VCO3_selection_0.NAND_3in_5.y gd gd sg13_lv_nmos ad=0.1005p pd=1.34u as=0.1005p ps=1.34u w=0.15u l=0.13u
X344 VCO4_selection_0.NAND_3in_0.y 3bit_to_8_outs_0.coarse_2 vp vp sg13_lv_pmos ad=0.1005p pd=1.34u as=0.1005p ps=1.34u w=0.15u l=0.13u
X345 vp 3bit_to_8_outs_0.c0_n 3bit_to_8_outs_0.inverter_1.in vp sg13_lv_pmos ad=0.1005p pd=1.34u as=0.1005p ps=1.34u w=0.15u l=0.13u
X346 VCO2_selection_0.NAND_3in_5.c VCO2_selection_0.inverter_4.out a_32920_31262# vp sg13_lv_pmos ad=0.1005p pd=1.34u as=0.1005p ps=1.34u w=0.15u l=0.13u
X347 VCO5_selection_0.NAND_2in_0.b 3bit_to_8_outs_0.coarse_2 vp vp sg13_lv_pmos ad=0.1005p pd=1.34u as=0.1005p ps=1.34u w=0.15u l=0.13u
X348 a_32468_38120# row_section_decoding_0.after_000011_n a_32252_38120# gd sg13_lv_nmos ad=0.1005p pd=1.34u as=0.1005p ps=1.34u w=0.15u l=0.13u
X349 VCO4_selection_0.XNOR_0.y f1 a_31592_48788# vp sg13_lv_pmos ad=0.204p pd=1.88u as=0.204p ps=1.88u w=0.6u l=0.13u
X350 a_32018_43486# VCO4_selection_0.NOR_2in_0.a vp vp sg13_lv_pmos ad=0.1005p pd=1.34u as=0.1005p ps=1.34u w=0.15u l=0.13u
X351 a_31877_32240# row_section_decoding_0.after_000111_n gd gd sg13_lv_nmos ad=0.1005p pd=1.34u as=0.1005p ps=1.34u w=0.15u l=0.13u
X352 VCO3_selection_0.NAND_2in_3.y 101 a_32048_42022# gd sg13_lv_nmos ad=0.1005p pd=1.34u as=0.1005p ps=1.34u w=0.15u l=0.13u
X353 VCO2_selection_0.NAND_4in_0.a 110 vp vp sg13_lv_pmos ad=0.1005p pd=1.34u as=0.1005p ps=1.34u w=0.15u l=0.13u
X354 VCO2_selection_0.inverter_0.out VCO2_selection_0.NAND_2in_0.y vp vp sg13_lv_pmos ad=0.1005p pd=1.34u as=0.1005p ps=1.34u w=0.15u l=0.13u
X355 vp row_section_decoding_0.after_000111 VCO2_selection_0.NAND_4in_0.b vp sg13_lv_pmos ad=0.1005p pd=1.34u as=0.1005p ps=1.34u w=0.15u l=0.13u
X356 vp row_section_decoding_0.after_000011 VCO4_selection_0.inverter_3.in vp sg13_lv_pmos ad=0.1005p pd=1.34u as=0.1005p ps=1.34u w=0.15u l=0.13u
X357 VCO4_selection_0.NAND_2in_0.b VCO4_selection_0.NOR_2in_0.b a_32018_43486# vp sg13_lv_pmos ad=0.1005p pd=1.34u as=0.1005p ps=1.34u w=0.15u l=0.13u
X358 VCO4_11_sel VCO4_selection_0.NAND_3in_1.y gd gd sg13_lv_nmos ad=0.1005p pd=1.34u as=0.1005p ps=1.34u w=0.15u l=0.13u
X359 VCO4_selection_0.inverter_5.in f0 a_31598_47902# gd sg13_lv_nmos ad=0.1005p pd=1.34u as=0.1005p ps=1.34u w=0.15u l=0.13u
X360 VCO2_selection_0.NAND_3in_3.c VCO2_selection_0.XNOR_0._a a_32405_30758# gd sg13_lv_nmos ad=0.1005p pd=1.34u as=0.1005p ps=1.34u w=0.15u l=0.13u
X361 VCO3_selection_0.NAND_3in_5.y row_section_decoding_0.after_001111_n vp vp sg13_lv_pmos ad=0.1005p pd=1.34u as=0.1005p ps=1.34u w=0.15u l=0.13u
X362 vp c2 3bit_to_8_outs_0.NAND_3in_0.y vp sg13_lv_pmos ad=0.1005p pd=1.34u as=0.1005p ps=1.34u w=0.15u l=0.13u
X363 VCO5_11_sel VCO5_selection_0.NOR_2in_0.y a_33013_28315# gd sg13_lv_nmos ad=0.1005p pd=1.34u as=0.1005p ps=1.34u w=0.15u l=0.13u
X364 gd 3bit_to_8_outs_0.inverter_6.in 100 gd sg13_lv_nmos ad=0.1005p pd=1.34u as=0.1005p ps=1.34u w=0.15u l=0.13u
X365 VCO3_selection_0.NAND_3in_3.y 3bit_to_8_outs_0.coarse_3 a_31788_38120# gd sg13_lv_nmos ad=0.1005p pd=1.34u as=0.1005p ps=1.34u w=0.15u l=0.13u
X366 VCO4_selection_0.XNOR_0.y f0 a_31598_48376# gd sg13_lv_nmos ad=0.1005p pd=1.34u as=0.1005p ps=1.34u w=0.15u l=0.13u
X367 row_section_decoding_0.f1_n f1 vp vp sg13_lv_pmos ad=0.1005p pd=1.34u as=0.1005p ps=1.34u w=0.15u l=0.13u
X368 a_33278_37142# VCO3_selection_0.inverter_3.out vp vp sg13_lv_pmos ad=0.1005p pd=1.34u as=0.1005p ps=1.34u w=0.15u l=0.13u
X369 VCO3_selection_0.NOR_2in_4.a VCO3_selection_0.NAND_2in_0.y vp vp sg13_lv_pmos ad=0.1005p pd=1.34u as=0.1005p ps=1.34u w=0.15u l=0.13u
X370 VCO4_selection_0.NAND_3in_2.y row_section_decoding_0.after_000011_n vp vp sg13_lv_pmos ad=0.1005p pd=1.34u as=0.1005p ps=1.34u w=0.15u l=0.13u
X371 gd 3bit_to_8_outs_0.inverter_8.in 3bit_to_8_outs_0.coarse_0 gd sg13_lv_nmos ad=0.1005p pd=1.34u as=0.1005p ps=1.34u w=0.15u l=0.13u
X372 gd c1 3bit_to_8_outs_0.c1_n gd sg13_lv_nmos ad=0.1005p pd=1.34u as=0.1005p ps=1.34u w=0.15u l=0.13u
X373 a_32306_24854# c1 a_32090_24854# gd sg13_lv_nmos ad=0.1005p pd=1.34u as=0.1005p ps=1.34u w=0.15u l=0.13u
X374 VCO2_selection_0.NOR_2in_0.b VCO2_selection_0.NAND_3in_7.y vp vp sg13_lv_pmos ad=0.1005p pd=1.34u as=0.1005p ps=1.34u w=0.15u l=0.13u
X375 VCO2_selection_0.NAND_3in_5.c VCO2_selection_0.inverter_6.out gd gd sg13_lv_nmos ad=0.1005p pd=1.34u as=0.1005p ps=1.34u w=0.15u l=0.13u
X376 VCO_selection_0.NAND_2in_2.y 101 a_30790_50186# gd sg13_lv_nmos ad=0.1005p pd=1.34u as=0.1005p ps=1.34u w=0.15u l=0.13u
X377 row_section_decoding_0.after_001111_n f4 gd gd sg13_lv_nmos ad=0.1005p pd=1.34u as=0.1005p ps=1.34u w=0.15u l=0.13u
X378 vp VCO2_selection_0.NOR_2in_2.y VCO2_11_sel vp sg13_lv_pmos ad=0.1005p pd=1.34u as=0.1005p ps=1.34u w=0.15u l=0.13u
X379 VCO3_selection_0.NOR_2in_1.y VCO3_selection_0.inverter_2.out a_33278_35660# vp sg13_lv_pmos ad=0.1005p pd=1.34u as=0.1005p ps=1.34u w=0.15u l=0.13u
X380 VCO3_selection_0.inverter_2.out VCO3_selection_0.NAND_3in_1.y gd gd sg13_lv_nmos ad=0.1005p pd=1.34u as=0.1005p ps=1.34u w=0.15u l=0.13u
X381 vp VCO_selection_0.NAND_2in_0.y VCO_sel vp sg13_lv_pmos ad=0.1005p pd=1.34u as=0.1005p ps=1.34u w=0.15u l=0.13u
X382 VCO2_selection_0.NAND_4in_0.d 111 vp vp sg13_lv_pmos ad=0.1005p pd=1.34u as=0.1005p ps=1.34u w=0.15u l=0.13u
X383 a_33113_33692# VCO2_selection_0.inverter_1.out vp vp sg13_lv_pmos ad=0.1005p pd=1.34u as=0.1005p ps=1.34u w=0.15u l=0.13u
X384 VCO4_selection_0.XNOR_1._b f1 gd gd sg13_lv_nmos ad=0.1005p pd=1.34u as=0.1005p ps=1.34u w=0.15u l=0.13u
X385 vp 3bit_to_8_outs_0.NAND_3in_6.y 3bit_to_8_outs_0.coarse_2 vp sg13_lv_pmos ad=0.1005p pd=1.34u as=0.1005p ps=1.34u w=0.15u l=0.13u
X386 3bit_to_8_outs_0.inverter_8.in 3bit_to_8_outs_0.c1_n vp vp sg13_lv_pmos ad=0.1005p pd=1.34u as=0.1005p ps=1.34u w=0.15u l=0.13u
X387 vp row_section_decoding_0.after_000011_n VCO2_selection_0.NAND_3in_3.y vp sg13_lv_pmos ad=0.1005p pd=1.34u as=0.1005p ps=1.34u w=0.15u l=0.13u
X388 VCO4_selection_0.NAND_3in_0.y 3bit_to_8_outs_0.coarse_2 a_31276_43990# gd sg13_lv_nmos ad=0.1005p pd=1.34u as=0.1005p ps=1.34u w=0.15u l=0.13u
X389 a_31410_26498# 3bit_to_8_outs_0.c0_n 3bit_to_8_outs_0.NAND_3in_6.y gd sg13_lv_nmos ad=0.1005p pd=1.34u as=0.1005p ps=1.34u w=0.15u l=0.13u
X390 VCO4_selection_0.XNOR_1._a f0 vp vp sg13_lv_pmos ad=0.1005p pd=1.34u as=0.1005p ps=1.34u w=0.15u l=0.13u
X391 a_31276_44464# row_section_decoding_0.after_000111 a_31060_44464# gd sg13_lv_nmos ad=0.1005p pd=1.34u as=0.1005p ps=1.34u w=0.15u l=0.13u
X392 a_32494_44968# VCO4_selection_0.NOR_2in_1.a vp vp sg13_lv_pmos ad=0.1005p pd=1.34u as=0.1005p ps=1.34u w=0.15u l=0.13u
X393 VCO3_selection_0.NAND_3in_9.y 3bit_to_8_outs_0.coarse_2 vp vp sg13_lv_pmos ad=0.1005p pd=1.34u as=0.1005p ps=1.34u w=0.15u l=0.13u
X394 a_32252_40540# VCO3_selection_0.inverter_12.out gd gd sg13_lv_nmos ad=0.1005p pd=1.34u as=0.1005p ps=1.34u w=0.15u l=0.13u
X395 VCO5_selection_0.NOR_2in_0.y VCO5_selection_0.inverter_1.out a_32537_27811# vp sg13_lv_pmos ad=0.1005p pd=1.34u as=0.1005p ps=1.34u w=0.15u l=0.13u
X396 a_31572_42496# row_section_decoding_0.after_001111_n gd gd sg13_lv_nmos ad=0.1005p pd=1.34u as=0.1005p ps=1.34u w=0.15u l=0.13u
X397 VCO4_selection_0.XNOR_0._a f0 vp vp sg13_lv_pmos ad=0.1005p pd=1.34u as=0.1005p ps=1.34u w=0.15u l=0.13u
X398 VCO4_selection_0.NAND_2in_0.b VCO4_selection_0.NOR_2in_0.a gd gd sg13_lv_nmos ad=0.1005p pd=1.34u as=0.1005p ps=1.34u w=0.15u l=0.13u
X399 VCO4_selection_0.XNOR_0._b f1 gd gd sg13_lv_nmos ad=0.1005p pd=1.34u as=0.1005p ps=1.34u w=0.15u l=0.13u
X400 row_section_decoding_0.after_000011 row_section_decoding_0.NAND_2in_0.b vp vp sg13_lv_pmos ad=0.1005p pd=1.34u as=0.1005p ps=1.34u w=0.15u l=0.13u
X401 VCO3_selection_0.inverter_8.out VCO3_selection_0.NAND_3in_8.y gd gd sg13_lv_nmos ad=0.1005p pd=1.34u as=0.1005p ps=1.34u w=0.15u l=0.13u
X402 VCO3_selection_0.NAND_2in_3.y row_section_decoding_0.after_000011_n vp vp sg13_lv_pmos ad=0.1005p pd=1.34u as=0.1005p ps=1.34u w=0.15u l=0.13u
X403 VCO4_selection_0.NOR_2in_0.a VCO4_selection_0.NAND_3in_2.y gd gd sg13_lv_nmos ad=0.1005p pd=1.34u as=0.1005p ps=1.34u w=0.15u l=0.13u
X404 gd VCO4_selection_0.NOR_2in_0.b VCO4_selection_0.NAND_2in_0.b gd sg13_lv_nmos ad=0.1005p pd=1.34u as=0.1005p ps=1.34u w=0.15u l=0.13u
X405 VCO3_selection_0.NAND_3in_1.y row_section_decoding_0.after_000111_n vp vp sg13_lv_pmos ad=0.1005p pd=1.34u as=0.1005p ps=1.34u w=0.15u l=0.13u
X406 vp 3bit_to_8_outs_0.coarse_3 VCO2_selection_0.NAND_2in_0.y vp sg13_lv_pmos ad=0.1005p pd=1.34u as=0.1005p ps=1.34u w=0.15u l=0.13u
X407 vp c2 3bit_to_8_outs_0.NAND_3in_3.y vp sg13_lv_pmos ad=0.1005p pd=1.34u as=0.1005p ps=1.34u w=0.15u l=0.13u
X408 3bit_to_8_outs_0.NAND_3in_6.y c1 vp vp sg13_lv_pmos ad=0.1005p pd=1.34u as=0.1005p ps=1.34u w=0.15u l=0.13u
X409 VCO4_selection_0.inverter_5.in VCO4_selection_0.XNOR_1._b a_32052_47400# vp sg13_lv_pmos ad=0.204p pd=1.88u as=0.204p ps=1.88u w=0.6u l=0.13u
X410 a_33692_38120# VCO3_selection_0.NOR_2in_1.y a_33476_38120# gd sg13_lv_nmos ad=0.1005p pd=1.34u as=0.1005p ps=1.34u w=0.15u l=0.13u
X411 a_31572_42022# f5 gd gd sg13_lv_nmos ad=0.1005p pd=1.34u as=0.1005p ps=1.34u w=0.15u l=0.13u
X412 a_31775_29201# VCO5_selection_0.XNOR_0._a vp vp sg13_lv_pmos ad=0.204p pd=1.88u as=0.204p ps=1.88u w=0.6u l=0.13u
X413 VCO2_selection_0.NAND_4in_0.a 110 a_31623_32714# gd sg13_lv_nmos ad=0.1005p pd=1.34u as=0.1005p ps=1.34u w=0.15u l=0.13u
X414 a_32368_32714# row_section_decoding_0.after_000111 a_32152_32714# gd sg13_lv_nmos ad=0.1005p pd=1.34u as=0.1005p ps=1.34u w=0.15u l=0.13u
X415 VCO3_selection_0.NOR_2in_1.y VCO3_selection_0.inverter_1.out gd gd sg13_lv_nmos ad=0.1005p pd=1.34u as=0.1005p ps=1.34u w=0.15u l=0.13u
X416 a_31740_45946# row_section_decoding_0.after_000111_n gd gd sg13_lv_nmos ad=0.1005p pd=1.34u as=0.1005p ps=1.34u w=0.15u l=0.13u
X417 VCO2_selection_0.NAND_3in_4.y 101 vp vp sg13_lv_pmos ad=0.1005p pd=1.34u as=0.1005p ps=1.34u w=0.15u l=0.13u
X418 VCO2_selection_0.inverter_1.in 100 a_31623_34196# gd sg13_lv_nmos ad=0.1005p pd=1.34u as=0.1005p ps=1.34u w=0.15u l=0.13u
X419 gd 3bit_to_8_outs_0.c2_n a_32306_26498# gd sg13_lv_nmos ad=0.1005p pd=1.34u as=0.1005p ps=1.34u w=0.15u l=0.13u
X420 row_section_decoding_0.after_000111 row_section_decoding_0.after_000111_n vp vp sg13_lv_pmos ad=0.1005p pd=1.34u as=0.1005p ps=1.34u w=0.15u l=0.13u
X421 VCO5_selection_0.inverter_0.in row_section_decoding_0.after_000011_n vp vp sg13_lv_pmos ad=0.1005p pd=1.34u as=0.1005p ps=1.34u w=0.15u l=0.13u
X422 vp row_section_decoding_0.after_000011 VCO3_selection_0.NAND_3in_3.y vp sg13_lv_pmos ad=0.1005p pd=1.34u as=0.1005p ps=1.34u w=0.15u l=0.13u
X423 VCO3_selection_0.NAND_3in_9.y 3bit_to_8_outs_0.coarse_2 a_32468_42496# gd sg13_lv_nmos ad=0.1005p pd=1.34u as=0.1005p ps=1.34u w=0.15u l=0.13u
X424 row_section_decoding_0.NAND_2in_0.a f2 gd gd sg13_lv_nmos ad=0.1005p pd=1.34u as=0.1005p ps=1.34u w=0.15u l=0.13u
X425 vp row_section_decoding_0.after_001111_n VCO2_selection_0.NAND_4in_0.a vp sg13_lv_pmos ad=0.1005p pd=1.34u as=0.1005p ps=1.34u w=0.15u l=0.13u
X426 VCO3_selection_0.inverter_4.in 3bit_to_8_outs_0.coarse_0 a_32258_36638# gd sg13_lv_nmos ad=0.1005p pd=1.34u as=0.1005p ps=1.34u w=0.15u l=0.13u
X427 VCO3_selection_0.inverter_7.out VCO3_selection_0.NAND_3in_4.y vp vp sg13_lv_pmos ad=0.1005p pd=1.34u as=0.1005p ps=1.34u w=0.15u l=0.13u
X428 VCO5_selection_0.inverter_2.in f0 a_31321_28789# gd sg13_lv_nmos ad=0.1005p pd=1.34u as=0.1005p ps=1.34u w=0.15u l=0.13u
X429 VCO5_selection_0.NOR_2in_0.y VCO5_selection_0.inverter_0.out gd gd sg13_lv_nmos ad=0.1005p pd=1.34u as=0.1005p ps=1.34u w=0.15u l=0.13u
X430 VCO5_selection_0.XNOR_0._a f0 vp vp sg13_lv_pmos ad=0.1005p pd=1.34u as=0.1005p ps=1.34u w=0.15u l=0.13u
X431 a_30790_49868# 110 gd gd sg13_lv_nmos ad=0.1005p pd=1.34u as=0.1005p ps=1.34u w=0.15u l=0.13u
X432 a_33589_34670# VCO2_selection_0.NOR_2in_2.y a_33373_34670# gd sg13_lv_nmos ad=0.1005p pd=1.34u as=0.1005p ps=1.34u w=0.15u l=0.13u
X433 VCO3_selection_0.NAND_3in_2.y 3bit_to_8_outs_0.coarse_1 vp vp sg13_lv_pmos ad=0.1005p pd=1.34u as=0.1005p ps=1.34u w=0.15u l=0.13u
X434 VCO3_selection_0.XNOR_1._a f0 gd gd sg13_lv_nmos ad=0.1005p pd=1.34u as=0.1005p ps=1.34u w=0.15u l=0.13u
X435 a_31592_47400# f0 vp vp sg13_lv_pmos ad=0.204p pd=1.88u as=0.204p ps=1.88u w=0.6u l=0.13u
X436 vp 3bit_to_8_outs_0.coarse_2 VCO2_selection_0.inverter_2.in vp sg13_lv_pmos ad=0.1005p pd=1.34u as=0.1005p ps=1.34u w=0.15u l=0.13u
X437 VCO3_selection_0.NOR_2in_4.a VCO3_selection_0.NAND_2in_0.y gd gd sg13_lv_nmos ad=0.1005p pd=1.34u as=0.1005p ps=1.34u w=0.15u l=0.13u
X438 a_31303_28315# row_section_decoding_0.f1_n gd gd sg13_lv_nmos ad=0.1005p pd=1.34u as=0.1005p ps=1.34u w=0.15u l=0.13u
X439 vp 101 VCO_selection_0.NAND_2in_2.y vp sg13_lv_pmos ad=0.1005p pd=1.34u as=0.1005p ps=1.34u w=0.15u l=0.13u
X440 vp VCO2_selection_0.NAND_4in_0.c VCO2_5_sel vp sg13_lv_pmos ad=0.1005p pd=1.34u as=0.1005p ps=1.34u w=0.15u l=0.13u
X441 vp 3bit_to_8_outs_0.c0_n 3bit_to_8_outs_0.inverter_6.in vp sg13_lv_pmos ad=0.1005p pd=1.34u as=0.1005p ps=1.34u w=0.15u l=0.13u
X442 VCO4_selection_0.inverter_4.in row_section_decoding_0.after_000011_n vp vp sg13_lv_pmos ad=0.1005p pd=1.34u as=0.1005p ps=1.34u w=0.15u l=0.13u
X443 VCO2_selection_0.NOR_2in_2.b VCO2_selection_0.inverter_3.in vp vp sg13_lv_pmos ad=0.1005p pd=1.34u as=0.1005p ps=1.34u w=0.15u l=0.13u
X444 VCO3_11_sel VCO3_selection_0.NAND_3in_0.c vp vp sg13_lv_pmos ad=0.1005p pd=1.34u as=0.1005p ps=1.34u w=0.15u l=0.13u
X445 row_section_decoding_0.f1_n f1 gd gd sg13_lv_nmos ad=0.1005p pd=1.34u as=0.1005p ps=1.34u w=0.15u l=0.13u
X446 VCO2_selection_0.NAND_4in_0.d 111 a_32093_32240# gd sg13_lv_nmos ad=0.1005p pd=1.34u as=0.1005p ps=1.34u w=0.15u l=0.13u
X447 a_31788_36638# row_section_decoding_0.after_000111 a_31572_36638# gd sg13_lv_nmos ad=0.1005p pd=1.34u as=0.1005p ps=1.34u w=0.15u l=0.13u
X448 a_31740_46420# row_section_decoding_0.after_000011_n gd gd sg13_lv_nmos ad=0.1005p pd=1.34u as=0.1005p ps=1.34u w=0.15u l=0.13u
X449 vp VCO5_selection_0.NOR_2in_0.y VCO5_11_sel vp sg13_lv_pmos ad=0.1005p pd=1.34u as=0.1005p ps=1.34u w=0.15u l=0.13u
X450 row_section_decoding_0.after_000111_n f4 a_30990_22377# vp sg13_lv_pmos ad=0.1005p pd=1.34u as=0.1005p ps=1.34u w=0.15u l=0.13u
X451 VCO2_selection_0.NAND_3in_7.y 110 vp vp sg13_lv_pmos ad=0.1005p pd=1.34u as=0.1005p ps=1.34u w=0.15u l=0.13u
X452 vp c1 3bit_to_8_outs_0.c1_n vp sg13_lv_pmos ad=0.1005p pd=1.34u as=0.1005p ps=1.34u w=0.15u l=0.13u
X453 gd 3bit_to_8_outs_0.NAND_3in_0.y 111 gd sg13_lv_nmos ad=0.1005p pd=1.34u as=0.1005p ps=1.34u w=0.15u l=0.13u
X454 vp row_section_decoding_0.after_000011_n VCO4_selection_0.NAND_3in_0.y vp sg13_lv_pmos ad=0.1005p pd=1.34u as=0.1005p ps=1.34u w=0.15u l=0.13u
X455 VCO3_selection_0.inverter_12.out VCO3_selection_0.XNOR_1.y vp vp sg13_lv_pmos ad=0.1005p pd=1.34u as=0.1005p ps=1.34u w=0.15u l=0.13u
X456 VCO5_selection_0.XNOR_0._b f1 gd gd sg13_lv_nmos ad=0.1005p pd=1.34u as=0.1005p ps=1.34u w=0.15u l=0.13u
X457 VCO3_selection_0.inverter_2.out VCO3_selection_0.NAND_3in_1.y vp vp sg13_lv_pmos ad=0.1005p pd=1.34u as=0.1005p ps=1.34u w=0.15u l=0.13u
X458 VCO4_selection_0.XNOR_1._b f1 vp vp sg13_lv_pmos ad=0.1005p pd=1.34u as=0.1005p ps=1.34u w=0.15u l=0.13u
X459 VCO4_11_sel VCO4_selection_0.NAND_3in_1.y vp vp sg13_lv_pmos ad=0.1005p pd=1.34u as=0.1005p ps=1.34u w=0.15u l=0.13u
X460 a_32048_42022# row_section_decoding_0.after_000011_n gd gd sg13_lv_nmos ad=0.1005p pd=1.34u as=0.1005p ps=1.34u w=0.15u l=0.13u
X461 VCO4_selection_0.XNOR_0._b f1 vp vp sg13_lv_pmos ad=0.1005p pd=1.34u as=0.1005p ps=1.34u w=0.15u l=0.13u
X462 VCO5_selection_0.inverter_2.out VCO5_selection_0.inverter_2.in gd gd sg13_lv_nmos ad=0.1005p pd=1.34u as=0.1005p ps=1.34u w=0.15u l=0.13u
X463 vp 3bit_to_8_outs_0.inverter_8.in 3bit_to_8_outs_0.coarse_0 vp sg13_lv_pmos ad=0.1005p pd=1.34u as=0.1005p ps=1.34u w=0.15u l=0.13u
X464 a_31598_47902# VCO4_selection_0.XNOR_1._b gd gd sg13_lv_nmos ad=0.1005p pd=1.34u as=0.1005p ps=1.34u w=0.15u l=0.13u
X465 vp 3bit_to_8_outs_0.c0_n 3bit_to_8_outs_0.NAND_3in_6.y vp sg13_lv_pmos ad=0.1005p pd=1.34u as=0.1005p ps=1.34u w=0.15u l=0.13u
X466 a_30783_28315# row_section_decoding_0.after_000011_n gd gd sg13_lv_nmos ad=0.1005p pd=1.34u as=0.1005p ps=1.34u w=0.15u l=0.13u
X467 VCO4_selection_0.NAND_3in_2.y 3bit_to_8_outs_0.coarse_3 vp vp sg13_lv_pmos ad=0.1005p pd=1.34u as=0.1005p ps=1.34u w=0.15u l=0.13u
X468 VCO5_selection_0.inverter_0.in 3bit_to_8_outs_0.coarse_1 a_32772_28789# gd sg13_lv_nmos ad=0.1005p pd=1.34u as=0.1005p ps=1.34u w=0.15u l=0.13u
X469 a_32920_31262# VCO2_selection_0.inverter_6.out vp vp sg13_lv_pmos ad=0.1005p pd=1.34u as=0.1005p ps=1.34u w=0.15u l=0.13u
X470 VCO3_selection_0.XNOR_1.y f0 a_32110_40066# gd sg13_lv_nmos ad=0.1005p pd=1.34u as=0.1005p ps=1.34u w=0.15u l=0.13u
X471 VCO3_selection_0.NAND_3in_4.y row_section_decoding_0.after_000111_n vp vp sg13_lv_pmos ad=0.1005p pd=1.34u as=0.1005p ps=1.34u w=0.15u l=0.13u
X472 VCO4_selection_0.inverter_1.in VCO4_selection_0.NOR_2in_1.a gd gd sg13_lv_nmos ad=0.1005p pd=1.34u as=0.1005p ps=1.34u w=0.15u l=0.13u
X473 a_33484_43000# VCO3_selection_0.inverter_11.out vp vp sg13_lv_pmos ad=0.1005p pd=1.34u as=0.1005p ps=1.34u w=0.15u l=0.13u
X474 VCO3_selection_0.NAND_3in_1.y 3bit_to_8_outs_0.coarse_2 a_31788_36164# gd sg13_lv_nmos ad=0.1005p pd=1.34u as=0.1005p ps=1.34u w=0.15u l=0.13u
X475 a_32564_39564# VCO3_selection_0.XNOR_1._a vp vp sg13_lv_pmos ad=0.204p pd=1.88u as=0.204p ps=1.88u w=0.6u l=0.13u
X476 a_31623_32714# row_section_decoding_0.after_001111_n a_31407_32714# gd sg13_lv_nmos ad=0.1005p pd=1.34u as=0.1005p ps=1.34u w=0.15u l=0.13u
X477 VCO3_selection_0.inverter_7.out VCO3_selection_0.NAND_3in_4.y gd gd sg13_lv_nmos ad=0.1005p pd=1.34u as=0.1005p ps=1.34u w=0.15u l=0.13u
X478 a_31250_23355# row_section_decoding_0.NAND_2in_0.b gd gd sg13_lv_nmos ad=0.1005p pd=1.34u as=0.1005p ps=1.34u w=0.15u l=0.13u
X479 vp VCO2_selection_0.NAND_4in_0.a VCO2_5_sel vp sg13_lv_pmos ad=0.1005p pd=1.34u as=0.1005p ps=1.34u w=0.15u l=0.13u
X480 a_31623_34196# row_section_decoding_0.after_000111 a_31407_34196# gd sg13_lv_nmos ad=0.1005p pd=1.34u as=0.1005p ps=1.34u w=0.15u l=0.13u
X481 VCO2_selection_0.NAND_3in_4.y 101 a_32779_32240# gd sg13_lv_nmos ad=0.1005p pd=1.34u as=0.1005p ps=1.34u w=0.15u l=0.13u
X482 VCO3_selection_0.XNOR_1.y f1 a_32104_39564# vp sg13_lv_pmos ad=0.204p pd=1.88u as=0.204p ps=1.88u w=0.6u l=0.13u
X483 3bit_to_8_outs_0.NAND_3in_0.y c1 vp vp sg13_lv_pmos ad=0.1005p pd=1.34u as=0.1005p ps=1.34u w=0.15u l=0.13u
X484 a_31788_38120# row_section_decoding_0.after_000011 a_31572_38120# gd sg13_lv_nmos ad=0.1005p pd=1.34u as=0.1005p ps=1.34u w=0.15u l=0.13u
X485 gd c2 a_31626_25172# gd sg13_lv_nmos ad=0.1005p pd=1.34u as=0.1005p ps=1.34u w=0.15u l=0.13u
X486 a_30774_22377# f3 vp vp sg13_lv_pmos ad=0.1005p pd=1.34u as=0.1005p ps=1.34u w=0.15u l=0.13u
X487 a_31598_48376# VCO4_selection_0.XNOR_0._b gd gd sg13_lv_nmos ad=0.1005p pd=1.34u as=0.1005p ps=1.34u w=0.15u l=0.13u
X488 gd 3bit_to_8_outs_0.c2_n a_31626_26816# gd sg13_lv_nmos ad=0.1005p pd=1.34u as=0.1005p ps=1.34u w=0.15u l=0.13u
X489 a_31060_45946# row_section_decoding_0.after_000111_n gd gd sg13_lv_nmos ad=0.1005p pd=1.34u as=0.1005p ps=1.34u w=0.15u l=0.13u
X490 a_31321_28789# VCO5_selection_0.XNOR_0._b gd gd sg13_lv_nmos ad=0.1005p pd=1.34u as=0.1005p ps=1.34u w=0.15u l=0.13u
X491 a_33278_35660# VCO3_selection_0.inverter_1.out vp vp sg13_lv_pmos ad=0.1005p pd=1.34u as=0.1005p ps=1.34u w=0.15u l=0.13u
X492 VCO2_selection_0.inverter_1.in 100 vp vp sg13_lv_pmos ad=0.1005p pd=1.34u as=0.1005p ps=1.34u w=0.15u l=0.13u
X493 row_section_decoding_0.after_000111 row_section_decoding_0.after_000111_n gd gd sg13_lv_nmos ad=0.1005p pd=1.34u as=0.1005p ps=1.34u w=0.15u l=0.13u
X494 a_33345_40066# VCO3_selection_0.NAND_3in_6.c gd gd sg13_lv_nmos ad=0.1005p pd=1.34u as=0.1005p ps=1.34u w=0.15u l=0.13u
X495 vp 3bit_to_8_outs_0.c2_n 3bit_to_8_outs_0.inverter_10.in vp sg13_lv_pmos ad=0.1005p pd=1.34u as=0.1005p ps=1.34u w=0.15u l=0.13u
X496 a_33013_28315# VCO5_selection_0.NAND_2in_0.b gd gd sg13_lv_nmos ad=0.1005p pd=1.34u as=0.1005p ps=1.34u w=0.15u l=0.13u
X497 VCO2_selection_0.inverter_2.in 3bit_to_8_outs_0.coarse_2 a_31407_34670# gd sg13_lv_nmos ad=0.1005p pd=1.34u as=0.1005p ps=1.34u w=0.15u l=0.13u
X498 a_32570_38594# f1 gd gd sg13_lv_nmos ad=0.1005p pd=1.34u as=0.1005p ps=1.34u w=0.15u l=0.13u
X499 row_section_decoding_0.f5_n f5 vp vp sg13_lv_pmos ad=0.1005p pd=1.34u as=0.1005p ps=1.34u w=0.15u l=0.13u
X500 VCO3_selection_0.NAND_3in_8.y 110 vp vp sg13_lv_pmos ad=0.1005p pd=1.34u as=0.1005p ps=1.34u w=0.15u l=0.13u
X501 vp 3bit_to_8_outs_0.NAND_3in_3.y 101 vp sg13_lv_pmos ad=0.1005p pd=1.34u as=0.1005p ps=1.34u w=0.15u l=0.13u
X502 VCO3_selection_0.NAND_3in_6.a VCO3_selection_0.inverter_11.out gd gd sg13_lv_nmos ad=0.1005p pd=1.34u as=0.1005p ps=1.34u w=0.15u l=0.13u
X503 vp 111 VCO2_selection_0.inverter_3.in vp sg13_lv_pmos ad=0.1005p pd=1.34u as=0.1005p ps=1.34u w=0.15u l=0.13u
X504 row_section_decoding_0.after_000111_n f4 gd gd sg13_lv_nmos ad=0.1005p pd=1.34u as=0.1005p ps=1.34u w=0.15u l=0.13u
X505 VCO2_selection_0.NAND_3in_3.y VCO2_selection_0.NAND_3in_3.c vp vp sg13_lv_pmos ad=0.1005p pd=1.34u as=0.1005p ps=1.34u w=0.15u l=0.13u
X506 a_31276_43990# row_section_decoding_0.after_000011_n a_31060_43990# gd sg13_lv_nmos ad=0.1005p pd=1.34u as=0.1005p ps=1.34u w=0.15u l=0.13u
X507 a_33044_32714# VCO2_selection_0.NAND_4in_0.c a_32828_32714# gd sg13_lv_nmos ad=0.1005p pd=1.34u as=0.1005p ps=1.34u w=0.15u l=0.13u
X508 vp row_section_decoding_0.after_000111 VCO3_selection_0.NAND_3in_9.y vp sg13_lv_pmos ad=0.1005p pd=1.34u as=0.1005p ps=1.34u w=0.15u l=0.13u
X509 VCO2_selection_0.NOR_2in_0.a VCO2_selection_0.NAND_3in_3.y vp vp sg13_lv_pmos ad=0.1005p pd=1.34u as=0.1005p ps=1.34u w=0.15u l=0.13u
X510 VCO2_selection_0.NOR_2in_2.b VCO2_selection_0.inverter_3.in gd gd sg13_lv_nmos ad=0.1005p pd=1.34u as=0.1005p ps=1.34u w=0.15u l=0.13u
X511 a_32537_27811# VCO5_selection_0.inverter_0.out vp vp sg13_lv_pmos ad=0.1005p pd=1.34u as=0.1005p ps=1.34u w=0.15u l=0.13u
X512 a_32564_39006# VCO3_selection_0.XNOR_0._a vp vp sg13_lv_pmos ad=0.204p pd=1.88u as=0.204p ps=1.88u w=0.6u l=0.13u
X513 VCO3_selection_0.inverter_3.out VCO3_selection_0.NAND_3in_2.y gd gd sg13_lv_nmos ad=0.1005p pd=1.34u as=0.1005p ps=1.34u w=0.15u l=0.13u
X514 VCO4_selection_0.NAND_3in_1.y 3bit_to_8_outs_0.coarse_0 a_31956_45946# gd sg13_lv_nmos ad=0.1005p pd=1.34u as=0.1005p ps=1.34u w=0.15u l=0.13u
X515 VCO3_selection_0.XNOR_1._b f1 gd gd sg13_lv_nmos ad=0.1005p pd=1.34u as=0.1005p ps=1.34u w=0.15u l=0.13u
X516 VCO3_selection_0.NAND_3in_7.c f1 a_32104_39006# vp sg13_lv_pmos ad=0.204p pd=1.88u as=0.204p ps=1.88u w=0.6u l=0.13u
X517 a_31260_49868# VCO_selection_0.NAND_2in_2.y gd gd sg13_lv_nmos ad=0.1005p pd=1.34u as=0.1005p ps=1.34u w=0.15u l=0.13u
X518 VCO5_selection_0.inverter_2.in VCO5_selection_0.XNOR_0._a a_31781_28789# gd sg13_lv_nmos ad=0.1005p pd=1.34u as=0.1005p ps=1.34u w=0.15u l=0.13u
X519 3bit_to_8_outs_0.NAND_3in_3.y 3bit_to_8_outs_0.c1_n vp vp sg13_lv_pmos ad=0.1005p pd=1.34u as=0.1005p ps=1.34u w=0.15u l=0.13u
C0 VCO4_selection_0.inverter_3.in m2_30981_45853# 0.12148f
C1 VCO4_selection_0.NOR_2in_0.b VCO4_selection_0.NAND_2in_0.b 0.92985f
C2 3bit_to_8_outs_0.NAND_3in_0.y vp 0.50656f
C3 row_section_decoding_0.after_000011 row_section_decoding_0.f5_n 0.51368f
C4 VCO5_selection_0.NOR_2in_0.y vp 0.30006f
C5 VCO5_selection_0.inverter_1.in 3bit_to_8_outs_0.coarse_2 0.40224f
C6 VCO4_11_sel vp 0.23681f
C7 row_section_decoding_0.f1_n 3bit_to_8_outs_0.coarse_0 0.09661f
C8 row_section_decoding_0.after_000111 row_section_decoding_0.after_001111 0.86048f
C9 VCO4_selection_0.XNOR_0._b VCO4_selection_0.XNOR_0.y 0.52282f
C10 row_section_decoding_0.f1_n f2 0.06033f
C11 row_section_decoding_0.after_000111_n a_30774_22377# 0.0101f
C12 VCO2_selection_0.NOR_2in_0.y m2_33323_30841# 0.01238f
C13 VCO2_selection_0.NOR_2in_2.b VCO2_selection_0.NOR_2in_2.a 1.14189f
C14 110 3bit_to_8_outs_0.coarse_3 0.28302f
C15 a_31315_29201# VCO5_selection_0.inverter_2.in 0.09334f
C16 VCO2_selection_0.NAND_4in_0.d vp 0.50382f
C17 VCO4_5_sel vp 0.35628f
C18 row_section_decoding_0.f1_n c0 0.07263f
C19 VCO3_selection_0.XNOR_1.y m2_33006_39891# 0.01096f
C20 VCO3_selection_0.NAND_3in_6.c VCO3_selection_0.inverter_8.out 0.32594f
C21 vp a_33085_39098# 0.0976f
C22 3bit_to_8_outs_0.NAND_3in_2.y vp 0.55595f
C23 3bit_to_8_outs_0.coarse_0 row_section_decoding_0.after_000011_n 2.04102f
C24 a_32104_39564# f0 0.13529f
C25 VCO2_selection_0.NOR_2in_0.a m2_32700_29945# 0.17579f
C26 VCO2_selection_0.NOR_2in_0.b VCO2_selection_0.NAND_3in_7.y 0.38507f
C27 VCO2_selection_0.NAND_3in_3.c VCO2_selection_0.XNOR_0._a 0.99037f
C28 row_section_decoding_0.after_000111 3bit_to_8_outs_0.c0_n 0.01724f
C29 row_section_decoding_0.after_000011_n f2 33.0718f
C30 VCO4_selection_0.inverter_5.in VCO4_selection_0.inverter_5.out 0.40996f
C31 VCO2_selection_0.NOR_2in_2.a m2_32824_34753# 0.01349f
C32 m2_31493_40623# row_section_decoding_0.after_000011 0.01291f
C33 c0 row_section_decoding_0.after_000011_n 0.08338f
C34 VCO3_selection_0.NAND_3in_2.y m2_32933_36721# 0.17387f
C35 VCO4_selection_0.NAND_3in_1.y a_31740_45946# 0.01087f
C36 m2_32496_34103# VCO2_selection_0.inverter_0.out 0.09002f
C37 VCO5_selection_0.inverter_1.in VCO5_selection_0.NAND_2in_0.b 0.58569f
C38 VCO3_selection_0.NAND_3in_6.a a_33484_43000# 0.07285f
C39 a_31410_26498# 3bit_to_8_outs_0.inverter_10.in 0.01203f
C40 VCO4_selection_0.inverter_2.in row_section_decoding_0.after_001111_n 0.52393f
C41 row_section_decoding_0.after_000111 f1 0.44203f
C42 VCO2_selection_0.NOR_2in_2.a VCO3_selection_0.inverter_2.out 0.01092f
C43 a_32018_44968# VCO4_selection_0.inverter_0.out 0.01124f
C44 110 VCO3_selection_0.NAND_3in_4.y 0.41155f
C45 a_32468_38120# VCO3_selection_0.NAND_3in_7.y 0.06651f
C46 row_section_decoding_0.after_000011_n VCO3_selection_0.NAND_2in_1.y 0.41683f
C47 m2_33137_42661# m2_33405_42661# 0.01389f
C48 VCO2_selection_0.XNOR_0._a f1 0.50696f
C49 VCO3_selection_0.NAND_3in_9.y VCO3_selection_0.NAND_3in_5.y 0.35476f
C50 row_section_decoding_0.after_001111 row_section_decoding_0.after_000011 41.5355f
C51 VCO4_selection_0.inverter_5.in a_32058_47902# 0.07022f
C52 110 VCO3_selection_0.NOR_2in_4.b 0.01331f
C53 VCO2_selection_0.NAND_3in_5.c VCO2_selection_0.NOR_2in_0.y 0.55561f
C54 row_section_decoding_0.after_000111_n m2_32353_45771# 0.01378f
C55 3bit_to_8_outs_0.coarse_0 c1 0.02985f
C56 VCO2_selection_0.NAND_3in_3.c VCO2_selection_0.NAND_3in_7.y 0.73712f
C57 row_section_decoding_0.f1_n 3bit_to_8_outs_0.coarse_1 0.06961f
C58 VCO2_selection_0.NAND_3in_3.c row_section_decoding_0.after_000011 0.01601f
C59 m2_32865_40869# VCO3_selection_0.inverter_8.out 0.21677f
C60 VCO3_selection_0.inverter_7.out vp 0.39795f
C61 a_33486_41044# VCO3_selection_0.NAND_3in_6.c 0.0729f
C62 VCO_selection_0.NAND_2in_2.y VCO_sel 0.5235f
C63 c1 f2 0.02985f
C64 m2_30761_25501# m2_31033_25501# 0.01344f
C65 a_32252_40540# VCO3_selection_0.inverter_12.out 0.01314f
C66 VCO3_selection_0.NOR_2in_4.a vp 0.40371f
C67 c0 c1 18.1784f
C68 m2_33405_42661# VCO3_selection_0.inverter_11.out 0.01577f
C69 a_32093_32240# a_31877_32240# 0.02238f
C70 m2_32494_47809# m2_32494_47727# 0.16392f
C71 110 101 33.9404f
C72 a_32090_25172# a_32306_25172# 0.02238f
C73 3bit_to_8_outs_0.c1_n 3bit_to_8_outs_0.inverter_10.in 0.07709f
C74 3bit_to_8_outs_0.coarse_1 row_section_decoding_0.after_000011_n 2.0878f
C75 110 3bit_to_8_outs_0.coarse_2 0.23934f
C76 VCO2_selection_0.inverter_4.out m2_32841_30841# 0.01202f
C77 VCO3_selection_0.NAND_3in_4.y VCO3_selection_0.NAND_3in_8.y 0.29808f
C78 m2_31673_43815# VCO4_selection_0.NAND_3in_0.y 0.01152f
C79 m2_31493_41847# VCO3_selection_0.NAND_2in_0.y 0.27335f
C80 row_section_decoding_0.after_000011_n VCO3_selection_0.XNOR_1._b 0.07003f
C81 VCO3_selection_0.XNOR_0._b row_section_decoding_0.after_000011_n 0.06965f
C82 a_32563_32240# row_section_decoding_0.after_000111_n 0.0131f
C83 VCO4_selection_0.NOR_2in_0.a m2_32353_46585# 0.22178f
C84 111 row_section_decoding_0.after_001111_n 0.25258f
C85 row_section_decoding_0.after_000011 f1 0.96167f
C86 VCO2_selection_0.NAND_4in_0.d f0 0.0141f
C87 VCO3_selection_0.inverter_7.out VCO3_selection_0.NAND_3in_6.b 0.33367f
C88 VCO3_selection_0.NAND_3in_3.y row_section_decoding_0.after_000111_n 0.62892f
C89 3bit_to_8_outs_0.inverter_6.in 101 0.65524f
C90 VCO3_selection_0.NAND_3in_1.y 3bit_to_8_outs_0.coarse_2 0.37153f
C91 VCO4_selection_0.XNOR_0.y row_section_decoding_0.after_000011_n 0.18799f
C92 m2_32865_37781# VCO3_selection_0.NAND_3in_7.y 0.22234f
C93 m2_32933_36071# m2_33199_36071# 0.01413f
C94 VCO3_selection_0.NAND_3in_9.y a_32468_42496# 0.06651f
C95 VCO3_selection_0.NOR_2in_4.a VCO3_selection_0.NAND_3in_6.b 0.23686f
C96 row_section_decoding_0.after_000111_n f5 3.95181f
C97 m2_33006_39973# VCO3_selection_0.XNOR_1._b 0.04693f
C98 VCO_selection_0.NAND_2in_1.y vp 0.44742f
C99 VCO3_selection_0.NOR_2in_1.y VCO2_11_sel 0.02687f
C100 VCO3_selection_0.NAND_3in_7.c a_32564_39006# 0.09922f
C101 3bit_to_8_outs_0.inverter_8.in a_31410_26816# 0.01203f
C102 row_section_decoding_0.after_000111_n row_section_decoding_0.NAND_2in_0.a 0.02971f
C103 VCO4_selection_0.inverter_5.out m2_32494_47563# 0.17612f
C104 VCO4_selection_0.inverter_5.in vp 0.5465f
C105 m2_31033_26159# 3bit_to_8_outs_0.coarse_2 0.17579f
C106 vp VCO2_selection_0.inverter_1.out 0.40248f
C107 VCO3_selection_0.inverter_10.out VCO3_selection_0.NAND_3in_6.a 0.33026f
C108 VCO3_selection_0.NAND_3in_3.y VCO3_selection_0.inverter_0.out 0.18223f
C109 VCO5_selection_0.inverter_0.in row_section_decoding_0.after_000011_n 1.16379f
C110 a_32494_43990# VCO4_selection_0.NOR_2in_0.a 0.01029f
C111 VCO_selection_0.NAND_2in_0.y vp 0.38485f
C112 m2_31033_26159# m2_30761_26159# 0.01344f
C113 VCO3_selection_0.NOR_2in_4.a VCO3_selection_0.NAND_2in_0.y 0.51667f
C114 a_31572_42496# VCO3_selection_0.NAND_3in_5.y 0.02085f
C115 a_31260_49868# VCO_selection_0.NAND_2in_2.y 0.01626f
C116 3bit_to_8_outs_0.inverter_1.in row_section_decoding_0.after_000011_n 0.01462f
C117 a_33085_39098# VCO3_selection_0.NAND_3in_0.c 0.07281f
C118 a_32087_30284# a_32303_30284# 0.02238f
C119 VCO5_selection_0.XNOR_0._b VCO5_selection_0.inverter_1.in 0.03494f
C120 3bit_to_8_outs_0.NAND_3in_2.y 3bit_to_8_outs_0.NAND_3in_6.y 0.05633f
C121 3bit_to_8_outs_0.coarse_1 c1 0.02985f
C122 a_31986_22377# f5 0.0109f
C123 VCO3_selection_0.NAND_3in_2.y a_31572_36638# 0.01087f
C124 VCO5_selection_0.inverter_1.in VCO5_selection_0.inverter_1.out 0.37698f
C125 a_32564_39006# VCO3_selection_0.XNOR_0._a 0.09297f
C126 m2_32989_41847# VCO3_selection_0.NOR_2in_4.b 0.03221f
C127 VCO3_selection_0.NAND_3in_1.y VCO3_selection_0.inverter_2.out 0.4741f
C128 a_32258_36164# VCO3_selection_0.NAND_2in_1.y 0.06997f
C129 110 100 2.78603f
C130 3bit_to_8_outs_0.NAND_3in_0.y 3bit_to_8_outs_0.c2_n 0.02839f
C131 VCO3_selection_0.NAND_3in_5.y vp 0.50981f
C132 f3 row_section_decoding_0.after_001111_n 0.03985f
C133 VCO4_selection_0.inverter_2.out m2_31673_44629# 0.17684f
C134 a_31775_29201# vp 0.13606f
C135 row_section_decoding_0.after_000111 3bit_to_8_outs_0.coarse_3 3.70109f
C136 row_section_decoding_0.after_000111_n m2_30981_45853# 0.65836f
C137 VCO4_selection_0.NAND_2in_0.a VCO4_selection_0.inverter_1.in 7.06034f
C138 row_section_decoding_0.after_000011 VCO2_selection_0.inverter_6.out 0.05937f
C139 VCO3_selection_0.NAND_3in_1.y 100 0.49562f
C140 a_31740_46420# VCO4_selection_0.inverter_4.in 0.01406f
C141 3bit_to_8_outs_0.inverter_10.in vp 0.48467f
C142 VCO4_selection_0.inverter_0.out m2_31673_44793# 0.02215f
C143 m2_32865_37781# m2_33137_37781# 0.01344f
C144 VCO_selection_0.NAND_2in_1.y a_31476_49868# 0.01693f
C145 VCO3_selection_0.NAND_3in_6.a VCO3_selection_0.NAND_3in_6.c 0.17346f
C146 a_32556_28789# a_32772_28789# 0.02238f
C147 3bit_to_8_outs_0.inverter_6.in 100 0.38559f
C148 VCO4_selection_0.NOR_2in_0.a VCO4_11_sel 0.01312f
C149 a_33589_34670# VCO2_11_sel 0.06543f
C150 VCO2_selection_0.NOR_2in_2.b m2_32286_34753# 0.09002f
C151 3bit_to_8_outs_0.inverter_1.in c1 0.59595f
C152 3bit_to_8_outs_0.NAND_3in_2.y 3bit_to_8_outs_0.c2_n 0.52425f
C153 110 VCO2_selection_0.NAND_3in_3.y 0.47651f
C154 VCO2_selection_0.inverter_0.out vp 0.30828f
C155 m2_30761_27145# m2_31033_27145# 0.01344f
C156 VCO3_selection_0.NAND_3in_5.y VCO3_selection_0.NAND_3in_6.b 0.01052f
C157 3bit_to_8_outs_0.coarse_0 f2 0.05865f
C158 row_section_decoding_0.after_000011 row_section_decoding_0.NAND_2in_0.b 1.05491f
C159 VCO2_selection_0.NAND_3in_3.y VCO2_selection_0.NOR_2in_0.a 0.43472f
C160 VCO4_selection_0.NOR_2in_0.a VCO4_5_sel 0.16566f
C161 3bit_to_8_outs_0.NAND_3in_0.y 3bit_to_8_outs_0.c0_n 0.45465f
C162 VCO2_selection_0.inverter_4.out VCO2_selection_0.inverter_6.out 0.52444f
C163 VCO4_11_sel m2_32353_45607# 0.22133f
C164 3bit_to_8_outs_0.coarse_0 c0 0.05337f
C165 3bit_to_8_outs_0.c0_n VCO5_selection_0.NOR_2in_0.y 0.01229f
C166 a_32903_35174# VCO2_selection_0.NOR_2in_2.b 0.0109f
C167 m2_30981_43897# row_section_decoding_0.after_000011_n 0.01794f
C168 VCO2_selection_0.NAND_3in_5.c vp 0.37316f
C169 a_32104_39006# VCO3_selection_0.NAND_3in_7.c 0.09342f
C170 VCO4_selection_0.inverter_1.in VCO4_selection_0.inverter_3.out 0.75418f
C171 m2_30981_44547# 3bit_to_8_outs_0.coarse_0 0.01071f
C172 VCO3_selection_0.NAND_3in_5.y VCO3_selection_0.NAND_2in_0.y 0.01322f
C173 VCO_selection_0.NAND_2in_2.y 101 0.3152f
C174 c0 f2 0.0533f
C175 a_32920_31262# vp 0.0977f
C176 VCO5_selection_0.inverter_1.in VCO5_selection_0.inverter_2.in 0.0121f
C177 VCO2_selection_0.inverter_1.out a_33113_33692# 0.04729f
C178 VCO4_selection_0.XNOR_0._b vp 0.30783f
C179 a_31788_40540# VCO3_selection_0.NAND_3in_4.y 0.06699f
C180 VCO5_selection_0.NAND_2in_0.b VCO5_selection_0.inverter_0.out 0.45362f
C181 VCO_selection_0.NAND_2in_1.y f0 0.02259f
C182 a_31572_40540# VCO3_selection_0.NAND_3in_4.y 0.01108f
C183 VCO2_selection_0.NAND_4in_0.b 101 0.63868f
C184 VCO4_selection_0.inverter_5.in f0 0.36958f
C185 m2_32451_41929# VCO3_selection_0.NAND_2in_0.y 0.16451f
C186 VCO4_selection_0.inverter_5.out row_section_decoding_0.after_000011_n 0.13082f
C187 110 VCO3_selection_0.inverter_12.out 0.02635f
C188 a_31956_46420# VCO4_selection_0.NAND_3in_2.y 0.06651f
C189 3bit_to_8_outs_0.coarse_3 row_section_decoding_0.after_000011 1.73797f
C190 VCO4_selection_0.inverter_4.in m2_32353_46585# 0.16449f
C191 VCO_selection_0.NAND_2in_0.y f0 0.02152f
C192 m2_32934_28222# VCO5_selection_0.NAND_2in_0.b 0.41185f
C193 VCO3_selection_0.XNOR_0._a VCO3_selection_0.inverter_5.out 0.01042f
C194 110 m2_30711_49775# 0.01068f
C195 a_33373_34670# a_33589_34670# 0.02238f
C196 a_31410_26498# a_31626_26498# 0.02238f
C197 a_31626_24854# 3bit_to_8_outs_0.NAND_3in_0.y 0.01403f
C198 m2_32934_28222# VCO5_11_sel 0.09359f
C199 VCO3_5_sel VCO3_selection_0.inverter_12.out 0.07295f
C200 a_32306_25172# c2 0.0131f
C201 row_section_decoding_0.after_000111 VCO2_selection_0.inverter_1.in 0.60479f
C202 m2_32865_42661# VCO3_selection_0.NAND_3in_5.y 0.16449f
C203 row_section_decoding_0.after_000111 101 2.05382f
C204 m2_30981_43897# m2_31673_43897# 0.01378f
C205 row_section_decoding_0.f1_n c2 0.04177f
C206 row_section_decoding_0.after_000111 3bit_to_8_outs_0.coarse_2 1.05845f
C207 a_31775_29201# f0 0.02647f
C208 3bit_to_8_outs_0.coarse_0 3bit_to_8_outs_0.coarse_1 34.9375f
C209 a_33561_40066# VCO3_selection_0.NAND_3in_6.b 0.04063f
C210 VCO3_selection_0.NAND_3in_5.y row_section_decoding_0.f5_n 1.15825f
C211 3bit_to_8_outs_0.coarse_1 f2 0.05767f
C212 VCO4_selection_0.inverter_0.out vp 0.33174f
C213 VCO3_selection_0.inverter_12.out VCO3_selection_0.NAND_3in_8.y 0.65032f
C214 vp VCO3_selection_0.NAND_3in_7.y 0.57533f
C215 f3 a_30774_23859# 0.0117f
C216 row_section_decoding_0.after_000011_n m2_31653_23684# 0.22133f
C217 VCO2_selection_0.inverter_0.out a_33113_33692# 0.0109f
C218 row_section_decoding_0.after_000011 VCO3_selection_0.NAND_3in_4.y 0.5644f
C219 m2_30711_49693# m2_30711_49775# 0.39957f
C220 3bit_to_8_outs_0.coarse_1 c0 0.05424f
C221 row_section_decoding_0.after_000011_n c2 9.02899f
C222 a_31303_28315# a_31519_28315# 0.02238f
C223 VCO4_selection_0.XNOR_1._b vp 0.29638f
C224 VCO3_selection_0.NOR_2in_0.y m2_33199_36721# 0.15347f
C225 VCO4_selection_0.NAND_2in_0.a VCO4_selection_0.NOR_2in_1.a 0.0332f
C226 m2_33405_42579# VCO3_selection_0.inverter_11.out 0.01302f
C227 m2_33034_34021# VCO2_selection_0.NOR_2in_1.y 0.27211f
C228 3bit_to_8_outs_0.inverter_10.in 3bit_to_8_outs_0.NAND_3in_6.y 0.36477f
C229 m2_31673_43815# f1 0.01378f
C230 3bit_to_8_outs_0.c1_n c1 0.90128f
C231 VCO4_selection_0.inverter_0.out m2_31939_44629# 0.47512f
C232 VCO5_selection_0.inverter_1.in VCO5_selection_0.XNOR_0._a 0.01839f
C233 a_30783_28315# 3bit_to_8_outs_0.coarse_2 0.01031f
C234 m2_31181_49775# VCO_sel 0.08648f
C235 VCO3_selection_0.NAND_3in_2.y 3bit_to_8_outs_0.coarse_0 0.41422f
C236 row_section_decoding_0.f1_n vp 0.34327f
C237 VCO2_selection_0.NAND_4in_0.d VCO2_selection_0.inverter_6.out 0.20793f
C238 VCO2_selection_0.NAND_4in_0.c VCO2_selection_0.NAND_3in_4.y 0.01515f
C239 VCO4_selection_0.inverter_0.out VCO4_selection_0.NAND_3in_0.y 0.43111f
C240 VCO_selection_0.NAND_2in_1.y row_section_decoding_0.after_001111 0.01595f
C241 111 110 42.4525f
C242 row_section_decoding_0.after_000011 101 1.24202f
C243 VCO4_selection_0.XNOR_0._b f0 0.43406f
C244 a_31626_25172# 3bit_to_8_outs_0.inverter_6.in 0.01403f
C245 VCO4_selection_0.NOR_2in_0.a VCO4_selection_0.inverter_5.in 0.01415f
C246 row_section_decoding_0.after_000111 100 1.26796f
C247 row_section_decoding_0.after_000111_n row_section_decoding_0.after_001111_n 41.4291f
C248 VCO4_selection_0.inverter_1.in VCO4_selection_0.NOR_2in_0.b 0.44374f
C249 VCO5_selection_0.inverter_0.in c0 0.01242f
C250 VCO3_selection_0.NAND_3in_1.y a_31572_36164# 0.01087f
C251 row_section_decoding_0.after_000011 3bit_to_8_outs_0.coarse_2 10.2438f
C252 VCO3_selection_0.NAND_3in_6.a VCO3_selection_0.XNOR_1.y 0.0169f
C253 m2_33199_36721# VCO3_selection_0.inverter_3.out 0.01349f
C254 VCO_selection_0.NAND_2in_0.y row_section_decoding_0.after_001111 0.31615f
C255 VCO3_selection_0.inverter_1.out VCO2_selection_0.NOR_2in_1.y 0.01011f
C256 VCO5_selection_0.inverter_1.out VCO5_selection_0.inverter_0.out 1.04645f
C257 a_33486_41044# VCO3_selection_0.inverter_8.out 0.0109f
C258 row_section_decoding_0.after_000011_n vp 4.89956f
C259 VCO4_selection_0.inverter_3.out VCO4_selection_0.NOR_2in_1.a 1.9702f
C260 c1 c2 15.8555f
C261 row_section_decoding_0.after_001111_n f5 0.95204f
C262 m2_33034_34021# VCO2_selection_0.inverter_1.in 0.01476f
C263 3bit_to_8_outs_0.inverter_6.in a_31410_25172# 0.01203f
C264 a_31250_23355# row_section_decoding_0.NAND_2in_0.a 0.01073f
C265 m2_32458_28222# VCO5_selection_0.inverter_0.out 0.01349f
C266 m2_30761_27145# 3bit_to_8_outs_0.inverter_8.in 0.17547f
C267 a_32252_40540# a_32468_40540# 0.02238f
C268 VCO2_selection_0.NOR_2in_2.a m2_32558_34753# 0.09062f
C269 a_31986_22377# row_section_decoding_0.after_001111_n 0.07285f
C270 3bit_to_8_outs_0.c2_n 3bit_to_8_outs_0.inverter_10.in 2.06995f
C271 VCO3_selection_0.inverter_4.in VCO3_selection_0.NAND_3in_7.y 0.03471f
C272 m2_32841_30841# m2_33323_30841# 0.01311f
C273 VCO2_selection_0.NAND_3in_4.y vp 0.55952f
C274 VCO3_selection_0.NAND_3in_2.y m2_32661_36721# 0.16451f
C275 VCO5_selection_0.inverter_1.in a_31519_28315# 0.01181f
C276 m2_32934_28222# m2_32458_28222# 0.01378f
C277 VCO3_selection_0.XNOR_0._b VCO3_selection_0.XNOR_1._b 0.02878f
C278 3bit_to_8_outs_0.coarse_1 VCO4_selection_0.XNOR_0.y 0.82069f
C279 VCO2_selection_0.NOR_2in_0.b VCO2_selection_0.NAND_3in_5.c 0.0159f
C280 row_section_decoding_0.after_000111_n m2_33176_32065# 0.01378f
C281 VCO4_selection_0.inverter_5.in f1 0.95431f
C282 a_32052_47400# vp 0.13606f
C283 a_32110_40066# VCO3_selection_0.XNOR_1.y 0.066f
C284 m2_32768_34103# m2_32496_34103# 0.01344f
C285 row_section_decoding_0.after_000011_n VCO4_selection_0.NAND_3in_0.y 0.64668f
C286 VCO4_selection_0.inverter_5.in VCO4_selection_0.XNOR_1._a 1.01148f
C287 110 f3 0.04f
C288 VCO2_selection_0.NAND_3in_5.c m2_33294_34753# 0.6842f
C289 VCO3_5_sel VCO3_selection_0.NAND_3in_6.c 0.71596f
C290 VCO2_selection_0.inverter_2.in vp 0.31334f
C291 a_31276_46420# VCO4_selection_0.inverter_4.in 0.06549f
C292 a_33260_32714# VCO2_5_sel 0.07413f
C293 c1 vp 0.48359f
C294 row_section_decoding_0.f1_n f4 0.06363f
C295 3bit_to_8_outs_0.NAND_3in_0.y m2_30761_24515# 0.17547f
C296 row_section_decoding_0.after_000011 100 2.26333f
C297 VCO5_selection_0.inverter_0.in 3bit_to_8_outs_0.coarse_1 0.47315f
C298 VCO4_selection_0.XNOR_0.y a_32058_48376# 0.07026f
C299 VCO3_selection_0.NAND_3in_2.y 3bit_to_8_outs_0.coarse_1 0.36667f
C300 row_section_decoding_0.after_000011_n VCO3_selection_0.NAND_2in_0.y 0.72607f
C301 VCO4_selection_0.XNOR_1._b f0 0.4341f
C302 m2_33006_39973# VCO3_selection_0.NAND_3in_6.b 0.01501f
C303 3bit_to_8_outs_0.c0_n 3bit_to_8_outs_0.inverter_10.in 0.45314f
C304 m2_33137_42661# VCO3_selection_0.inverter_11.out 0.17609f
C305 m2_30981_44547# m2_30981_43897# 0.03318f
C306 row_section_decoding_0.f1_n f0 0.14501f
C307 row_section_decoding_0.after_000011_n f4 0.06341f
C308 a_31781_28789# VCO5_selection_0.inverter_2.in 0.07022f
C309 VCO2_selection_0.NAND_3in_5.c m2_32841_30841# 0.15347f
C310 VCO2_selection_0.NAND_3in_5.c VCO2_selection_0.NAND_3in_3.c 0.07623f
C311 VCO2_selection_0.inverter_4.out m2_32841_30923# 0.06156f
C312 m2_31673_43897# VCO4_selection_0.NAND_3in_0.y 0.0105f
C313 VCO2_selection_0.NAND_3in_7.y VCO2_selection_0.NAND_3in_3.y 0.36284f
C314 row_section_decoding_0.after_000111 VCO4_selection_0.inverter_2.in 0.60953f
C315 VCO3_selection_0.inverter_1.out VCO3_selection_0.inverter_2.out 1.25049f
C316 row_section_decoding_0.f1_n row_section_decoding_0.f5_n 0.11499f
C317 3bit_to_8_outs_0.NAND_3in_3.y c0 0.53998f
C318 a_31788_38120# row_section_decoding_0.after_000111_n 0.01182f
C319 a_31788_38120# VCO3_selection_0.NAND_3in_3.y 0.06699f
C320 row_section_decoding_0.after_000011 a_31877_32240# 0.04155f
C321 VCO_selection_0.NAND_2in_1.y VCO_sel 0.61001f
C322 row_section_decoding_0.after_000011_n f0 0.40595f
C323 VCO4_selection_0.inverter_2.out VCO4_selection_0.inverter_2.in 0.51582f
C324 VCO3_selection_0.NAND_3in_9.y a_32252_42496# 0.01044f
C325 a_32018_43486# VCO4_selection_0.NAND_2in_0.b 0.07285f
C326 111 VCO_selection_0.NAND_2in_2.y 0.32806f
C327 3bit_to_8_outs_0.c1_n c0 2.52554f
C328 a_32537_27811# vp 0.09771f
C329 row_section_decoding_0.after_000011_n row_section_decoding_0.f5_n 7.46923f
C330 VCO_selection_0.NAND_2in_0.y VCO_sel 0.61615f
C331 VCO4_selection_0.inverter_3.in a_31956_45946# 0.01203f
C332 3bit_to_8_outs_0.coarse_0 c2 0.02985f
C333 VCO2_selection_0.NAND_4in_0.d 101 0.3511f
C334 VCO4_selection_0.XNOR_0._b a_31598_48376# 0.04323f
C335 m2_32661_36071# row_section_decoding_0.after_000011_n 0.01321f
C336 row_section_decoding_0.f5_n a_31572_36638# 0.01485f
C337 VCO4_selection_0.XNOR_0._b f1 2.21998f
C338 a_31572_42496# a_31788_42496# 0.02238f
C339 a_30774_23859# row_section_decoding_0.NAND_2in_0.a 0.07247f
C340 m2_32865_40869# VCO3_selection_0.NAND_3in_8.y 0.22234f
C341 a_31510_22377# f5 0.0109f
C342 3bit_to_8_outs_0.coarse_2 VCO4_5_sel 0.01439f
C343 f2 c2 0.05523f
C344 VCO4_selection_0.NAND_3in_1.y 3bit_to_8_outs_0.coarse_0 0.57254f
C345 a_32052_47400# f0 0.02647f
C346 VCO4_selection_0.inverter_0.out VCO4_selection_0.NOR_2in_0.a 0.08073f
C347 3bit_to_8_outs_0.NAND_3in_2.y 3bit_to_8_outs_0.coarse_2 0.02136f
C348 m2_32192_28222# VCO5_selection_0.inverter_1.in 0.01429f
C349 c0 c2 0.47452f
C350 VCO4_selection_0.NOR_2in_0.b a_32018_43486# 0.01126f
C351 VCO3_selection_0.NOR_2in_1.y VCO3_11_sel 0.68774f
C352 f1 m2_32217_28954# 0.01037f
C353 c1 f0 0.03743f
C354 row_section_decoding_0.after_000111 111 4.46575f
C355 VCO3_selection_0.inverter_7.out VCO3_selection_0.NAND_3in_4.y 0.46411f
C356 m2_32451_41683# VCO3_selection_0.NAND_2in_3.y 0.22093f
C357 VCO5_selection_0.NAND_2in_0.b VCO5_selection_0.NOR_2in_0.y 0.96665f
C358 c1 row_section_decoding_0.f5_n 0.04764f
C359 111 VCO2_selection_0.XNOR_0._a 0.0178f
C360 VCO4_selection_0.XNOR_0.y VCO4_selection_0.inverter_5.out 1.11513f
C361 a_31781_28789# VCO5_selection_0.XNOR_0._a 0.05886f
C362 VCO2_selection_0.NOR_2in_2.y VCO2_11_sel 0.6088f
C363 m2_31493_40623# row_section_decoding_0.after_000011_n 0.15581f
C364 row_section_decoding_0.after_001111 row_section_decoding_0.f1_n 43.2671f
C365 a_31626_26498# 3bit_to_8_outs_0.NAND_3in_6.y 0.01087f
C366 VCO5_11_sel VCO5_selection_0.NOR_2in_0.y 0.40429f
C367 VCO2_selection_0.NOR_2in_2.b m2_32824_34835# 0.03221f
C368 a_32570_40066# VCO3_selection_0.XNOR_1._a 0.05886f
C369 3bit_to_8_outs_0.coarse_0 vp 2.35502f
C370 VCO3_selection_0.NOR_2in_4.b VCO3_selection_0.NOR_2in_4.a 1.14189f
C371 VCO5_selection_0.XNOR_0._b m2_32217_28872# 0.04693f
C372 c1 3bit_to_8_outs_0.NAND_3in_6.y 0.59599f
C373 f2 vp 0.23799f
C374 VCO2_selection_0.NAND_3in_5.c VCO2_selection_0.inverter_6.out 0.23532f
C375 VCO4_selection_0.NAND_2in_0.a VCO4_selection_0.inverter_2.out 0.16052f
C376 a_32920_31262# VCO2_selection_0.inverter_6.out 0.0461f
C377 3bit_to_8_outs_0.inverter_1.in 3bit_to_8_outs_0.NAND_3in_3.y 0.05633f
C378 c0 vp 1.93925f
C379 3bit_to_8_outs_0.NAND_3in_2.y VCO5_selection_0.NAND_2in_0.b 0.03412f
C380 3bit_to_8_outs_0.coarse_3 VCO3_selection_0.NAND_3in_5.y 0.3788f
C381 row_section_decoding_0.after_001111 row_section_decoding_0.after_000011_n 0.83296f
C382 VCO2_selection_0.NOR_2in_0.a m2_32700_30109# 0.21723f
C383 VCO4_selection_0.XNOR_1._b f1 2.23863f
C384 m2_32286_34753# m2_32558_34753# 0.01344f
C385 m2_32824_34835# m2_32824_34753# 0.39957f
C386 row_section_decoding_0.f1_n 3bit_to_8_outs_0.c0_n 0.01689f
C387 a_32494_44968# VCO4_selection_0.inverter_3.out 0.01124f
C388 VCO4_selection_0.XNOR_1._b VCO4_selection_0.XNOR_1._a 0.4882f
C389 VCO5_selection_0.inverter_2.out VCO5_selection_0.inverter_2.in 0.41402f
C390 110 row_section_decoding_0.after_000111_n 0.30038f
C391 VCO2_selection_0.NAND_3in_3.c row_section_decoding_0.after_000011_n 0.19584f
C392 3bit_to_8_outs_0.coarse_1 c2 0.02985f
C393 row_section_decoding_0.after_000111 f3 0.03998f
C394 a_32468_40540# VCO3_selection_0.NAND_3in_8.y 0.06651f
C395 3bit_to_8_outs_0.coarse_3 3bit_to_8_outs_0.inverter_10.in 0.38664f
C396 VCO2_selection_0.NOR_2in_1.y VCO2_selection_0.inverter_1.out 0.2367f
C397 VCO2_selection_0.XNOR_0._b VCO2_selection_0.XNOR_0._a 0.4882f
C398 vp VCO3_selection_0.NAND_2in_1.y 0.35422f
C399 111 row_section_decoding_0.after_000011 1.05967f
C400 row_section_decoding_0.f1_n f1 1.01245f
C401 110 f5 0.33126f
C402 a_31598_47902# f0 0.03549f
C403 3bit_to_8_outs_0.c2_n a_31626_26498# 0.01312f
C404 a_31740_46420# VCO4_selection_0.NAND_3in_2.y 0.01087f
C405 VCO3_selection_0.NAND_3in_1.y row_section_decoding_0.after_000111_n 0.54116f
C406 VCO2_selection_0.NAND_3in_3.c VCO2_selection_0.NAND_3in_4.y 0.02495f
C407 110 row_section_decoding_0.NAND_2in_0.a 0.02588f
C408 VCO2_selection_0.NAND_4in_0.c VCO2_selection_0.NAND_4in_0.a 0.03704f
C409 m2_30981_46503# m2_30981_45853# 0.02035f
C410 VCO3_selection_0.XNOR_1.y VCO3_selection_0.NAND_3in_8.y 0.01603f
C411 m2_33407_40705# VCO3_selection_0.inverter_7.out 0.10408f
C412 row_section_decoding_0.after_000011_n 3bit_to_8_outs_0.c0_n 0.06427f
C413 a_32368_32714# a_32152_32714# 0.02238f
C414 m2_31673_44629# m2_31673_44547# 0.16392f
C415 3bit_to_8_outs_0.c2_n c1 0.46692f
C416 VCO2_selection_0.XNOR_0._b m2_31328_30191# 0.02565f
C417 a_31410_24854# 3bit_to_8_outs_0.NAND_3in_0.y 0.01203f
C418 VCO2_selection_0.inverter_3.in row_section_decoding_0.after_000011_n 0.42076f
C419 VCO4_selection_0.NAND_3in_1.y VCO4_selection_0.XNOR_0.y 0.01935f
C420 VCO2_selection_0.NAND_4in_0.d a_31877_32240# 0.01066f
C421 row_section_decoding_0.after_000011 VCO4_selection_0.inverter_3.in 0.84067f
C422 VCO2_selection_0.inverter_2.in row_section_decoding_0.after_001111 0.01617f
C423 row_section_decoding_0.after_000011_n f1 4.50696f
C424 m2_31673_43897# VCO4_selection_0.NOR_2in_0.a 0.01591f
C425 row_section_decoding_0.after_001111 c1 0.0422f
C426 3bit_to_8_outs_0.coarse_0 VCO3_selection_0.inverter_4.in 0.45857f
C427 a_33317_29780# VCO2_selection_0.NOR_2in_0.a 0.04415f
C428 3bit_to_8_outs_0.inverter_1.in c2 0.52425f
C429 VCO2_selection_0.inverter_1.in VCO2_selection_0.inverter_1.out 0.51667f
C430 3bit_to_8_outs_0.coarse_0 f4 0.06316f
C431 a_32779_32240# VCO2_selection_0.NAND_4in_0.d 0.01408f
C432 3bit_to_8_outs_0.NAND_3in_2.y a_31626_26816# 0.01087f
C433 3bit_to_8_outs_0.coarse_1 vp 2.05034f
C434 VCO3_selection_0.NAND_3in_5.y VCO3_selection_0.NOR_2in_4.b 0.01212f
C435 f2 f4 0.06316f
C436 a_33345_40066# VCO3_selection_0.NAND_3in_6.b 0.0456f
C437 VCO3_selection_0.NOR_2in_0.y VCO3_selection_0.NOR_2in_1.y 0.9908f
C438 vp VCO2_selection_0.NAND_4in_0.a 0.89981f
C439 VCO3_selection_0.XNOR_0._b vp 0.29551f
C440 VCO2_selection_0.NAND_3in_7.y VCO2_selection_0.XNOR_0._b 0.04756f
C441 VCO3_selection_0.XNOR_1._b vp 0.29549f
C442 VCO3_selection_0.NAND_3in_3.y VCO3_selection_0.inverter_5.out 0.37881f
C443 row_section_decoding_0.after_000011 VCO2_selection_0.XNOR_0._b 0.13221f
C444 a_32018_44968# vp 0.09771f
C445 m2_31673_43651# VCO4_selection_0.NOR_2in_0.b 0.01413f
C446 c0 f4 0.48862f
C447 m2_31181_49775# m2_30711_49775# 0.01451f
C448 m2_32451_41929# VCO3_selection_0.NOR_2in_4.b 0.09002f
C449 row_section_decoding_0.after_000011 f3 0.09034f
C450 VCO4_selection_0.XNOR_0.y vp 0.44867f
C451 c1 3bit_to_8_outs_0.c0_n 1.86958f
C452 VCO2_selection_0.NOR_2in_1.y VCO2_selection_0.inverter_0.out 0.32931f
C453 VCO2_selection_0.inverter_3.in VCO2_selection_0.inverter_2.in 0.5758f
C454 3bit_to_8_outs_0.coarse_0 f0 33.3522f
C455 VCO5_selection_0.NOR_2in_0.y VCO5_selection_0.inverter_1.out 0.37982f
C456 VCO4_selection_0.XNOR_1._a a_32052_47400# 0.09297f
C457 m2_32458_28222# VCO5_selection_0.NOR_2in_0.y 0.15347f
C458 f2 f0 0.12975f
C459 m2_32353_46585# VCO4_selection_0.NAND_3in_2.y 0.01152f
C460 VCO3_selection_0.inverter_4.in VCO3_selection_0.NAND_2in_1.y 0.03336f
C461 VCO3_selection_0.NAND_3in_5.y 3bit_to_8_outs_0.coarse_2 0.41121f
C462 m2_33034_34103# VCO2_selection_0.NOR_2in_1.y 0.16583f
C463 VCO3_selection_0.inverter_0.out VCO3_selection_0.inverter_5.out 0.76875f
C464 3bit_to_8_outs_0.coarse_0 row_section_decoding_0.f5_n 0.1548f
C465 c1 f1 0.02994f
C466 VCO2_selection_0.NAND_3in_5.c VCO2_selection_0.NOR_2in_1.y 0.22326f
C467 VCO3_selection_0.inverter_4.in m2_32661_36721# 0.0104f
C468 c0 f0 0.06101f
C469 VCO5_selection_0.inverter_0.in vp 0.54583f
C470 VCO3_selection_0.NAND_3in_2.y vp 0.50419f
C471 3bit_to_8_outs_0.inverter_1.in vp 0.55257f
C472 VCO3_selection_0.inverter_11.out vp 0.37694f
C473 f2 row_section_decoding_0.f5_n 0.05811f
C474 3bit_to_8_outs_0.coarse_2 3bit_to_8_outs_0.inverter_10.in 0.65828f
C475 111 a_31266_50186# 0.04006f
C476 m2_30761_26159# 3bit_to_8_outs_0.inverter_10.in 0.17547f
C477 c0 row_section_decoding_0.f5_n 0.09431f
C478 3bit_to_8_outs_0.coarse_1 VCO3_selection_0.NAND_2in_0.y 0.31737f
C479 3bit_to_8_outs_0.NAND_3in_3.y 3bit_to_8_outs_0.c1_n 0.59597f
C480 VCO2_selection_0.inverter_0.out VCO2_selection_0.inverter_1.in 0.5084f
C481 VCO2_selection_0.NAND_2in_0.y a_32093_34196# 0.06997f
C482 a_31788_36164# a_31572_36164# 0.02238f
C483 VCO2_selection_0.NAND_4in_0.b VCO2_5_sel 0.89697f
C484 3bit_to_8_outs_0.coarse_3 VCO3_selection_0.NAND_3in_7.y 0.48232f
C485 VCO_selection_0.NAND_2in_0.y a_30790_49868# 0.06997f
C486 row_section_decoding_0.f5_n a_32252_42496# 0.0201f
C487 3bit_to_8_outs_0.coarse_3 VCO4_selection_0.XNOR_1._b 0.01804f
C488 a_31883_34670# row_section_decoding_0.after_000011_n 0.04112f
C489 m2_32192_28222# VCO5_selection_0.inverter_0.out 0.09007f
C490 VCO2_selection_0.NAND_3in_4.y VCO2_selection_0.inverter_6.out 0.92498f
C491 3bit_to_8_outs_0.NAND_3in_0.y 111 0.38549f
C492 3bit_to_8_outs_0.coarse_1 f4 0.06316f
C493 VCO4_selection_0.inverter_4.in row_section_decoding_0.after_000011_n 1.53845f
C494 VCO3_selection_0.inverter_1.out VCO3_selection_0.NOR_2in_1.y 0.23666f
C495 a_30990_22377# a_30774_22377# 0.02238f
C496 a_33278_37142# vp 0.09943f
C497 VCO3_selection_0.inverter_11.out VCO3_selection_0.NAND_3in_6.b 0.01342f
C498 row_section_decoding_0.after_000011_n row_section_decoding_0.NAND_2in_0.b 0.21315f
C499 VCO3_selection_0.inverter_7.out VCO3_selection_0.inverter_12.out 0.31445f
C500 VCO3_selection_0.inverter_8.out VCO3_selection_0.NAND_3in_8.y 0.44201f
C501 a_32368_32714# 101 0.05377f
C502 VCO2_selection_0.NOR_2in_2.y VCO2_selection_0.NOR_2in_2.a 0.23685f
C503 VCO2_selection_0.NAND_3in_5.c VCO2_selection_0.NOR_2in_2.b 0.06976f
C504 3bit_to_8_outs_0.c2_n a_32306_26816# 0.01315f
C505 VCO3_selection_0.NAND_3in_2.y m2_33199_36803# 0.01476f
C506 VCO_selection_0.NAND_2in_2.y f5 0.28511f
C507 3bit_to_8_outs_0.NAND_3in_3.y c2 0.52431f
C508 row_section_decoding_0.f1_n 3bit_to_8_outs_0.coarse_3 0.09553f
C509 m2_31181_49775# 111 0.02609f
C510 m2_32496_33857# VCO2_selection_0.NAND_2in_0.y 0.21637f
C511 VCO5_selection_0.inverter_1.in a_31303_28315# 0.0146f
C512 VCO2_selection_0.NOR_2in_0.y vp 0.21729f
C513 VCO4_selection_0.XNOR_0._b VCO4_selection_0.XNOR_0._a 0.4882f
C514 m2_33199_36721# m2_32933_36721# 0.01413f
C515 VCO3_selection_0.inverter_10.out VCO4_5_sel 0.01971f
C516 3bit_to_8_outs_0.coarse_1 f0 0.72014f
C517 111 VCO2_selection_0.NAND_4in_0.d 0.58191f
C518 a_31321_28789# f0 0.03549f
C519 VCO4_selection_0.inverter_3.in VCO4_11_sel 0.38f
C520 f0 VCO3_selection_0.XNOR_1._b 0.52465f
C521 a_32252_38120# a_32468_38120# 0.02238f
C522 VCO3_selection_0.XNOR_0._b f0 0.52232f
C523 m2_31925_23438# f1 0.17387f
C524 m2_32865_42661# m2_33137_42661# 0.01344f
C525 3bit_to_8_outs_0.c1_n c2 0.98377f
C526 VCO3_selection_0.NOR_2in_0.y VCO3_selection_0.inverter_4.out 0.32932f
C527 VCO3_selection_0.NAND_3in_2.y VCO3_selection_0.inverter_4.in 0.59614f
C528 a_33278_35660# vp 0.0976f
C529 3bit_to_8_outs_0.coarse_1 row_section_decoding_0.f5_n 0.20963f
C530 row_section_decoding_0.after_001111 3bit_to_8_outs_0.coarse_0 0.8487f
C531 3bit_to_8_outs_0.c2_n c0 1.04353f
C532 3bit_to_8_outs_0.coarse_3 row_section_decoding_0.after_000011_n 1.25198f
C533 row_section_decoding_0.after_000111 row_section_decoding_0.after_000111_n 0.82745f
C534 VCO4_selection_0.XNOR_0.y f0 0.34813f
C535 3bit_to_8_outs_0.inverter_6.in m2_30761_25501# 0.17547f
C536 row_section_decoding_0.f5_n VCO2_selection_0.NAND_4in_0.a 0.20185f
C537 VCO3_selection_0.XNOR_0._b row_section_decoding_0.f5_n 0.11645f
C538 row_section_decoding_0.f5_n VCO3_selection_0.XNOR_1._b 0.11631f
C539 m2_33407_40623# VCO3_selection_0.NAND_3in_6.b 0.02514f
C540 row_section_decoding_0.after_000111_n a_31572_40540# 0.0131f
C541 VCO4_selection_0.NAND_2in_0.a VCO4_5_sel 0.43945f
C542 row_section_decoding_0.after_001111 f2 0.06042f
C543 row_section_decoding_0.after_000111 f5 1.79949f
C544 110 VCO3_selection_0.NAND_2in_3.y 0.02502f
C545 row_section_decoding_0.after_001111 c0 0.07171f
C546 VCO4_selection_0.inverter_5.out vp 0.36186f
C547 3bit_to_8_outs_0.NAND_3in_3.y vp 0.50587f
C548 VCO3_selection_0.NAND_3in_9.y vp 0.56475f
C549 VCO4_selection_0.inverter_3.out VCO4_11_sel 0.45134f
C550 row_section_decoding_0.after_000111_n m2_31328_30191# 0.66923f
C551 VCO2_selection_0.NAND_3in_5.c m2_32841_30923# 0.3034f
C552 VCO2_selection_0.NAND_3in_3.c a_32405_30758# 0.07261f
C553 VCO3_selection_0.inverter_4.out VCO3_selection_0.inverter_3.out 1.14187f
C554 VCO4_selection_0.inverter_0.out 3bit_to_8_outs_0.coarse_2 0.02033f
C555 m2_30981_43897# VCO4_selection_0.NAND_3in_0.y 0.09043f
C556 VCO3_selection_0.NAND_3in_2.y row_section_decoding_0.f5_n 0.60057f
C557 a_32090_26816# a_32306_26816# 0.02238f
C558 VCO_selection_0.NAND_2in_0.y m2_30711_49775# 0.09359f
C559 3bit_to_8_outs_0.c1_n vp 0.55218f
C560 a_31572_38120# row_section_decoding_0.after_000111_n 0.02308f
C561 VCO3_selection_0.NAND_3in_3.y VCO3_selection_0.NOR_2in_0.y 0.02431f
C562 c0 3bit_to_8_outs_0.c0_n 2.31619f
C563 3bit_to_8_outs_0.coarse_0 f1 0.41882f
C564 row_section_decoding_0.after_001111 m2_32661_36721# 0.01321f
C565 a_31572_38120# VCO3_selection_0.NAND_3in_3.y 0.01108f
C566 VCO2_selection_0.NAND_3in_7.y m2_32700_30109# 0.16449f
C567 row_section_decoding_0.after_000011 a_31407_32240# 0.01589f
C568 row_section_decoding_0.after_000011_n VCO3_selection_0.NAND_3in_4.y 0.49919f
C569 3bit_to_8_outs_0.coarse_3 c1 0.02985f
C570 110 row_section_decoding_0.after_001111_n 1.96494f
C571 m2_32865_37945# VCO3_selection_0.NAND_3in_7.y 0.01152f
C572 VCO4_selection_0.inverter_1.in VCO4_selection_0.NOR_2in_1.a 0.22782f
C573 m2_32661_36071# m2_32933_36071# 0.01344f
C574 f2 f1 33.477f
C575 m2_33199_36721# m2_33199_36071# 0.01404f
C576 row_section_decoding_0.f1_n 101 0.09553f
C577 3bit_to_8_outs_0.c2_n 3bit_to_8_outs_0.coarse_1 0.01131f
C578 a_31060_43990# VCO4_selection_0.NAND_3in_0.y 0.01087f
C579 VCO2_selection_0.NAND_3in_7.y row_section_decoding_0.after_000111_n 0.52516f
C580 c0 f1 0.05336f
C581 row_section_decoding_0.after_000011 row_section_decoding_0.after_000111_n 62.9308f
C582 VCO3_selection_0.NAND_3in_8.y VCO3_selection_0.NAND_2in_3.y 0.01323f
C583 VCO3_selection_0.NAND_3in_3.y row_section_decoding_0.after_000011 0.56667f
C584 row_section_decoding_0.f1_n 3bit_to_8_outs_0.coarse_2 2.0681f
C585 row_section_decoding_0.after_000111_n a_30990_22377# 0.0659f
C586 VCO2_selection_0.NAND_3in_7.y f5 0.01731f
C587 c2 vp 0.46719f
C588 VCO4_selection_0.inverter_3.in a_31740_45946# 0.01406f
C589 row_section_decoding_0.after_000011 f5 1.32952f
C590 a_33044_32714# a_33260_32714# 0.02238f
C591 row_section_decoding_0.after_001111 3bit_to_8_outs_0.coarse_1 0.33958f
C592 VCO5_selection_0.inverter_0.in VCO2_selection_0.NOR_2in_0.b 0.01492f
C593 VCO2_selection_0.inverter_1.in row_section_decoding_0.after_000011_n 0.0162f
C594 row_section_decoding_0.after_000111 a_31407_32714# 0.0131f
C595 row_section_decoding_0.after_000011 row_section_decoding_0.NAND_2in_0.a 0.52366f
C596 a_31060_45946# a_31276_45946# 0.02238f
C597 m2_31925_23438# row_section_decoding_0.NAND_2in_0.b 0.01347f
C598 VCO2_selection_0.NAND_4in_0.c vp 0.29206f
C599 VCO3_selection_0.XNOR_0._b m2_33006_38677# 0.04721f
C600 row_section_decoding_0.after_000011_n 101 0.87275f
C601 VCO4_selection_0.NAND_3in_1.y vp 0.56332f
C602 a_32104_39564# VCO3_selection_0.XNOR_1.y 0.09334f
C603 a_32048_42022# VCO3_selection_0.NAND_2in_3.y 0.06997f
C604 VCO3_selection_0.NAND_3in_6.c VCO3_selection_0.inverter_7.out 0.1664f
C605 row_section_decoding_0.after_000011_n 3bit_to_8_outs_0.coarse_2 2.82533f
C606 VCO4_selection_0.NOR_2in_0.a VCO4_selection_0.XNOR_0.y 0.22272f
C607 VCO3_selection_0.NAND_3in_7.c VCO3_selection_0.NAND_3in_7.y 0.70937f
C608 a_32399_31170# VCO2_selection_0.XNOR_0._a 0.09297f
C609 m2_31033_27145# 3bit_to_8_outs_0.NAND_3in_2.y 0.2121f
C610 VCO3_selection_0.NAND_3in_6.a VCO3_5_sel 0.73951f
C611 VCO_selection_0.NAND_2in_1.y 111 0.37561f
C612 101 VCO2_selection_0.NAND_3in_4.y 0.57007f
C613 VCO4_selection_0.inverter_5.in a_31592_47400# 0.09334f
C614 VCO3_selection_0.inverter_3.out VCO3_selection_0.inverter_0.out 0.01423f
C615 m2_33199_36071# VCO3_selection_0.inverter_2.out 0.41204f
C616 a_33068_41518# VCO3_selection_0.NOR_2in_4.a 0.04729f
C617 VCO3_selection_0.NAND_3in_9.y m2_32865_42661# 0.01152f
C618 row_section_decoding_0.f1_n VCO5_selection_0.NAND_2in_0.b 0.5618f
C619 VCO3_selection_0.NAND_3in_2.y row_section_decoding_0.after_001111 0.71883f
C620 a_31410_26498# 3bit_to_8_outs_0.NAND_3in_6.y 0.06651f
C621 VCO4_5_sel VCO4_selection_0.NAND_2in_0.b 0.38479f
C622 m2_33397_38027# VCO3_selection_0.NAND_3in_0.c 0.69789f
C623 3bit_to_8_outs_0.coarse_1 f1 0.63161f
C624 m2_31328_34835# 3bit_to_8_outs_0.coarse_2 0.0111f
C625 row_section_decoding_0.f1_n 100 0.09554f
C626 row_section_decoding_0.after_000011 m2_30981_45853# 0.01284f
C627 m2_31673_44547# VCO4_selection_0.inverter_2.in 0.0105f
C628 VCO3_selection_0.XNOR_1.y a_32570_40066# 0.07022f
C629 VCO2_selection_0.NOR_2in_0.b VCO2_selection_0.NOR_2in_0.y 0.43472f
C630 VCO3_selection_0.XNOR_0._b f1 2.085f
C631 f1 VCO3_selection_0.XNOR_1._b 2.08701f
C632 VCO4_selection_0.inverter_5.in VCO4_selection_0.NAND_3in_2.y 0.0417f
C633 c1 101 0.02985f
C634 VCO2_selection_0.NOR_2in_2.b VCO2_selection_0.inverter_2.in 0.51081f
C635 VCO3_selection_0.inverter_10.out VCO3_selection_0.NAND_3in_5.y 0.382f
C636 VCO3_selection_0.NAND_3in_9.y row_section_decoding_0.f5_n 0.54645f
C637 VCO2_selection_0.inverter_2.in 3bit_to_8_outs_0.coarse_2 0.31778f
C638 c1 3bit_to_8_outs_0.coarse_2 0.02985f
C639 VCO4_selection_0.XNOR_0.y a_31598_48376# 0.06602f
C640 VCO4_11_sel m2_32353_45771# 0.17624f
C641 VCO4_selection_0.XNOR_0.y f1 0.95466f
C642 row_section_decoding_0.after_000011_n VCO5_selection_0.NAND_2in_0.b 0.96486f
C643 VCO2_selection_0.NAND_3in_3.c a_32087_30284# 0.01742f
C644 VCO2_selection_0.NOR_2in_0.a m2_33238_30191# 0.41184f
C645 f2 row_section_decoding_0.NAND_2in_0.b 0.011f
C646 3bit_to_8_outs_0.inverter_1.in 3bit_to_8_outs_0.c0_n 0.54004f
C647 3bit_to_8_outs_0.NAND_3in_3.y 3bit_to_8_outs_0.NAND_3in_6.y 0.10377f
C648 VCO3_selection_0.NAND_3in_7.c row_section_decoding_0.after_000011_n 0.30526f
C649 row_section_decoding_0.after_000011_n 100 0.93989f
C650 a_31775_29201# VCO5_selection_0.inverter_2.in 0.09922f
C651 c0 row_section_decoding_0.NAND_2in_0.b 0.02056f
C652 m2_32494_47727# VCO4_selection_0.inverter_5.in 0.01096f
C653 a_32252_40540# VCO3_selection_0.NAND_3in_8.y 0.01083f
C654 VCO4_selection_0.NOR_2in_0.b VCO4_5_sel 0.65726f
C655 VCO3_selection_0.NAND_3in_6.b vp 0.35448f
C656 vp VCO4_selection_0.NAND_3in_0.y 0.55661f
C657 row_section_decoding_0.after_001111 m2_32496_34103# 0.01321f
C658 a_32903_35174# VCO2_selection_0.NOR_2in_2.y 0.07285f
C659 3bit_to_8_outs_0.coarse_3 3bit_to_8_outs_0.coarse_0 0.44236f
C660 c2 f0 0.03743f
C661 VCO2_selection_0.NAND_4in_0.d VCO2_5_sel 0.1482f
C662 VCO2_selection_0.NAND_3in_3.c VCO2_selection_0.NOR_2in_0.y 0.01497f
C663 VCO3_selection_0.NAND_2in_0.y vp 0.3141f
C664 a_32303_30284# VCO2_selection_0.NAND_3in_3.y 0.06445f
C665 row_section_decoding_0.after_000011_n VCO3_selection_0.XNOR_1._a 0.01891f
C666 VCO3_selection_0.XNOR_0._a row_section_decoding_0.after_000011_n 0.0189f
C667 3bit_to_8_outs_0.coarse_3 f2 0.05678f
C668 VCO2_selection_0.NAND_4in_0.b VCO2_selection_0.NAND_2in_0.y 0.01384f
C669 a_31060_45946# VCO4_selection_0.inverter_3.in 0.01087f
C670 row_section_decoding_0.after_000011_n VCO2_selection_0.NAND_3in_3.y 0.90507f
C671 3bit_to_8_outs_0.inverter_1.in a_31626_24854# 0.01087f
C672 row_section_decoding_0.f5_n c2 0.04755f
C673 3bit_to_8_outs_0.coarse_3 c0 0.0533f
C674 3bit_to_8_outs_0.inverter_1.in m2_31033_24515# 0.2121f
C675 VCO3_selection_0.inverter_4.in vp 0.35362f
C676 a_33476_38120# a_33692_38120# 0.02238f
C677 f4 vp 0.4679f
C678 VCO2_selection_0.NAND_4in_0.c row_section_decoding_0.f5_n 0.16146f
C679 a_32563_32240# VCO2_selection_0.NAND_4in_0.d 0.01208f
C680 c1 100 0.02985f
C681 3bit_to_8_outs_0.NAND_3in_2.y a_31410_26816# 0.06651f
C682 row_section_decoding_0.after_000111_n VCO2_selection_0.NAND_4in_0.d 0.64883f
C683 vp a_33113_33692# 0.0976f
C684 3bit_to_8_outs_0.coarse_1 VCO4_selection_0.inverter_4.in 0.42136f
C685 a_32564_39564# vp 0.13606f
C686 VCO2_selection_0.inverter_3.in m2_32286_34999# 0.21853f
C687 VCO4_selection_0.NOR_2in_0.a VCO4_selection_0.inverter_5.out 0.32199f
C688 m2_31673_43815# VCO4_selection_0.NOR_2in_0.b 0.01413f
C689 row_section_decoding_0.after_000111 row_section_decoding_0.after_001111_n 3.55085f
C690 3bit_to_8_outs_0.c1_n 3bit_to_8_outs_0.c2_n 4.74896f
C691 f0 vp 21.5031f
C692 a_32779_32240# VCO2_selection_0.NAND_3in_4.y 0.0665f
C693 VCO4_selection_0.inverter_4.in VCO4_selection_0.XNOR_0.y 1.17861f
C694 row_section_decoding_0.after_000011_n VCO3_selection_0.inverter_12.out 0.19827f
C695 VCO5_selection_0.inverter_2.in m2_32217_28954# 0.01096f
C696 VCO3_selection_0.inverter_0.out a_33085_39098# 0.04401f
C697 row_section_decoding_0.f5_n vp 0.8226f
C698 m2_30981_43897# f1 0.65823f
C699 3bit_to_8_outs_0.inverter_8.in 3bit_to_8_outs_0.NAND_3in_2.y 0.36477f
C700 a_31775_29201# VCO5_selection_0.XNOR_0._a 0.09297f
C701 VCO3_selection_0.XNOR_0._b a_32110_38594# 0.04323f
C702 m2_33006_39973# VCO3_selection_0.inverter_12.out 0.09002f
C703 VCO5_selection_0.XNOR_0._b row_section_decoding_0.after_000011_n 0.02579f
C704 vp VCO3_selection_0.NAND_3in_0.c 0.26072f
C705 row_section_decoding_0.after_000011_n VCO4_selection_0.inverter_2.in 0.04072f
C706 a_32494_44968# VCO4_selection_0.inverter_1.in 0.07285f
C707 3bit_to_8_outs_0.coarse_3 3bit_to_8_outs_0.coarse_1 0.85822f
C708 3bit_to_8_outs_0.NAND_3in_6.y vp 0.50587f
C709 3bit_to_8_outs_0.c2_n c2 0.739f
C710 m2_32989_41847# m2_32989_41929# 0.39957f
C711 row_section_decoding_0.after_000011_n VCO5_selection_0.inverter_1.out 0.53986f
C712 m2_31493_41847# f5 0.07259f
C713 VCO3_selection_0.inverter_10.out m2_33405_42661# 0.06034f
C714 3bit_to_8_outs_0.coarse_0 101 0.22777f
C715 3bit_to_8_outs_0.coarse_3 VCO2_selection_0.NAND_4in_0.a 0.06906f
C716 a_31060_43990# f1 0.0131f
C717 3bit_to_8_outs_0.coarse_0 3bit_to_8_outs_0.coarse_2 0.51968f
C718 3bit_to_8_outs_0.c1_n 3bit_to_8_outs_0.c0_n 6.37934f
C719 101 f2 0.05593f
C720 row_section_decoding_0.after_001111 c2 0.04095f
C721 a_31740_45946# row_section_decoding_0.after_000111_n 0.0131f
C722 m2_32768_34103# VCO2_selection_0.inverter_1.in 0.17387f
C723 f2 3bit_to_8_outs_0.coarse_2 0.05712f
C724 a_31407_34670# row_section_decoding_0.after_000011_n 0.01007f
C725 c0 101 0.05418f
C726 row_section_decoding_0.after_000011 a_31250_23355# 0.07078f
C727 VCO4_selection_0.NAND_2in_0.a VCO4_selection_0.inverter_0.out 1.10864f
C728 VCO2_selection_0.NOR_2in_0.b vp 0.29221f
C729 row_section_decoding_0.after_000011 row_section_decoding_0.after_001111_n 0.49414f
C730 VCO2_selection_0.NOR_2in_0.y VCO2_selection_0.inverter_6.out 0.02124f
C731 c0 3bit_to_8_outs_0.coarse_2 0.06551f
C732 111 row_section_decoding_0.f1_n 0.09649f
C733 a_32903_35174# VCO2_selection_0.NOR_2in_2.a 0.04729f
C734 row_section_decoding_0.f5_n VCO3_selection_0.NAND_2in_0.y 0.08976f
C735 c2 3bit_to_8_outs_0.c0_n 4.58879f
C736 a_32058_47902# VCO4_selection_0.XNOR_1._a 0.05886f
C737 f0 f4 0.06413f
C738 3bit_to_8_outs_0.c2_n vp 0.53302f
C739 VCO2_5_sel VCO2_selection_0.inverter_1.out 0.02531f
C740 VCO2_selection_0.NOR_2in_2.b VCO3_selection_0.NAND_2in_1.y 0.01984f
C741 m2_30711_49693# 110 0.0624f
C742 VCO4_selection_0.NAND_3in_1.y m2_32353_45607# 0.22111f
C743 a_31572_36164# row_section_decoding_0.after_000011_n 0.01236f
C744 VCO3_selection_0.XNOR_1._b VCO3_selection_0.NAND_3in_4.y 0.02348f
C745 110 VCO3_selection_0.NAND_3in_8.y 0.51638f
C746 a_32564_39564# f0 0.02767f
C747 row_section_decoding_0.f5_n f4 0.06337f
C748 111 row_section_decoding_0.after_000011_n 1.01449f
C749 c2 f1 0.05535f
C750 row_section_decoding_0.after_001111 vp 0.70558f
C751 VCO4_selection_0.NOR_2in_0.a vp 0.38587f
C752 VCO4_selection_0.inverter_0.out VCO4_selection_0.inverter_3.out 0.0254f
C753 VCO2_selection_0.inverter_2.in a_31407_34670# 0.06997f
C754 row_section_decoding_0.after_000011_n VCO5_selection_0.inverter_2.in 0.10181f
C755 3bit_to_8_outs_0.coarse_0 100 0.17898f
C756 VCO2_selection_0.NAND_3in_3.c vp 0.52274f
C757 m2_32865_42661# row_section_decoding_0.f5_n 0.01378f
C758 VCO2_selection_0.NOR_2in_0.b m2_32972_29945# 0.18965f
C759 c0 VCO5_selection_0.NAND_2in_0.b 0.02124f
C760 f2 100 0.05627f
C761 VCO4_selection_0.inverter_3.in row_section_decoding_0.after_000011_n 0.01553f
C762 3bit_to_8_outs_0.coarse_1 101 0.92809f
C763 row_section_decoding_0.f5_n f0 0.27933f
C764 row_section_decoding_0.after_000011_n VCO4_selection_0.NAND_3in_2.y 0.52194f
C765 VCO2_selection_0.inverter_1.in VCO2_selection_0.NAND_4in_0.a 0.03503f
C766 a_31626_24854# c2 0.0131f
C767 c0 VCO5_11_sel 0.022f
C768 VCO2_selection_0.NOR_2in_2.y VCO3_selection_0.inverter_1.out 0.02178f
C769 row_section_decoding_0.f1_n f3 0.03997f
C770 3bit_to_8_outs_0.coarse_1 3bit_to_8_outs_0.coarse_2 33.4803f
C771 c0 100 0.05336f
C772 101 VCO2_selection_0.NAND_4in_0.a 0.29959f
C773 3bit_to_8_outs_0.c0_n vp 1.68714f
C774 VCO3_selection_0.NAND_2in_1.y VCO3_selection_0.inverter_2.out 0.51472f
C775 VCO4_selection_0.inverter_4.in VCO4_selection_0.inverter_5.out 0.33657f
C776 VCO2_selection_0.inverter_3.in vp 0.35174f
C777 VCO3_selection_0.inverter_8.out VCO3_selection_0.inverter_7.out 1.09977f
C778 VCO4_selection_0.NOR_2in_0.a VCO4_selection_0.NAND_3in_0.y 0.0858f
C779 VCO3_selection_0.NOR_2in_1.y m2_33199_36071# 0.15549f
C780 VCO2_selection_0.inverter_2.in 111 0.21627f
C781 VCO4_selection_0.XNOR_0._a VCO4_selection_0.XNOR_0.y 0.9791f
C782 111 c1 0.02985f
C783 VCO3_selection_0.inverter_8.out VCO3_selection_0.NOR_2in_4.a 0.01383f
C784 a_31740_46420# a_31956_46420# 0.02238f
C785 f1 vp 3.54597f
C786 VCO4_selection_0.XNOR_0._a a_32058_48376# 0.05886f
C787 100 VCO3_selection_0.NAND_2in_1.y 0.35107f
C788 a_31572_38120# a_31788_38120# 0.02238f
C789 VCO2_selection_0.NAND_3in_7.y m2_33238_30191# 0.01521f
C790 a_30783_28315# VCO5_selection_0.inverter_1.in 0.06997f
C791 a_32537_27811# VCO5_selection_0.inverter_1.out 0.0109f
C792 VCO4_selection_0.XNOR_1._a vp 0.32442f
C793 row_section_decoding_0.after_000011_n f3 0.04005f
C794 a_32494_44968# VCO4_selection_0.NOR_2in_1.a 0.04409f
C795 a_32093_32240# row_section_decoding_0.after_000011 0.03993f
C796 VCO2_selection_0.NAND_3in_5.c VCO2_5_sel 0.18246f
C797 m2_32723_41929# m2_32989_41929# 0.01413f
C798 a_31060_45946# row_section_decoding_0.after_000111_n 0.0131f
C799 VCO3_selection_0.NOR_2in_1.y m2_33137_37781# 0.0149f
C800 m2_33407_40623# VCO3_selection_0.NAND_3in_4.y 0.01471f
C801 row_section_decoding_0.after_001111 VCO3_selection_0.inverter_4.in 0.41787f
C802 3bit_to_8_outs_0.coarse_3 VCO4_selection_0.inverter_5.out 0.77398f
C803 row_section_decoding_0.after_001111 f4 0.06327f
C804 VCO4_selection_0.inverter_0.out VCO4_selection_0.NAND_2in_0.b 0.18386f
C805 VCO4_selection_0.inverter_2.out VCO4_selection_0.NOR_2in_1.a 0.01771f
C806 3bit_to_8_outs_0.inverter_8.in 3bit_to_8_outs_0.inverter_10.in 0.17759f
C807 f1 VCO4_selection_0.NAND_3in_0.y 0.52994f
C808 m2_33137_37945# VCO3_selection_0.NAND_3in_0.c 0.01589f
C809 3bit_to_8_outs_0.coarse_1 100 8.48021f
C810 VCO3_selection_0.NAND_3in_7.c VCO3_selection_0.XNOR_0._b 0.51943f
C811 a_33486_41044# VCO3_selection_0.inverter_7.out 0.04579f
C812 VCO5_selection_0.inverter_2.out m2_32477_28872# 0.01415f
C813 row_section_decoding_0.after_000111_n a_31407_30284# 0.0131f
C814 m2_32496_34103# VCO2_selection_0.inverter_1.in 0.16451f
C815 VCO3_11_sel VCO3_selection_0.inverter_5.out 0.05075f
C816 row_section_decoding_0.after_001111 f0 0.31555f
C817 3bit_to_8_outs_0.coarse_0 VCO4_selection_0.inverter_2.in 0.57217f
C818 VCO2_selection_0.NAND_3in_3.c f0 0.3497f
C819 row_section_decoding_0.after_000111 110 1.45845f
C820 3bit_to_8_outs_0.c2_n 3bit_to_8_outs_0.NAND_3in_6.y 0.52425f
C821 m2_30711_49693# VCO_selection_0.NAND_2in_2.y 0.0155f
C822 VCO3_selection_0.inverter_4.out VCO3_selection_0.NAND_3in_7.y 0.02485f
C823 VCO2_selection_0.inverter_6.out vp 0.5341f
C824 VCO4_selection_0.inverter_0.out VCO4_selection_0.NOR_2in_0.b 0.02205f
C825 m2_32933_36071# VCO3_selection_0.inverter_2.out 0.16606f
C826 row_section_decoding_0.after_001111 row_section_decoding_0.f5_n 5.45121f
C827 VCO5_selection_0.inverter_0.in VCO5_selection_0.NAND_2in_0.b 0.0917f
C828 VCO_sel vp 0.38419f
C829 VCO3_selection_0.NAND_3in_9.y m2_32865_42825# 0.22234f
C830 f1 f4 0.06438f
C831 VCO3_selection_0.XNOR_1._b VCO3_selection_0.XNOR_1._a 0.44799f
C832 VCO3_selection_0.XNOR_0._b VCO3_selection_0.XNOR_0._a 0.44799f
C833 3bit_to_8_outs_0.coarse_1 VCO2_selection_0.NAND_3in_3.y 0.02579f
C834 VCO2_selection_0.NOR_2in_2.b m2_32286_34999# 0.21677f
C835 m2_33006_38677# VCO3_selection_0.NAND_3in_0.c 0.14995f
C836 3bit_to_8_outs_0.coarse_3 c2 0.02985f
C837 c0 VCO5_selection_0.inverter_1.out 0.02212f
C838 m2_30981_44547# VCO4_selection_0.inverter_2.in 0.09043f
C839 VCO4_selection_0.inverter_4.in vp 0.50459f
C840 row_section_decoding_0.NAND_2in_0.b vp 0.26916f
C841 m2_33407_40705# m2_33407_40623# 0.39957f
C842 m2_30981_43897# 3bit_to_8_outs_0.coarse_2 0.01005f
C843 m2_32217_28872# m2_32477_28872# 0.0149f
C844 VCO4_selection_0.XNOR_0.y a_32052_48788# 0.09922f
C845 a_31598_48376# f0 0.03549f
C846 f0 f1 7.89941f
C847 a_32828_32714# a_33044_32714# 0.02238f
C848 VCO4_selection_0.XNOR_1._a f0 1.58883f
C849 VCO4_selection_0.inverter_1.in VCO4_5_sel 0.04408f
C850 VCO2_selection_0.NOR_2in_2.y m2_32824_34835# 0.26528f
C851 VCO3_selection_0.inverter_10.out m2_33405_42579# 0.01079f
C852 3bit_to_8_outs_0.NAND_3in_3.y 101 0.41505f
C853 3bit_to_8_outs_0.c0_n 3bit_to_8_outs_0.NAND_3in_6.y 0.54004f
C854 row_section_decoding_0.f5_n f1 0.42864f
C855 VCO3_selection_0.NAND_3in_3.y VCO3_selection_0.NAND_3in_7.y 0.34186f
C856 VCO2_selection_0.inverter_2.in m2_32558_34753# 0.17387f
C857 VCO5_selection_0.inverter_0.in VCO2_selection_0.NAND_3in_3.y 0.02133f
C858 VCO3_selection_0.NAND_3in_9.y 3bit_to_8_outs_0.coarse_2 0.51646f
C859 a_31276_45946# 3bit_to_8_outs_0.coarse_1 0.01001f
C860 m2_33006_39973# m2_33006_39891# 0.16392f
C861 111 3bit_to_8_outs_0.coarse_0 0.17549f
C862 110 VCO2_selection_0.NAND_3in_7.y 0.49593f
C863 m2_33176_31901# VCO2_selection_0.NAND_3in_4.y 0.22234f
C864 a_31476_49868# VCO_sel 0.06545f
C865 3bit_to_8_outs_0.coarse_3 vp 7.31344f
C866 110 row_section_decoding_0.after_000011 1.23883f
C867 111 f2 0.18451f
C868 m2_31673_44629# m2_31939_44629# 0.01413f
C869 VCO2_selection_0.NAND_3in_7.y VCO2_selection_0.NOR_2in_0.a 0.53945f
C870 a_33278_35660# VCO3_selection_0.inverter_2.out 0.01126f
C871 VCO5_selection_0.XNOR_0._b 3bit_to_8_outs_0.coarse_1 0.22511f
C872 111 c0 0.0533f
C873 VCO3_selection_0.NAND_3in_7.y VCO3_selection_0.inverter_0.out 0.43112f
C874 VCO5_selection_0.XNOR_0._b a_31321_28789# 0.04323f
C875 VCO2_selection_0.NAND_4in_0.d a_33260_32714# 0.01119f
C876 row_section_decoding_0.f1_n row_section_decoding_0.after_000111_n 0.14386f
C877 3bit_to_8_outs_0.coarse_0 VCO4_selection_0.inverter_3.in 0.4975f
C878 3bit_to_8_outs_0.inverter_1.in a_31410_24854# 0.06651f
C879 VCO3_selection_0.NAND_3in_1.y row_section_decoding_0.after_000011 0.56495f
C880 VCO3_selection_0.inverter_11.out a_33484_43000# 0.04987f
C881 row_section_decoding_0.f1_n f5 0.26557f
C882 a_32093_32240# VCO2_selection_0.NAND_4in_0.d 0.06647f
C883 3bit_to_8_outs_0.c2_n 3bit_to_8_outs_0.c0_n 1.80627f
C884 101 c2 0.04115f
C885 VCO2_selection_0.inverter_6.out f0 0.017f
C886 row_section_decoding_0.NAND_2in_0.b f4 0.21092f
C887 VCO3_selection_0.NOR_2in_0.y VCO3_selection_0.inverter_5.out 0.06724f
C888 row_section_decoding_0.after_000111_n row_section_decoding_0.after_000011_n 2.12743f
C889 VCO3_selection_0.NAND_3in_3.y row_section_decoding_0.after_000011_n 0.49592f
C890 3bit_to_8_outs_0.coarse_2 c2 0.02985f
C891 f0 VCO_sel 0.01506f
C892 VCO2_selection_0.NOR_2in_1.y vp 0.40099f
C893 VCO2_selection_0.NAND_4in_0.c 101 0.12239f
C894 row_section_decoding_0.after_001111 3bit_to_8_outs_0.c0_n 0.01686f
C895 VCO3_selection_0.NAND_3in_4.y vp 0.50972f
C896 VCO3_selection_0.NAND_3in_3.y m2_33137_37781# 0.17547f
C897 3bit_to_8_outs_0.coarse_0 f3 0.04343f
C898 VCO2_selection_0.inverter_3.in row_section_decoding_0.after_001111 0.0149f
C899 row_section_decoding_0.after_000011_n f5 3.6272f
C900 a_32563_32240# VCO2_selection_0.NAND_3in_4.y 0.01087f
C901 VCO5_selection_0.inverter_2.out VCO5_selection_0.inverter_0.out 0.01069f
C902 VCO5_selection_0.inverter_0.in VCO5_selection_0.inverter_1.out 0.53954f
C903 VCO5_selection_0.inverter_2.in m2_32217_29118# 0.22185f
C904 row_section_decoding_0.after_000111_n VCO2_selection_0.NAND_3in_4.y 0.5199f
C905 VCO3_selection_0.NOR_2in_4.b vp 0.32349f
C906 f2 f3 6.37366f
C907 a_31623_32714# VCO2_selection_0.NAND_4in_0.a 0.06651f
C908 VCO5_selection_0.inverter_0.in m2_32458_28222# 0.06579f
C909 m2_32700_29945# m2_32972_29945# 0.01344f
C910 VCO2_selection_0.NOR_2in_2.y VCO2_selection_0.inverter_1.out 0.01448f
C911 row_section_decoding_0.after_000111 VCO_selection_0.NAND_2in_2.y 0.54593f
C912 a_31260_49868# a_31476_49868# 0.02238f
C913 a_33692_38120# VCO3_11_sel 0.06651f
C914 m2_32451_41929# VCO3_selection_0.NAND_2in_3.y 0.0104f
C915 row_section_decoding_0.after_001111 f1 0.55666f
C916 c0 f3 0.05188f
C917 3bit_to_8_outs_0.c1_n VCO5_11_sel 0.01016f
C918 VCO3_selection_0.inverter_4.in m2_32661_36967# 0.22093f
C919 111 3bit_to_8_outs_0.coarse_1 0.17738f
C920 3bit_to_8_outs_0.coarse_3 f4 0.06316f
C921 VCO2_selection_0.NAND_3in_3.c f1 0.97398f
C922 VCO3_selection_0.NOR_2in_0.y VCO3_11_sel 0.46714f
C923 row_section_decoding_0.after_000111 VCO2_selection_0.NAND_4in_0.b 0.59043f
C924 VCO3_selection_0.inverter_3.out VCO3_selection_0.inverter_5.out 0.01548f
C925 VCO4_selection_0.NOR_2in_1.a VCO4_11_sel 0.01962f
C926 VCO2_selection_0.inverter_1.in vp 0.50624f
C927 3bit_to_8_outs_0.coarse_1 VCO5_selection_0.inverter_2.in 0.42265f
C928 VCO5_selection_0.NAND_2in_0.b a_33013_28315# 0.01292f
C929 VCO3_selection_0.NAND_3in_5.y row_section_decoding_0.after_001111_n 1.18198f
C930 a_33044_32714# VCO2_selection_0.NAND_4in_0.d 0.01181f
C931 a_33345_40066# VCO3_selection_0.NAND_3in_6.c 0.01575f
C932 m2_31328_34835# f5 0.06456f
C933 101 vp 1.42783f
C934 a_31321_28789# VCO5_selection_0.inverter_2.in 0.066f
C935 VCO2_selection_0.NAND_3in_5.c VCO2_11_sel 0.59337f
C936 a_32152_32714# row_section_decoding_0.f5_n 0.01984f
C937 f0 a_32110_38594# 0.03549f
C938 row_section_decoding_0.after_000111_n c1 0.04197f
C939 VCO5_11_sel a_33013_28315# 0.06997f
C940 VCO2_selection_0.NOR_2in_2.b vp 0.3149f
C941 VCO4_selection_0.XNOR_0._a vp 0.31936f
C942 VCO2_selection_0.NOR_2in_2.a m2_32824_34835# 0.10665f
C943 3bit_to_8_outs_0.coarse_2 vp 2.00712f
C944 VCO4_selection_0.inverter_3.in 3bit_to_8_outs_0.coarse_1 0.43899f
C945 VCO3_selection_0.NOR_2in_4.b VCO3_selection_0.NAND_3in_6.b 0.32676f
C946 VCO2_selection_0.inverter_2.in f5 0.3361f
C947 3bit_to_8_outs_0.coarse_3 f0 0.40871f
C948 c1 f5 0.03061f
C949 a_32090_26816# 3bit_to_8_outs_0.c0_n 0.01039f
C950 VCO3_selection_0.NAND_3in_4.y VCO3_selection_0.NAND_2in_0.y 0.01539f
C951 c2 100 0.02985f
C952 VCO4_selection_0.NAND_2in_0.a a_32018_44968# 0.07285f
C953 VCO2_selection_0.NAND_2in_0.y VCO2_selection_0.inverter_0.out 0.40105f
C954 a_31572_40540# a_31788_40540# 0.02238f
C955 VCO2_selection_0.NAND_4in_0.c 100 0.31415f
C956 VCO4_selection_0.inverter_3.in VCO4_selection_0.XNOR_0.y 0.09514f
C957 VCO3_selection_0.NOR_2in_4.b VCO3_selection_0.NAND_2in_0.y 0.51081f
C958 VCO3_selection_0.inverter_10.out VCO3_selection_0.inverter_11.out 0.99891f
C959 3bit_to_8_outs_0.coarse_3 row_section_decoding_0.f5_n 0.26697f
C960 3bit_to_8_outs_0.NAND_3in_0.y 110 0.65524f
C961 VCO4_selection_0.XNOR_1._a f1 0.50728f
C962 VCO4_selection_0.XNOR_0.y VCO4_selection_0.NAND_3in_2.y 0.16986f
C963 m2_32989_41929# VCO3_selection_0.NOR_2in_4.a 0.01349f
C964 m2_33199_36721# m2_33199_36803# 0.39957f
C965 a_31788_36164# VCO3_selection_0.NAND_3in_1.y 0.06651f
C966 3bit_to_8_outs_0.coarse_2 VCO4_selection_0.NAND_3in_0.y 0.5304f
C967 3bit_to_8_outs_0.coarse_1 f3 0.04206f
C968 VCO2_selection_0.NOR_2in_1.y a_33113_33692# 0.07285f
C969 vp VCO3_selection_0.inverter_2.out 0.30157f
C970 3bit_to_8_outs_0.NAND_3in_0.y 3bit_to_8_outs_0.inverter_6.in 0.17759f
C971 101 VCO3_selection_0.NAND_2in_0.y 0.21893f
C972 m2_32841_30841# VCO2_selection_0.inverter_6.out 0.01105f
C973 VCO2_selection_0.NAND_3in_3.c VCO2_selection_0.inverter_6.out 0.06696f
C974 VCO2_selection_0.NOR_2in_2.y VCO2_selection_0.NAND_3in_5.c 0.21058f
C975 VCO5_selection_0.NAND_2in_0.b vp 0.53844f
C976 m2_32494_47809# VCO4_selection_0.XNOR_1._b 0.04693f
C977 VCO2_selection_0.NAND_3in_5.c a_33373_34670# 0.01514f
C978 VCO2_selection_0.XNOR_0._a m2_31328_30191# 0.01201f
C979 VCO4_selection_0.inverter_2.in m2_31673_44793# 0.22234f
C980 VCO5_11_sel vp 0.20122f
C981 VCO3_selection_0.NAND_3in_7.c vp 0.49676f
C982 VCO4_selection_0.inverter_3.out VCO4_selection_0.XNOR_0.y 0.0338f
C983 100 vp 1.60572f
C984 VCO4_selection_0.NOR_2in_0.a VCO4_selection_0.inverter_4.in 0.46318f
C985 a_31939_31170# vp 0.13599f
C986 101 f4 0.06316f
C987 row_section_decoding_0.f5_n VCO3_selection_0.NAND_3in_4.y 0.06263f
C988 3bit_to_8_outs_0.coarse_2 f4 0.06316f
C989 row_section_decoding_0.after_000111 row_section_decoding_0.after_000011 0.5907f
C990 3bit_to_8_outs_0.coarse_1 VCO5_selection_0.XNOR_0._a 0.1759f
C991 m2_31033_27145# 3bit_to_8_outs_0.coarse_1 0.17579f
C992 VCO3_selection_0.XNOR_1._a vp 0.32244f
C993 VCO3_selection_0.XNOR_0._a vp 0.32302f
C994 VCO3_selection_0.NAND_3in_6.b m2_33006_39727# 0.0149f
C995 VCO2_selection_0.inverter_3.in a_31883_34670# 0.06997f
C996 101 f0 0.30819f
C997 VCO3_selection_0.NAND_3in_7.c a_32570_38594# 0.07031f
C998 VCO2_selection_0.NAND_3in_3.y vp 0.52896f
C999 a_32052_48788# vp 0.13606f
C1000 VCO4_selection_0.XNOR_0._a f0 1.58889f
C1001 a_31626_25172# 3bit_to_8_outs_0.NAND_3in_3.y 0.01087f
C1002 3bit_to_8_outs_0.coarse_2 f0 0.39961f
C1003 row_section_decoding_0.after_001111 3bit_to_8_outs_0.coarse_3 0.77732f
C1004 VCO2_selection_0.NAND_3in_7.y m2_31328_30191# 0.10528f
C1005 VCO2_selection_0.inverter_1.in row_section_decoding_0.f5_n 0.55314f
C1006 VCO5_selection_0.NOR_2in_0.y VCO5_selection_0.inverter_0.out 0.28267f
C1007 row_section_decoding_0.after_000011 m2_31328_30191# 0.01903f
C1008 VCO4_selection_0.inverter_4.in f1 0.01138f
C1009 101 row_section_decoding_0.f5_n 1.22983f
C1010 m2_33407_40623# VCO3_selection_0.NAND_3in_6.c 0.15304f
C1011 f1 row_section_decoding_0.NAND_2in_0.b 1.32783f
C1012 row_section_decoding_0.f5_n 3bit_to_8_outs_0.coarse_2 0.76547f
C1013 3bit_to_8_outs_0.NAND_3in_3.y a_31410_25172# 0.06651f
C1014 a_33085_39098# VCO3_selection_0.inverter_5.out 0.01126f
C1015 VCO2_selection_0.NOR_2in_1.y m2_33294_34753# 0.03251f
C1016 VCO3_selection_0.NAND_3in_9.y VCO3_selection_0.inverter_10.out 0.44204f
C1017 VCO5_selection_0.inverter_0.in a_32772_28789# 0.06817f
C1018 VCO3_selection_0.inverter_4.out m2_32661_36721# 0.09002f
C1019 VCO2_selection_0.inverter_4.out VCO2_selection_0.XNOR_0._a 0.01042f
C1020 3bit_to_8_outs_0.coarse_0 row_section_decoding_0.after_000111_n 0.28067f
C1021 m2_31493_40623# VCO3_selection_0.NAND_3in_4.y 0.10528f
C1022 VCO3_selection_0.NAND_3in_3.y 3bit_to_8_outs_0.coarse_0 0.03584f
C1023 m2_32934_28222# VCO5_selection_0.NOR_2in_0.y 0.01152f
C1024 VCO3_selection_0.XNOR_0._a a_32570_38594# 0.05886f
C1025 a_33484_43000# vp 0.0976f
C1026 3bit_to_8_outs_0.coarse_2 3bit_to_8_outs_0.NAND_3in_6.y 0.41518f
C1027 row_section_decoding_0.after_000111_n f2 0.05912f
C1028 row_section_decoding_0.after_000011_n VCO3_selection_0.NAND_2in_3.y 0.42604f
C1029 3bit_to_8_outs_0.coarse_0 f5 0.22182f
C1030 f4 100 0.06316f
C1031 3bit_to_8_outs_0.inverter_8.in a_32306_26816# 0.02085f
C1032 VCO3_selection_0.inverter_12.out vp 0.33319f
C1033 VCO2_selection_0.NAND_3in_7.y row_section_decoding_0.after_000011 0.60883f
C1034 VCO3_selection_0.NOR_2in_0.y VCO3_selection_0.inverter_3.out 0.25426f
C1035 row_section_decoding_0.f1_n row_section_decoding_0.after_001111_n 0.51621f
C1036 row_section_decoding_0.after_000111_n c0 0.09569f
C1037 a_31407_34196# row_section_decoding_0.f5_n 0.0131f
C1038 f2 f5 0.38217f
C1039 VCO4_selection_0.inverter_5.out VCO4_selection_0.NAND_3in_2.y 0.89505f
C1040 a_32556_28789# row_section_decoding_0.after_000011_n 0.018f
C1041 VCO3_selection_0.NAND_3in_6.a m2_33405_42661# 0.2674f
C1042 VCO5_selection_0.inverter_2.out m2_32217_28872# 0.09002f
C1043 VCO2_selection_0.NOR_2in_2.a VCO2_selection_0.inverter_0.out 0.01559f
C1044 3bit_to_8_outs_0.coarse_3 f1 0.48465f
C1045 f2 row_section_decoding_0.NAND_2in_0.a 0.16246f
C1046 3bit_to_8_outs_0.inverter_8.in 3bit_to_8_outs_0.coarse_0 0.38894f
C1047 3bit_to_8_outs_0.coarse_3 VCO4_selection_0.XNOR_1._a 0.01861f
C1048 VCO3_selection_0.NAND_3in_7.c a_32252_38120# 0.01977f
C1049 c0 f5 0.0704f
C1050 a_31626_25172# c2 0.0131f
C1051 VCO4_selection_0.inverter_1.in VCO4_selection_0.inverter_0.out 0.15775f
C1052 VCO5_selection_0.XNOR_0._b vp 0.39558f
C1053 VCO3_selection_0.NAND_3in_7.c f0 0.34564f
C1054 VCO4_selection_0.inverter_2.in vp 0.55737f
C1055 f0 100 0.26426f
C1056 a_33278_35660# VCO3_selection_0.NOR_2in_1.y 0.07285f
C1057 VCO3_selection_0.NOR_2in_1.y m2_33397_38027# 0.01464f
C1058 a_31939_31170# f0 0.13412f
C1059 VCO5_selection_0.inverter_1.out vp 0.30074f
C1060 3bit_to_8_outs_0.NAND_3in_3.y m2_31033_25501# 0.2121f
C1061 row_section_decoding_0.after_000111 a_31266_50186# 0.01521f
C1062 m2_31181_49775# VCO_selection_0.NAND_2in_2.y 0.67854f
C1063 VCO2_selection_0.NAND_3in_7.y a_31623_30284# 0.06699f
C1064 row_section_decoding_0.after_000011_n row_section_decoding_0.after_001111_n 0.56891f
C1065 m2_32494_47727# VCO4_selection_0.inverter_5.out 0.17624f
C1066 m2_32661_36071# VCO3_selection_0.inverter_2.out 0.09002f
C1067 3bit_to_8_outs_0.inverter_8.in c0 0.45239f
C1068 m2_32865_37945# m2_33137_37945# 0.01344f
C1069 m2_32496_33857# VCO2_selection_0.inverter_0.out 0.2201f
C1070 row_section_decoding_0.f1_n a_31303_28315# 0.0131f
C1071 VCO3_selection_0.NAND_3in_7.c row_section_decoding_0.f5_n 0.01352f
C1072 VCO3_selection_0.NAND_3in_8.y VCO3_selection_0.NOR_2in_4.a 0.01519f
C1073 VCO3_selection_0.inverter_12.out VCO3_selection_0.NAND_3in_6.b 0.10522f
C1074 111 c2 0.02985f
C1075 a_32564_39564# VCO3_selection_0.XNOR_1._a 0.09297f
C1076 row_section_decoding_0.f5_n 100 0.67583f
C1077 3bit_to_8_outs_0.c2_n 3bit_to_8_outs_0.coarse_2 0.01136f
C1078 VCO3_selection_0.XNOR_1.y VCO3_selection_0.XNOR_1._b 0.57839f
C1079 VCO_selection_0.NAND_2in_0.y 110 0.29972f
C1080 VCO2_5_sel VCO2_selection_0.NAND_4in_0.a 0.4876f
C1081 111 VCO2_selection_0.NAND_4in_0.c 0.18695f
C1082 row_section_decoding_0.after_001111 VCO2_selection_0.inverter_1.in 0.71909f
C1083 VCO3_selection_0.NAND_3in_7.c VCO3_selection_0.NAND_3in_0.c 0.03048f
C1084 m2_32824_34753# m2_33294_34753# 0.01451f
C1085 row_section_decoding_0.after_001111 101 0.22782f
C1086 f0 VCO3_selection_0.XNOR_1._a 1.72583f
C1087 VCO3_selection_0.XNOR_0._a f0 1.7247f
C1088 VCO2_selection_0.NAND_4in_0.b VCO2_selection_0.NAND_4in_0.d 0.04636f
C1089 VCO3_selection_0.NAND_3in_2.y VCO3_selection_0.inverter_4.out 0.51081f
C1090 row_section_decoding_0.after_001111 3bit_to_8_outs_0.coarse_2 0.24388f
C1091 VCO4_selection_0.NOR_2in_0.a 3bit_to_8_outs_0.coarse_2 0.02579f
C1092 VCO4_selection_0.inverter_2.in VCO4_selection_0.NAND_3in_0.y 0.03972f
C1093 a_32090_26498# a_32306_26498# 0.02238f
C1094 a_32052_48788# f0 0.02647f
C1095 row_section_decoding_0.after_000111_n 3bit_to_8_outs_0.coarse_1 0.42076f
C1096 VCO4_selection_0.NAND_2in_0.a VCO4_selection_0.NAND_3in_1.y 0.02902f
C1097 VCO4_selection_0.NAND_3in_1.y VCO4_selection_0.inverter_3.in 0.40182f
C1098 VCO4_selection_0.NAND_3in_1.y VCO4_selection_0.NAND_3in_2.y 0.02338f
C1099 VCO3_selection_0.NAND_3in_3.y VCO3_selection_0.XNOR_0._b 0.02375f
C1100 VCO3_selection_0.inverter_1.out VCO3_selection_0.inverter_3.out 0.02854f
C1101 3bit_to_8_outs_0.coarse_1 f5 1.60622f
C1102 m2_30761_24515# m2_31033_24515# 0.01344f
C1103 c1 row_section_decoding_0.after_001111_n 0.04172f
C1104 m2_32989_41847# VCO3_selection_0.NOR_2in_4.a 0.10665f
C1105 VCO3_selection_0.NAND_3in_3.y a_32468_38120# 0.01157f
C1106 a_31592_47400# vp 0.13599f
C1107 a_31945_30758# f0 0.03549f
C1108 VCO3_selection_0.inverter_10.out vp 0.30235f
C1109 a_31060_43990# a_31276_43990# 0.02238f
C1110 m2_30711_49693# VCO_selection_0.NAND_2in_0.y 0.25957f
C1111 111 vp 1.72531f
C1112 row_section_decoding_0.after_000011_n a_32252_40540# 0.01003f
C1113 m2_33176_32065# VCO2_selection_0.NAND_3in_4.y 0.01152f
C1114 VCO2_selection_0.inverter_3.in VCO2_selection_0.NOR_2in_2.b 0.4032f
C1115 m2_31493_40623# 100 0.01011f
C1116 3bit_to_8_outs_0.inverter_8.in 3bit_to_8_outs_0.coarse_1 0.65802f
C1117 VCO5_selection_0.inverter_2.in vp 0.48323f
C1118 VCO3_selection_0.inverter_4.out a_33278_37142# 0.0109f
C1119 101 f1 0.39102f
C1120 VCO3_selection_0.XNOR_0._b VCO3_selection_0.inverter_0.out 0.06329f
C1121 3bit_to_8_outs_0.coarse_3 VCO4_selection_0.inverter_4.in 0.51342f
C1122 a_31740_45946# a_31956_45946# 0.02238f
C1123 VCO4_selection_0.XNOR_0._a f1 0.50732f
C1124 3bit_to_8_outs_0.coarse_2 f1 0.53491f
C1125 3bit_to_8_outs_0.inverter_6.in 3bit_to_8_outs_0.inverter_10.in 0.05233f
C1126 VCO4_selection_0.XNOR_0._a VCO4_selection_0.XNOR_1._a 0.02854f
C1127 VCO3_selection_0.NAND_3in_3.y VCO3_selection_0.NAND_3in_2.y 0.02973f
C1128 VCO4_selection_0.NAND_2in_0.a vp 0.3163f
C1129 VCO5_selection_0.inverter_1.in row_section_decoding_0.f1_n 1.27619f
C1130 VCO4_selection_0.inverter_3.in vp 0.50179f
C1131 VCO4_selection_0.NAND_3in_2.y vp 0.57586f
C1132 3bit_to_8_outs_0.NAND_3in_0.y a_32306_24854# 0.02085f
C1133 row_section_decoding_0.after_001111 100 0.33961f
C1134 VCO3_selection_0.NAND_3in_9.y VCO4_selection_0.NAND_2in_0.b 0.01934f
C1135 VCO5_selection_0.XNOR_0._b f0 0.39684f
C1136 3bit_to_8_outs_0.inverter_1.in row_section_decoding_0.NAND_2in_0.a 0.01103f
C1137 m2_32841_30923# m2_32841_30841# 0.39957f
C1138 VCO3_selection_0.NAND_3in_6.c vp 0.19034f
C1139 a_31939_31170# VCO2_selection_0.NAND_3in_3.c 0.09342f
C1140 3bit_to_8_outs_0.coarse_1 m2_30981_45853# 0.01924f
C1141 VCO4_selection_0.NAND_2in_0.a m2_31939_44629# 0.27756f
C1142 VCO2_selection_0.XNOR_0._b vp 0.29778f
C1143 VCO5_selection_0.inverter_1.in row_section_decoding_0.after_000011_n 0.84249f
C1144 a_33068_41518# vp 0.0976f
C1145 VCO4_selection_0.inverter_0.out VCO4_selection_0.NOR_2in_1.a 0.0822f
C1146 f3 vp 0.88066f
C1147 row_section_decoding_0.after_000011 VCO2_selection_0.NAND_4in_0.d 0.76415f
C1148 VCO4_selection_0.inverter_3.out vp 0.28144f
C1149 VCO4_selection_0.XNOR_0.y m2_30981_45853# 0.01903f
C1150 3bit_to_8_outs_0.c2_n a_31626_26816# 0.01312f
C1151 m2_31925_23438# row_section_decoding_0.after_001111_n 0.03428f
C1152 VCO3_selection_0.NOR_2in_1.y vp 0.33239f
C1153 VCO2_selection_0.inverter_3.in 100 0.02663f
C1154 a_31407_32714# VCO2_selection_0.NAND_4in_0.a 0.01087f
C1155 VCO5_selection_0.inverter_0.in m2_32192_28222# 0.03487f
C1156 VCO_selection_0.NAND_2in_1.y VCO_selection_0.NAND_2in_2.y 0.25355f
C1157 a_33561_40066# VCO3_5_sel 0.06627f
C1158 111 f4 0.06316f
C1159 VCO3_selection_0.NAND_3in_7.c f1 1.0069f
C1160 VCO2_selection_0.NAND_3in_3.c VCO2_selection_0.NAND_3in_3.y 0.70867f
C1161 101 VCO2_selection_0.inverter_6.out 0.08752f
C1162 a_31060_44464# a_31276_44464# 0.02238f
C1163 VCO3_selection_0.NAND_3in_6.c VCO3_selection_0.NAND_3in_6.b 1.31087f
C1164 f1 100 0.42959f
C1165 m2_32841_30923# f1 0.01037f
C1166 m2_32865_37781# VCO3_selection_0.inverter_0.out 0.17579f
C1167 VCO_selection_0.NAND_2in_0.y VCO_selection_0.NAND_2in_2.y 0.36823f
C1168 3bit_to_8_outs_0.coarse_1 a_31315_29201# 0.01382f
C1169 VCO4_selection_0.XNOR_0._a VCO_sel 0.02319f
C1170 a_32828_32714# VCO2_selection_0.NAND_4in_0.d 0.05174f
C1171 a_33068_41518# VCO3_selection_0.NAND_3in_6.b 0.07327f
C1172 VCO3_selection_0.inverter_10.out m2_32865_42661# 0.17624f
C1173 VCO3_selection_0.NAND_3in_3.y m2_33397_38027# 0.0161f
C1174 m2_32477_28872# row_section_decoding_0.after_000011_n 0.69802f
C1175 a_32306_26498# 3bit_to_8_outs_0.inverter_10.in 0.02085f
C1176 a_31592_47400# f0 0.13409f
C1177 VCO5_selection_0.XNOR_0._a vp 0.29066f
C1178 VCO2_selection_0.NAND_3in_3.c a_31945_30758# 0.0662f
C1179 111 f0 0.34364f
C1180 m2_30761_27145# 3bit_to_8_outs_0.coarse_0 0.17823f
C1181 a_33317_29780# VCO2_selection_0.NOR_2in_0.y 0.07288f
C1182 f1 VCO3_selection_0.XNOR_1._a 0.78301f
C1183 VCO3_selection_0.XNOR_0._a f1 0.78301f
C1184 VCO5_selection_0.inverter_2.in f0 0.36958f
C1185 VCO_selection_0.NAND_2in_1.y row_section_decoding_0.after_000111 0.58851f
C1186 VCO2_selection_0.NOR_2in_2.a VCO2_selection_0.inverter_2.in 0.51667f
C1187 m2_30981_46503# row_section_decoding_0.after_000011_n 0.67368f
C1188 a_30774_22377# vp 0.10023f
C1189 101 a_32152_32714# 0.01206f
C1190 111 row_section_decoding_0.f5_n 33.1709f
C1191 3bit_to_8_outs_0.coarse_0 row_section_decoding_0.after_001111_n 0.23481f
C1192 m2_32723_41929# VCO3_selection_0.NOR_2in_4.a 0.09062f
C1193 f0 VCO4_selection_0.NAND_3in_2.y 0.01146f
C1194 f2 row_section_decoding_0.after_001111_n 0.05822f
C1195 110 row_section_decoding_0.f1_n 0.09566f
C1196 f3 f4 0.71644f
C1197 a_32494_43990# VCO4_5_sel 0.06997f
C1198 3bit_to_8_outs_0.coarse_3 VCO2_selection_0.inverter_1.in 0.41466f
C1199 a_31276_43990# VCO4_selection_0.NAND_3in_0.y 0.06651f
C1200 c0 row_section_decoding_0.after_001111_n 0.10187f
C1201 vp VCO4_selection_0.NAND_2in_0.b 0.28019f
C1202 m2_33405_42579# VCO3_selection_0.NAND_3in_6.a 0.15559f
C1203 VCO4_selection_0.NAND_3in_1.y m2_32353_45771# 0.01152f
C1204 3bit_to_8_outs_0.coarse_3 101 0.26375f
C1205 m2_30981_44547# row_section_decoding_0.after_001111_n 0.65782f
C1206 a_32306_25172# 3bit_to_8_outs_0.inverter_6.in 0.02085f
C1207 m2_32841_30923# VCO2_selection_0.inverter_6.out 0.01421f
C1208 3bit_to_8_outs_0.coarse_3 3bit_to_8_outs_0.coarse_2 35.4632f
C1209 VCO2_selection_0.XNOR_0._b f0 0.39339f
C1210 row_section_decoding_0.after_000111 VCO3_selection_0.NAND_3in_5.y 0.75372f
C1211 m2_33407_40623# VCO3_selection_0.inverter_8.out 0.01079f
C1212 VCO2_selection_0.NAND_4in_0.c VCO2_5_sel 0.80763f
C1213 m2_30761_26159# 3bit_to_8_outs_0.coarse_3 0.17582f
C1214 a_31788_36638# a_31572_36638# 0.02238f
C1215 f3 f0 0.0481f
C1216 110 row_section_decoding_0.after_000011_n 8.70495f
C1217 a_31276_44464# VCO4_selection_0.inverter_2.in 0.06651f
C1218 VCO2_selection_0.NAND_4in_0.b VCO2_selection_0.inverter_0.out 0.01263f
C1219 VCO2_selection_0.NAND_4in_0.c a_31407_32240# 0.07014f
C1220 a_31410_24854# a_31626_24854# 0.02238f
C1221 3bit_to_8_outs_0.c1_n 3bit_to_8_outs_0.inverter_8.in 0.70113f
C1222 VCO3_selection_0.inverter_4.out vp 0.31375f
C1223 f3 row_section_decoding_0.f5_n 0.03981f
C1224 row_section_decoding_0.after_000111_n c2 0.04409f
C1225 VCO4_selection_0.NOR_2in_0.b vp 0.23303f
C1226 VCO3_selection_0.NAND_3in_1.y row_section_decoding_0.after_000011_n 0.76198f
C1227 VCO5_selection_0.XNOR_0._b f1 2.07979f
C1228 a_32368_32714# VCO2_selection_0.NAND_4in_0.b 0.06402f
C1229 row_section_decoding_0.after_000111_n VCO2_selection_0.NAND_4in_0.c 0.35681f
C1230 VCO4_selection_0.NAND_3in_1.y row_section_decoding_0.after_000111_n 0.52199f
C1231 c2 f5 0.05601f
C1232 VCO3_selection_0.NOR_2in_1.y VCO3_selection_0.NAND_3in_0.c 0.16899f
C1233 VCO2_5_sel vp 0.40582f
C1234 VCO3_selection_0.XNOR_1.y vp 0.55498f
C1235 VCO3_selection_0.NAND_3in_7.c a_32110_38594# 0.06622f
C1236 VCO2_selection_0.NAND_4in_0.c f5 0.29116f
C1237 111 row_section_decoding_0.after_001111 0.34344f
C1238 VCO2_selection_0.NAND_2in_0.y VCO2_selection_0.NAND_4in_0.a 0.03514f
C1239 3bit_to_8_outs_0.coarse_1 row_section_decoding_0.after_001111_n 0.21867f
C1240 VCO5_selection_0.XNOR_0._a f0 1.59096f
C1241 111 VCO2_selection_0.NAND_3in_3.c 0.01279f
C1242 a_32779_32240# VCO2_selection_0.inverter_6.out 0.01409f
C1243 row_section_decoding_0.after_001111_n VCO2_selection_0.NAND_4in_0.a 0.58406f
C1244 row_section_decoding_0.after_000011_n VCO3_selection_0.NAND_3in_8.y 0.70925f
C1245 110 c1 0.02985f
C1246 VCO3_selection_0.NAND_3in_7.c 3bit_to_8_outs_0.coarse_3 0.09522f
C1247 3bit_to_8_outs_0.coarse_3 100 34.1737f
C1248 VCO4_selection_0.inverter_0.out m2_31673_43651# 0.17579f
C1249 m2_33034_34021# VCO2_selection_0.inverter_1.out 0.10665f
C1250 VCO5_selection_0.inverter_0.in a_32556_28789# 0.01158f
C1251 VCO4_selection_0.inverter_2.out m2_31673_44547# 0.09062f
C1252 VCO4_selection_0.NAND_2in_0.a VCO4_selection_0.NOR_2in_0.a 0.08445f
C1253 m2_32451_41929# m2_32723_41929# 0.01344f
C1254 VCO3_selection_0.inverter_4.out m2_33199_36803# 0.03221f
C1255 row_section_decoding_0.after_000111_n vp 1.24264f
C1256 VCO4_selection_0.NOR_2in_0.a VCO4_selection_0.NAND_3in_2.y 0.44928f
C1257 VCO3_selection_0.NAND_3in_3.y vp 0.57062f
C1258 VCO5_selection_0.inverter_1.in 3bit_to_8_outs_0.coarse_0 0.32434f
C1259 m2_33137_37781# VCO3_selection_0.inverter_5.out 0.17554f
C1260 a_30790_50186# VCO_selection_0.NAND_2in_2.y 0.07006f
C1261 VCO2_selection_0.inverter_3.in 111 0.4599f
C1262 row_section_decoding_0.after_000011_n a_32048_42022# 0.04035f
C1263 f5 vp 0.9231f
C1264 101 3bit_to_8_outs_0.coarse_2 0.30019f
C1265 a_32090_24854# a_32306_24854# 0.02238f
C1266 VCO2_selection_0.inverter_4.out m2_33323_30841# 0.09124f
C1267 row_section_decoding_0.NAND_2in_0.a vp 0.33336f
C1268 111 f1 0.41429f
C1269 VCO3_selection_0.inverter_4.in VCO3_selection_0.inverter_4.out 0.40573f
C1270 a_31986_22377# vp 0.09776f
C1271 vp VCO3_selection_0.inverter_0.out 0.43303f
C1272 3bit_to_8_outs_0.inverter_8.in vp 0.51105f
C1273 f2 a_30774_23859# 0.04379f
C1274 VCO5_selection_0.inverter_2.in f1 0.95418f
C1275 m2_32286_34753# row_section_decoding_0.after_000011_n 0.01321f
C1276 row_section_decoding_0.after_001111 f3 0.0399f
C1277 VCO2_selection_0.XNOR_0._b m2_32841_30841# 0.04721f
C1278 VCO2_selection_0.NAND_3in_3.y m2_32700_29945# 0.22234f
C1279 VCO2_selection_0.NAND_3in_3.c VCO2_selection_0.XNOR_0._b 0.53965f
C1280 a_33317_29780# vp 0.0976f
C1281 VCO4_selection_0.NOR_2in_0.a VCO4_selection_0.inverter_3.out 0.03291f
C1282 a_31407_34196# VCO2_selection_0.inverter_1.in 0.01087f
C1283 VCO3_selection_0.NAND_3in_4.y 100 0.36877f
C1284 VCO2_selection_0.NOR_2in_2.b m2_32824_34753# 0.01079f
C1285 VCO_selection_0.NAND_2in_1.y a_31266_50186# 0.06983f
C1286 VCO2_selection_0.NAND_3in_7.y a_31407_30284# 0.01108f
C1287 m2_32494_47809# VCO4_selection_0.inverter_5.out 0.09002f
C1288 m2_33034_34021# VCO2_selection_0.inverter_0.out 0.03221f
C1289 m2_32496_34103# VCO2_selection_0.NAND_2in_0.y 0.0104f
C1290 VCO3_selection_0.NAND_3in_6.a VCO3_selection_0.inverter_11.out 0.21565f
C1291 VCO5_selection_0.inverter_2.out m2_32217_28954# 0.17624f
C1292 a_32564_39564# VCO3_selection_0.XNOR_1.y 0.09922f
C1293 a_32110_40066# VCO3_selection_0.XNOR_1._b 0.04323f
C1294 VCO2_selection_0.NOR_2in_2.a VCO3_selection_0.NAND_2in_1.y 0.01186f
C1295 VCO4_selection_0.inverter_2.out VCO4_selection_0.inverter_0.out 0.74277f
C1296 m2_33034_34103# m2_33034_34021# 0.39957f
C1297 m2_31673_44629# VCO4_selection_0.inverter_2.in 0.01152f
C1298 f5 VCO3_selection_0.NAND_2in_0.y 0.29076f
C1299 VCO2_selection_0.inverter_1.in 100 0.36751f
C1300 VCO2_selection_0.XNOR_0._b f1 2.07983f
C1301 3bit_to_8_outs_0.coarse_2 VCO5_selection_0.NAND_2in_0.b 0.36817f
C1302 m2_32494_47727# f1 0.01037f
C1303 VCO3_selection_0.XNOR_1.y f0 0.36836f
C1304 101 100 35.542f
C1305 row_section_decoding_0.after_000111_n f4 0.7922f
C1306 m2_32286_34753# VCO2_selection_0.inverter_2.in 0.16451f
C1307 a_31407_30284# a_31623_30284# 0.02238f
C1308 VCO2_selection_0.NAND_3in_5.c VCO2_selection_0.inverter_4.out 0.91551f
C1309 f3 f1 1.89832f
C1310 row_section_decoding_0.after_000111 row_section_decoding_0.f1_n 43.299f
C1311 3bit_to_8_outs_0.coarse_2 100 9.05582f
C1312 VCO5_selection_0.inverter_1.in 3bit_to_8_outs_0.coarse_1 0.01026f
C1313 a_32920_31262# VCO2_selection_0.inverter_4.out 0.0109f
C1314 a_32399_31170# vp 0.13606f
C1315 VCO3_selection_0.inverter_8.out vp 0.31497f
C1316 VCO_selection_0.NAND_2in_1.y m2_31181_49775# 0.04997f
C1317 f5 f4 3.64398f
C1318 VCO3_selection_0.inverter_3.out m2_32933_36721# 0.09062f
C1319 m2_32865_37945# VCO3_selection_0.NAND_3in_7.c 0.01387f
C1320 VCO3_selection_0.NAND_3in_3.y a_32252_38120# 0.01516f
C1321 row_section_decoding_0.after_000111_n f0 0.36412f
C1322 m2_31181_49775# VCO_selection_0.NAND_2in_0.y 0.01316f
C1323 a_31986_22377# f4 0.04379f
C1324 m2_32217_28872# m2_32217_28954# 0.16392f
C1325 row_section_decoding_0.after_000111 row_section_decoding_0.after_000011_n 51.2144f
C1326 a_31315_29201# vp 0.13599f
C1327 VCO4_selection_0.NOR_2in_0.a VCO4_selection_0.NAND_2in_0.b 0.31477f
C1328 110 3bit_to_8_outs_0.coarse_0 0.21316f
C1329 VCO3_selection_0.NAND_3in_4.y VCO3_selection_0.inverter_12.out 1.33397f
C1330 f0 f5 0.66212f
C1331 row_section_decoding_0.after_000111_n row_section_decoding_0.f5_n 0.81454f
C1332 VCO3_selection_0.NAND_3in_3.y row_section_decoding_0.f5_n 0.06257f
C1333 VCO4_selection_0.XNOR_0._a a_32052_48788# 0.09297f
C1334 a_31592_48788# VCO4_selection_0.XNOR_0.y 0.09334f
C1335 VCO5_selection_0.XNOR_0._a f1 0.50697f
C1336 VCO3_selection_0.inverter_8.out VCO3_selection_0.NAND_3in_6.b 0.02513f
C1337 110 f2 0.05894f
C1338 VCO5_selection_0.inverter_0.in VCO5_selection_0.inverter_1.in 0.10414f
C1339 a_32537_27811# VCO5_selection_0.inverter_0.out 0.04729f
C1340 VCO3_selection_0.NAND_3in_3.y VCO3_selection_0.NAND_3in_0.c 0.07926f
C1341 row_section_decoding_0.f5_n f5 2.14358f
C1342 f0 VCO3_selection_0.inverter_0.out 0.01414f
C1343 VCO5_selection_0.NAND_2in_0.b VCO5_11_sel 0.54469f
C1344 110 c0 0.0533f
C1345 a_32779_32240# 101 0.01018f
C1346 VCO4_selection_0.inverter_3.in VCO4_selection_0.inverter_4.in 0.03164f
C1347 3bit_to_8_outs_0.NAND_3in_0.y a_32090_24854# 0.07661f
C1348 VCO4_selection_0.inverter_4.in VCO4_selection_0.NAND_3in_2.y 0.38998f
C1349 VCO2_selection_0.XNOR_0._b VCO2_selection_0.inverter_6.out 0.05403f
C1350 a_33486_41044# vp 0.0976f
C1351 row_section_decoding_0.f1_n row_section_decoding_0.after_000011 0.12316f
C1352 3bit_to_8_outs_0.coarse_1 m2_30981_46503# 0.01835f
C1353 VCO5_selection_0.inverter_2.out row_section_decoding_0.after_000011_n 0.32128f
C1354 a_31740_46420# row_section_decoding_0.after_000011_n 0.0131f
C1355 VCO4_selection_0.NOR_2in_0.b VCO4_selection_0.NOR_2in_0.a 2.11259f
C1356 111 3bit_to_8_outs_0.coarse_3 0.21255f
C1357 3bit_to_8_outs_0.inverter_6.in c0 0.45306f
C1358 VCO3_selection_0.inverter_0.out VCO3_selection_0.NAND_3in_0.c 0.23019f
C1359 row_section_decoding_0.after_000111 c1 0.04265f
C1360 VCO2_selection_0.NAND_3in_7.y a_32303_30284# 0.01228f
C1361 VCO3_selection_0.NAND_3in_3.y m2_33137_37945# 0.17539f
C1362 VCO2_selection_0.NOR_2in_0.y m2_33238_30191# 0.16365f
C1363 VCO4_selection_0.XNOR_0.y m2_30981_46503# 0.09561f
C1364 VCO4_selection_0.NOR_2in_1.a VCO4_selection_0.XNOR_0.y 2.90092f
C1365 a_32258_36638# VCO3_selection_0.inverter_4.in 0.06997f
C1366 VCO3_selection_0.NAND_3in_7.c VCO3_selection_0.XNOR_0._a 0.94156f
C1367 VCO2_selection_0.NAND_3in_7.y row_section_decoding_0.after_000011_n 0.36289f
C1368 VCO3_selection_0.NAND_3in_1.y VCO3_selection_0.NAND_2in_1.y 0.77668f
C1369 m2_31493_40623# row_section_decoding_0.after_000111_n 0.65835f
C1370 VCO5_selection_0.inverter_0.in m2_32477_28872# 0.12283f
C1371 c2 row_section_decoding_0.after_001111_n 0.0408f
C1372 row_section_decoding_0.after_000011 row_section_decoding_0.after_000011_n 0.9172f
C1373 VCO2_11_sel vp 0.35955f
C1374 f3 row_section_decoding_0.NAND_2in_0.b 0.10041f
C1375 f1 m2_33006_39891# 0.01037f
C1376 3bit_to_8_outs_0.coarse_3 VCO4_selection_0.NAND_3in_2.y 0.53974f
C1377 VCO5_selection_0.XNOR_0._b 3bit_to_8_outs_0.coarse_2 0.02129f
C1378 m2_33407_40705# VCO3_selection_0.inverter_12.out 0.01366f
C1379 VCO3_selection_0.NAND_2in_3.y vp 0.35059f
C1380 a_32399_31170# f0 0.02647f
C1381 VCO2_selection_0.NAND_3in_5.c VCO2_selection_0.NAND_4in_0.d 0.02022f
C1382 row_section_decoding_0.after_000011 VCO2_selection_0.NAND_3in_4.y 0.60087f
C1383 m2_30761_24515# 111 0.17552f
C1384 VCO2_selection_0.NAND_3in_3.c m2_32700_30109# 0.01387f
C1385 110 3bit_to_8_outs_0.coarse_1 0.23364f
C1386 VCO2_selection_0.NOR_2in_0.b a_33317_29780# 0.0144f
C1387 VCO3_selection_0.inverter_10.out m2_32865_42825# 0.21677f
C1388 row_section_decoding_0.after_001111 row_section_decoding_0.after_000111_n 0.79931f
C1389 a_31407_32714# row_section_decoding_0.f5_n 0.01007f
C1390 a_31572_42496# row_section_decoding_0.after_001111_n 0.0131f
C1391 VCO3_selection_0.XNOR_0._a VCO3_selection_0.XNOR_1._a 0.02878f
C1392 a_32090_26498# 3bit_to_8_outs_0.inverter_10.in 0.07661f
C1393 110 VCO2_selection_0.NAND_4in_0.a 0.36459f
C1394 3bit_to_8_outs_0.coarse_1 VCO2_selection_0.NOR_2in_0.a 0.0151f
C1395 VCO3_selection_0.inverter_1.out m2_33199_36071# 0.01349f
C1396 VCO2_selection_0.NAND_3in_3.c row_section_decoding_0.after_000111_n 0.0165f
C1397 c0 VCO5_selection_0.inverter_0.out 0.042f
C1398 row_section_decoding_0.after_000011_n a_31572_42022# 0.01236f
C1399 3bit_to_8_outs_0.coarse_3 f3 0.04084f
C1400 3bit_to_8_outs_0.inverter_8.in 3bit_to_8_outs_0.c2_n 2.06966f
C1401 row_section_decoding_0.after_001111 f5 0.6437f
C1402 VCO2_selection_0.NAND_2in_0.y vp 0.35108f
C1403 a_31315_29201# f0 0.13409f
C1404 VCO3_selection_0.inverter_12.out m2_33006_39727# 0.17579f
C1405 VCO3_selection_0.XNOR_1.y f1 1.00719f
C1406 m2_32353_46585# row_section_decoding_0.after_000011_n 0.01378f
C1407 VCO3_selection_0.NAND_3in_2.y a_31788_36638# 0.06651f
C1408 VCO3_selection_0.inverter_12.out 100 0.07061f
C1409 row_section_decoding_0.after_001111_n vp 0.67737f
C1410 row_section_decoding_0.after_000011 c1 0.04125f
C1411 m2_33006_38677# VCO3_selection_0.inverter_0.out 0.02443f
C1412 row_section_decoding_0.after_000111_n 3bit_to_8_outs_0.c0_n 0.01503f
C1413 VCO2_selection_0.NOR_2in_2.y vp 0.29269f
C1414 VCO_selection_0.NAND_2in_1.y VCO_selection_0.NAND_2in_0.y 0.79532f
C1415 VCO2_selection_0.NAND_3in_5.c m2_32824_34835# 0.01524f
C1416 VCO5_selection_0.XNOR_0._b VCO5_selection_0.NAND_2in_0.b 0.01166f
C1417 3bit_to_8_outs_0.inverter_1.in 110 0.41505f
C1418 111 101 0.32724f
C1419 VCO5_selection_0.NAND_2in_0.b VCO5_selection_0.inverter_1.out 0.52804f
C1420 VCO3_selection_0.NAND_2in_0.y VCO3_selection_0.NAND_2in_3.y 0.57767f
C1421 111 3bit_to_8_outs_0.coarse_2 1.34229f
C1422 m2_32458_28222# VCO5_selection_0.NAND_2in_0.b 0.40008f
C1423 row_section_decoding_0.after_000111_n f1 0.74297f
C1424 a_32090_25172# 3bit_to_8_outs_0.inverter_6.in 0.07661f
C1425 VCO3_selection_0.NAND_3in_1.y VCO3_selection_0.NAND_3in_2.y 0.03956f
C1426 m2_33176_31901# VCO2_selection_0.inverter_6.out 0.17658f
C1427 VCO3_selection_0.NAND_3in_6.a vp 0.33704f
C1428 3bit_to_8_outs_0.inverter_8.in 3bit_to_8_outs_0.c0_n 0.48759f
C1429 f1 f5 33.4296f
C1430 3bit_to_8_outs_0.NAND_3in_0.y row_section_decoding_0.f1_n 0.01097f
C1431 a_31060_44464# VCO4_selection_0.inverter_2.in 0.01087f
C1432 f1 row_section_decoding_0.NAND_2in_0.a 0.38533f
C1433 VCO3_selection_0.NOR_2in_1.y VCO2_selection_0.NOR_2in_1.y 0.02016f
C1434 a_33068_41518# VCO3_selection_0.NOR_2in_4.b 0.0109f
C1435 VCO4_selection_0.inverter_1.in vp 0.26515f
C1436 a_31788_36164# row_section_decoding_0.after_000011_n 0.01126f
C1437 row_section_decoding_0.after_000111 3bit_to_8_outs_0.coarse_0 1.1584f
C1438 3bit_to_8_outs_0.inverter_8.in a_32090_26816# 0.07661f
C1439 m2_31033_25501# 101 0.17579f
C1440 VCO4_selection_0.NOR_2in_1.a VCO4_selection_0.inverter_5.out 0.52357f
C1441 VCO2_selection_0.NAND_3in_3.c a_32399_31170# 0.10234f
C1442 VCO3_selection_0.NAND_3in_6.a VCO3_selection_0.NAND_3in_6.b 0.84603f
C1443 row_section_decoding_0.after_000111 f2 0.06945f
C1444 a_32258_36638# row_section_decoding_0.after_001111 0.04021f
C1445 row_section_decoding_0.after_000011_n VCO5_selection_0.NOR_2in_0.y 0.01844f
C1446 VCO2_selection_0.NOR_2in_0.y VCO2_selection_0.NOR_2in_0.a 0.39716f
C1447 101 f3 0.03973f
C1448 a_33476_38120# VCO3_selection_0.NAND_3in_0.c 0.01914f
C1449 row_section_decoding_0.after_001111_n f4 0.18082f
C1450 VCO4_selection_0.inverter_2.out 3bit_to_8_outs_0.coarse_0 0.02421f
C1451 VCO2_selection_0.inverter_0.out VCO2_selection_0.inverter_1.out 1.13832f
C1452 row_section_decoding_0.after_000111 c0 0.07234f
C1453 f3 3bit_to_8_outs_0.coarse_2 0.0413f
C1454 row_section_decoding_0.f5_n VCO3_selection_0.NAND_2in_3.y 0.02164f
C1455 111 100 6.89981f
C1456 row_section_decoding_0.after_000111 m2_30981_44547# 0.01284f
C1457 VCO5_selection_0.inverter_0.in VCO5_selection_0.inverter_0.out 0.80357f
C1458 row_section_decoding_0.after_000111_n VCO2_selection_0.inverter_6.out 0.67967f
C1459 VCO4_selection_0.inverter_0.out m2_31673_43815# 0.17624f
C1460 m2_33034_34103# VCO2_selection_0.inverter_1.out 0.01349f
C1461 m2_33407_40705# VCO3_selection_0.NAND_3in_6.c 0.26483f
C1462 a_31623_34196# VCO2_selection_0.inverter_1.in 0.06651f
C1463 row_section_decoding_0.after_001111_n f0 0.28428f
C1464 VCO2_selection_0.XNOR_0._a a_32405_30758# 0.05886f
C1465 VCO3_selection_0.inverter_4.out m2_32661_36967# 0.21677f
C1466 VCO5_selection_0.inverter_1.in vp 0.43601f
C1467 VCO5_selection_0.inverter_0.in m2_32934_28222# 0.06028f
C1468 VCO4_selection_0.XNOR_0._b VCO_selection_0.NAND_2in_0.y 0.01156f
C1469 VCO4_selection_0.inverter_5.in m2_32494_47563# 0.22185f
C1470 VCO2_selection_0.NAND_4in_0.d VCO2_selection_0.NAND_3in_4.y 0.05771f
C1471 VCO2_selection_0.NAND_3in_5.c m2_33323_30841# 0.16655f
C1472 3bit_to_8_outs_0.NAND_3in_0.y c1 0.70372f
C1473 row_section_decoding_0.f5_n row_section_decoding_0.after_001111_n 41.629f
C1474 a_33044_32714# VCO2_selection_0.NAND_4in_0.c 0.01188f
C1475 m2_33294_34753# VCO2_11_sel 0.0866f
C1476 row_section_decoding_0.after_000111_n row_section_decoding_0.NAND_2in_0.b 0.43744f
C1477 VCO2_selection_0.NAND_4in_0.b VCO2_selection_0.NAND_4in_0.a 1.47122f
C1478 a_30774_23859# vp 0.09956f
C1479 a_31592_48788# vp 0.13599f
C1480 VCO2_selection_0.NOR_2in_2.a vp 0.39962f
C1481 VCO4_selection_0.inverter_3.in m2_32625_45771# 0.17539f
C1482 row_section_decoding_0.after_000011 3bit_to_8_outs_0.coarse_0 1.2188f
C1483 f5 row_section_decoding_0.NAND_2in_0.b 0.41688f
C1484 a_31510_22377# vp 0.09781f
C1485 m2_31493_41847# row_section_decoding_0.after_000011_n 0.40052f
C1486 VCO3_selection_0.NOR_2in_1.y VCO3_selection_0.inverter_2.out 0.60775f
C1487 VCO3_selection_0.NAND_3in_5.y a_32468_42496# 0.01085f
C1488 3bit_to_8_outs_0.inverter_6.in 3bit_to_8_outs_0.NAND_3in_3.y 0.36477f
C1489 row_section_decoding_0.after_000011 f2 0.06f
C1490 row_section_decoding_0.NAND_2in_0.b row_section_decoding_0.NAND_2in_0.a 0.74936f
C1491 m2_32458_28222# VCO5_selection_0.inverter_1.out 0.01079f
C1492 row_section_decoding_0.after_000111 3bit_to_8_outs_0.coarse_1 9.96974f
C1493 a_31407_34196# a_31623_34196# 0.02238f
C1494 f3 100 0.04013f
C1495 row_section_decoding_0.after_000011 c0 0.07388f
C1496 VCO3_selection_0.inverter_10.out a_33484_43000# 0.0109f
C1497 row_section_decoding_0.after_000111 VCO2_selection_0.NAND_4in_0.a 0.77142f
C1498 m2_32989_41929# VCO3_selection_0.NAND_3in_6.b 0.15347f
C1499 3bit_to_8_outs_0.coarse_3 row_section_decoding_0.after_000111_n 8.85092f
C1500 VCO3_selection_0.NAND_3in_3.y 3bit_to_8_outs_0.coarse_3 0.49057f
C1501 m2_33034_34103# VCO2_selection_0.inverter_0.out 0.01079f
C1502 3bit_to_8_outs_0.inverter_6.in 3bit_to_8_outs_0.c1_n 0.70099f
C1503 VCO3_selection_0.NAND_3in_6.a VCO3_selection_0.NAND_3in_0.c 0.01457f
C1504 a_32468_40540# VCO3_selection_0.NAND_3in_4.y 0.01157f
C1505 VCO5_selection_0.inverter_2.out m2_32217_29118# 0.19069f
C1506 VCO4_selection_0.inverter_3.out m2_32625_45771# 0.18487f
C1507 3bit_to_8_outs_0.coarse_3 f5 0.25615f
C1508 110 c2 0.04115f
C1509 VCO4_selection_0.inverter_2.out a_32018_44968# 0.04947f
C1510 VCO2_selection_0.NOR_2in_1.y VCO2_5_sel 0.02521f
C1511 m2_32558_34753# m2_32824_34753# 0.01413f
C1512 VCO4_selection_0.NOR_2in_1.a vp 0.32268f
C1513 VCO4_selection_0.inverter_5.in VCO4_selection_0.XNOR_1._b 0.57839f
C1514 VCO2_selection_0.NOR_2in_2.y m2_33294_34753# 0.01308f
C1515 111 m2_30711_49775# 0.02497f
C1516 VCO3_selection_0.XNOR_1.y VCO3_selection_0.NAND_3in_4.y 0.02065f
C1517 a_32110_40066# f0 0.03549f
C1518 a_31060_46420# a_31276_46420# 0.02238f
C1519 m2_32824_34835# VCO2_selection_0.inverter_2.in 0.01476f
C1520 VCO2_selection_0.NAND_3in_5.c a_32920_31262# 0.07285f
C1521 VCO3_selection_0.inverter_4.out m2_33199_36721# 0.01079f
C1522 VCO3_selection_0.NAND_3in_2.y row_section_decoding_0.after_000111 0.56942f
C1523 a_32564_39006# vp 0.13606f
C1524 VCO3_11_sel m2_33397_38027# 0.08566f
C1525 VCO5_selection_0.inverter_2.out 3bit_to_8_outs_0.coarse_1 1.02703f
C1526 VCO5_selection_0.NOR_2in_0.y a_32537_27811# 0.07285f
C1527 row_section_decoding_0.after_001111 VCO2_selection_0.NAND_2in_0.y 0.42184f
C1528 3bit_to_8_outs_0.inverter_6.in c2 2.06986f
C1529 VCO4_selection_0.inverter_3.in a_31276_45946# 0.06651f
C1530 VCO5_selection_0.XNOR_0._b VCO5_selection_0.inverter_2.in 0.57839f
C1531 VCO2_selection_0.XNOR_0._b a_31945_30758# 0.04323f
C1532 row_section_decoding_0.after_001111 row_section_decoding_0.after_001111_n 0.87945f
C1533 VCO5_selection_0.inverter_2.in VCO5_selection_0.inverter_1.out 0.01189f
C1534 m2_31673_43897# m2_31673_43815# 0.16392f
C1535 a_32018_43486# vp 0.09776f
C1536 row_section_decoding_0.after_000111_n VCO3_selection_0.NAND_3in_4.y 0.52378f
C1537 VCO3_selection_0.NAND_3in_6.c VCO3_selection_0.inverter_12.out 0.02127f
C1538 row_section_decoding_0.after_000011 3bit_to_8_outs_0.coarse_1 1.12273f
C1539 a_31510_22377# f4 0.04379f
C1540 VCO4_selection_0.inverter_3.in VCO4_selection_0.inverter_2.in 0.02944f
C1541 110 vp 1.77972f
C1542 VCO3_selection_0.inverter_1.out VCO3_selection_0.NAND_2in_1.y 0.50705f
C1543 VCO2_selection_0.NOR_2in_0.a vp 0.38113f
C1544 a_31592_48788# f0 0.13418f
C1545 VCO5_selection_0.inverter_2.out VCO5_selection_0.inverter_0.in 0.62746f
C1546 a_31626_25172# a_31410_25172# 0.02238f
C1547 a_31519_28315# VCO5_selection_0.NAND_2in_0.b 0.06651f
C1548 VCO3_5_sel vp 0.34051f
C1549 VCO3_selection_0.NAND_3in_1.y vp 0.50218f
C1550 3bit_to_8_outs_0.inverter_6.in vp 0.48465f
C1551 VCO3_selection_0.inverter_4.out VCO3_selection_0.inverter_2.out 0.02854f
C1552 row_section_decoding_0.after_000111_n 101 0.29168f
C1553 VCO4_selection_0.inverter_1.in VCO4_selection_0.NOR_2in_0.a 5.36557f
C1554 row_section_decoding_0.after_001111_n f1 0.5123f
C1555 VCO4_selection_0.inverter_0.out m2_31673_44547# 0.01424f
C1556 row_section_decoding_0.after_000111_n 3bit_to_8_outs_0.coarse_2 0.32644f
C1557 VCO2_selection_0.NOR_2in_0.b m2_33238_30191# 0.0135f
C1558 3bit_to_8_outs_0.inverter_1.in row_section_decoding_0.after_000011 0.03278f
C1559 101 f5 3.04602f
C1560 VCO4_selection_0.inverter_5.in a_32052_47400# 0.09922f
C1561 3bit_to_8_outs_0.coarse_2 f5 1.10935f
C1562 3bit_to_8_outs_0.NAND_3in_0.y c0 0.37871f
C1563 VCO2_selection_0.NAND_3in_7.y a_32087_30284# 0.01701f
C1564 VCO3_selection_0.NAND_3in_3.y m2_32865_37945# 0.16449f
C1565 VCO3_selection_0.NAND_3in_8.y vp 0.57366f
C1566 VCO4_selection_0.XNOR_0._b VCO4_selection_0.XNOR_1._b 0.0901f
C1567 m2_32451_41929# row_section_decoding_0.after_000011_n 0.01323f
C1568 c0 VCO5_selection_0.NOR_2in_0.y 0.04316f
C1569 VCO3_selection_0.NOR_2in_0.y a_33278_37142# 0.07504f
C1570 VCO3_selection_0.NAND_3in_2.y VCO3_selection_0.inverter_3.out 0.51667f
C1571 VCO3_5_sel VCO3_selection_0.NAND_3in_6.b 0.65265f
C1572 VCO3_selection_0.XNOR_1.y m2_33006_39727# 0.22185f
C1573 a_32104_39006# vp 0.13599f
C1574 vp VCO3_selection_0.inverter_5.out 0.30513f
C1575 VCO3_selection_0.NAND_3in_7.c VCO3_selection_0.XNOR_1.y 0.05676f
C1576 VCO3_selection_0.NAND_3in_9.y row_section_decoding_0.after_000111 0.6096f
C1577 m2_32353_45771# m2_32625_45771# 0.01344f
C1578 VCO5_selection_0.XNOR_0._b VCO5_selection_0.XNOR_0._a 0.4882f
C1579 a_32564_39006# f0 0.02767f
C1580 VCO3_selection_0.inverter_8.out VCO3_selection_0.NAND_3in_4.y 0.33973f
C1581 m2_32865_37945# VCO3_selection_0.inverter_0.out 0.17624f
C1582 VCO5_selection_0.inverter_0.out vp 0.38935f
C1583 110 f4 0.06316f
C1584 VCO4_selection_0.inverter_2.out m2_31673_44793# 0.17638f
C1585 3bit_to_8_outs_0.NAND_3in_2.y c0 0.54002f
C1586 111 VCO2_selection_0.XNOR_0._b 0.01823f
C1587 VCO4_selection_0.NAND_3in_1.y a_31956_45946# 0.06651f
C1588 VCO3_selection_0.NOR_2in_0.y m2_33397_38027# 0.01083f
C1589 a_31626_26498# 3bit_to_8_outs_0.inverter_10.in 0.01403f
C1590 111 f3 0.04793f
C1591 VCO3_selection_0.inverter_1.out m2_32933_36071# 0.09062f
C1592 VCO3_selection_0.inverter_3.out a_33278_37142# 0.04692f
C1593 VCO3_selection_0.NAND_3in_7.c row_section_decoding_0.after_000111_n 0.0168f
C1594 VCO3_selection_0.NAND_3in_3.y VCO3_selection_0.NAND_3in_7.c 0.71393f
C1595 VCO3_selection_0.XNOR_1.y VCO3_selection_0.XNOR_1._a 0.97395f
C1596 row_section_decoding_0.after_000111_n 100 0.44397f
C1597 row_section_decoding_0.after_001111 a_32093_34196# 0.04109f
C1598 c1 3bit_to_8_outs_0.inverter_10.in 0.70106f
C1599 VCO3_11_sel vp 0.34371f
C1600 110 f0 0.30361f
C1601 VCO3_selection_0.inverter_12.out m2_33006_39891# 0.17625f
C1602 VCO2_selection_0.NAND_3in_5.c VCO2_selection_0.NAND_3in_4.y 0.02219f
C1603 VCO2_selection_0.NAND_4in_0.b VCO2_selection_0.NAND_4in_0.c 0.3111f
C1604 f5 100 7.28469f
C1605 VCO2_selection_0.NAND_3in_3.y m2_32700_30109# 0.01152f
C1606 VCO2_selection_0.inverter_4.out VCO2_selection_0.NOR_2in_0.y 0.97586f
C1607 a_32903_35174# vp 0.09771f
C1608 110 row_section_decoding_0.f5_n 0.24377f
C1609 row_section_decoding_0.after_000011_n m2_32217_28954# 0.01576f
C1610 VCO3_selection_0.NAND_3in_7.c VCO3_selection_0.inverter_0.out 0.22732f
C1611 VCO4_selection_0.NAND_2in_0.a VCO4_selection_0.inverter_3.out 0.10746f
C1612 a_31598_47902# VCO4_selection_0.inverter_5.in 0.066f
C1613 VCO4_selection_0.inverter_3.out VCO4_selection_0.inverter_3.in 0.38404f
C1614 row_section_decoding_0.NAND_2in_0.b a_31250_23355# 0.03777f
C1615 row_section_decoding_0.after_000111 c2 0.05395f
C1616 row_section_decoding_0.after_001111_n row_section_decoding_0.NAND_2in_0.b 0.10671f
C1617 VCO_selection_0.NAND_2in_2.y vp 0.40192f
C1618 a_31410_26816# a_31626_26816# 0.02238f
C1619 m2_32989_41847# VCO3_selection_0.NAND_3in_6.b 0.26528f
C1620 VCO4_selection_0.XNOR_0.y VCO4_11_sel 0.01854f
C1621 m2_32192_28222# VCO5_selection_0.NAND_2in_0.b 0.16392f
C1622 VCO3_selection_0.NAND_3in_1.y row_section_decoding_0.f5_n 0.01124f
C1623 m2_31673_44629# row_section_decoding_0.after_001111_n 0.01378f
C1624 row_section_decoding_0.after_000111_n a_31877_32240# 0.01268f
C1625 m2_33176_32065# VCO2_selection_0.inverter_6.out 0.34315f
C1626 VCO2_selection_0.NAND_4in_0.d VCO2_selection_0.NAND_4in_0.a 0.02543f
C1627 VCO5_selection_0.XNOR_0._a VCO5_selection_0.inverter_2.in 1.01148f
C1628 3bit_to_8_outs_0.NAND_3in_2.y 3bit_to_8_outs_0.coarse_1 0.41521f
C1629 VCO3_selection_0.XNOR_1.y VCO3_selection_0.inverter_12.out 0.40627f
C1630 VCO2_selection_0.NAND_4in_0.b vp 0.49178f
C1631 m2_33407_40705# VCO3_selection_0.inverter_8.out 0.03221f
C1632 VCO3_5_sel VCO3_selection_0.NAND_3in_0.c 0.01962f
C1633 VCO3_selection_0.NAND_3in_1.y m2_32661_36071# 0.17387f
C1634 VCO4_selection_0.inverter_2.out VCO4_selection_0.NAND_3in_1.y 0.02977f
C1635 a_32563_32240# a_32779_32240# 0.02238f
C1636 m2_31673_43651# VCO4_selection_0.NAND_3in_0.y 0.22111f
C1637 m2_32989_41847# VCO3_selection_0.NAND_2in_0.y 0.01476f
C1638 3bit_to_8_outs_0.inverter_1.in 3bit_to_8_outs_0.NAND_3in_0.y 0.36477f
C1639 3bit_to_8_outs_0.coarse_3 VCO2_selection_0.NAND_2in_0.y 0.46198f
C1640 VCO4_selection_0.NOR_2in_0.a VCO4_selection_0.NOR_2in_1.a 3.13593f
C1641 VCO5_selection_0.inverter_0.in VCO5_selection_0.NOR_2in_0.y 0.17746f
C1642 VCO4_selection_0.inverter_0.out row_section_decoding_0.after_000011_n 0.015f
C1643 VCO2_selection_0.NOR_2in_1.y VCO2_11_sel 0.49381f
C1644 row_section_decoding_0.after_000011_n VCO3_selection_0.NAND_3in_7.y 0.68782f
C1645 a_32494_44968# vp 0.0976f
C1646 3bit_to_8_outs_0.coarse_3 row_section_decoding_0.after_001111_n 0.24953f
C1647 VCO3_selection_0.inverter_1.out a_33278_35660# 0.04729f
C1648 a_32104_39006# f0 0.13529f
C1649 VCO2_selection_0.NOR_2in_0.b VCO2_selection_0.NOR_2in_0.a 1.15924f
C1650 m2_31033_26159# 3bit_to_8_outs_0.NAND_3in_6.y 0.2121f
C1651 row_section_decoding_0.after_000111 vp 1.42837f
C1652 3bit_to_8_outs_0.inverter_8.in a_31626_26816# 0.01403f
C1653 row_section_decoding_0.after_000111_n VCO3_selection_0.inverter_12.out 0.01615f
C1654 m2_31493_41847# 3bit_to_8_outs_0.coarse_1 0.01129f
C1655 row_section_decoding_0.after_000011 m2_31653_23684# 0.22093f
C1656 c2 a_32306_24854# 0.0131f
C1657 a_32018_43486# VCO4_selection_0.NOR_2in_0.a 0.04403f
C1658 VCO4_selection_0.inverter_2.out vp 0.41037f
C1659 VCO2_selection_0.XNOR_0._a vp 0.33131f
C1660 row_section_decoding_0.f1_n row_section_decoding_0.after_000011_n 2.38634f
C1661 VCO3_selection_0.NOR_2in_4.b VCO3_selection_0.NAND_2in_3.y 0.40573f
C1662 a_31788_42496# VCO3_selection_0.NAND_3in_5.y 0.07649f
C1663 row_section_decoding_0.after_000011 c2 0.04078f
C1664 VCO3_selection_0.inverter_5.out VCO3_selection_0.NAND_3in_0.c 1.05613f
C1665 VCO4_selection_0.NAND_2in_0.a VCO4_selection_0.NAND_2in_0.b 0.59918f
C1666 row_section_decoding_0.after_000011 VCO2_selection_0.NAND_4in_0.c 0.35947f
C1667 VCO4_selection_0.NAND_3in_1.y row_section_decoding_0.after_000011 0.61069f
C1668 m2_33405_42579# VCO3_selection_0.NAND_3in_5.y 0.01495f
C1669 110 row_section_decoding_0.after_001111 3.14858f
C1670 VCO3_selection_0.inverter_12.out VCO3_selection_0.inverter_0.out 0.01663f
C1671 a_31276_46420# VCO4_selection_0.XNOR_0.y 0.0235f
C1672 m2_32451_41683# VCO3_selection_0.NOR_2in_4.b 0.21677f
C1673 m2_32768_34103# VCO2_selection_0.inverter_1.out 0.09062f
C1674 VCO4_selection_0.inverter_0.out m2_31673_43897# 0.09002f
C1675 3bit_to_8_outs_0.inverter_6.in 3bit_to_8_outs_0.c2_n 0.07444f
C1676 f3 a_30774_22377# 0.04464f
C1677 110 VCO2_selection_0.NAND_3in_3.c 0.09694f
C1678 VCO3_selection_0.inverter_10.out VCO4_selection_0.NOR_2in_0.b 0.01142f
C1679 VCO4_selection_0.inverter_2.out m2_31939_44629# 0.01344f
C1680 101 VCO3_selection_0.NAND_2in_3.y 0.45794f
C1681 VCO2_selection_0.NOR_2in_2.y VCO2_selection_0.NOR_2in_1.y 0.9225f
C1682 VCO5_selection_0.inverter_2.out vp 0.29272f
C1683 VCO3_selection_0.NOR_2in_0.y vp 0.4836f
C1684 m2_33137_37945# VCO3_selection_0.inverter_5.out 0.17552f
C1685 a_31956_46420# VCO4_selection_0.inverter_4.in 0.01203f
C1686 VCO3_11_sel VCO3_selection_0.NAND_3in_0.c 0.70065f
C1687 a_32828_32714# VCO2_selection_0.NAND_4in_0.c 0.0123f
C1688 3bit_to_8_outs_0.inverter_8.in VCO5_selection_0.inverter_1.out 0.0112f
C1689 VCO2_selection_0.NAND_2in_0.y VCO2_selection_0.inverter_1.in 0.59261f
C1690 VCO2_selection_0.NAND_3in_7.y vp 0.51978f
C1691 VCO3_selection_0.NAND_3in_6.c m2_33006_39891# 0.01575f
C1692 VCO4_selection_0.NAND_2in_0.a VCO4_selection_0.NOR_2in_0.b 0.31687f
C1693 row_section_decoding_0.f1_n c1 0.04115f
C1694 row_section_decoding_0.after_000011 vp 1.3574f
C1695 VCO4_selection_0.inverter_3.in m2_32353_45771# 0.16449f
C1696 m2_30711_49693# row_section_decoding_0.after_001111 0.0111f
C1697 a_30990_22377# vp 0.07672f
C1698 m2_30761_25501# 100 0.17554f
C1699 c0 3bit_to_8_outs_0.inverter_10.in 0.41738f
C1700 VCO2_selection_0.NOR_2in_2.b VCO2_selection_0.NAND_2in_0.y 0.01674f
C1701 VCO3_selection_0.NAND_3in_5.y a_32252_42496# 0.01223f
C1702 m2_31328_34835# row_section_decoding_0.after_000011_n 0.40071f
C1703 110 f1 0.42446f
C1704 101 row_section_decoding_0.after_001111_n 1.04843f
C1705 row_section_decoding_0.after_000111 f4 0.06331f
C1706 VCO2_selection_0.inverter_3.in VCO3_selection_0.NAND_3in_1.y 0.01293f
C1707 a_31572_36164# row_section_decoding_0.after_000111_n 0.0131f
C1708 a_31060_46420# row_section_decoding_0.after_000011_n 0.0131f
C1709 3bit_to_8_outs_0.inverter_6.in 3bit_to_8_outs_0.c0_n 0.41745f
C1710 3bit_to_8_outs_0.coarse_2 row_section_decoding_0.after_001111_n 0.26745f
C1711 m2_32192_28222# m2_32458_28222# 0.01413f
C1712 a_31510_22377# row_section_decoding_0.NAND_2in_0.b 0.07281f
C1713 VCO3_selection_0.inverter_3.out vp 0.40124f
C1714 VCO3_selection_0.inverter_8.out VCO3_selection_0.inverter_12.out 0.45489f
C1715 111 row_section_decoding_0.after_000111_n 0.37492f
C1716 m2_33006_38677# VCO3_selection_0.inverter_5.out 0.43604f
C1717 VCO2_selection_0.NOR_2in_2.y VCO2_selection_0.NOR_2in_2.b 0.34603f
C1718 VCO2_selection_0.inverter_2.in row_section_decoding_0.after_000011_n 0.72209f
C1719 VCO2_selection_0.NAND_4in_0.b row_section_decoding_0.f5_n 0.53306f
C1720 c1 row_section_decoding_0.after_000011_n 0.04611f
C1721 VCO3_selection_0.NOR_2in_0.y m2_33199_36803# 0.26528f
C1722 VCO2_selection_0.inverter_4.out vp 0.24157f
C1723 111 f5 0.35182f
C1724 VCO2_selection_0.inverter_1.out VCO2_selection_0.NAND_4in_0.a 0.01897f
C1725 a_32252_40540# VCO3_selection_0.NAND_3in_4.y 0.01516f
C1726 VCO3_selection_0.XNOR_1.y VCO3_selection_0.NAND_3in_6.c 0.06871f
C1727 row_section_decoding_0.after_000111 f0 0.3296f
C1728 110 m2_31033_24515# 0.17579f
C1729 VCO3_selection_0.NAND_3in_9.y VCO4_5_sel 0.03866f
C1730 VCO4_selection_0.inverter_5.in VCO4_selection_0.XNOR_0.y 0.05777f
C1731 m2_32768_34103# m2_33034_34103# 0.01413f
C1732 VCO4_selection_0.inverter_3.in row_section_decoding_0.after_000111_n 1.54217f
C1733 m2_32723_41929# VCO3_selection_0.NAND_2in_0.y 0.17387f
C1734 a_31598_47902# VCO4_selection_0.XNOR_1._b 0.04323f
C1735 3bit_to_8_outs_0.c2_n a_32306_26498# 0.01315f
C1736 VCO2_selection_0.NOR_2in_2.y m2_32824_34753# 0.15347f
C1737 a_32104_39564# vp 0.13599f
C1738 VCO2_selection_0.XNOR_0._a f0 1.58861f
C1739 row_section_decoding_0.after_000111 row_section_decoding_0.f5_n 2.6224f
C1740 m2_33407_40623# VCO3_selection_0.inverter_7.out 0.01092f
C1741 VCO4_selection_0.inverter_4.in m2_30981_46503# 0.1183f
C1742 VCO2_selection_0.NAND_3in_7.y m2_32972_29945# 0.17547f
C1743 m2_30981_44547# m2_31673_44547# 0.01378f
C1744 VCO3_selection_0.inverter_1.out vp 0.40491f
C1745 VCO4_selection_0.NOR_2in_1.a VCO4_selection_0.inverter_4.in 0.3823f
C1746 m2_31328_34835# VCO2_selection_0.inverter_2.in 0.27335f
C1747 VCO5_selection_0.NOR_2in_0.y a_33013_28315# 0.01073f
C1748 a_31775_29201# 3bit_to_8_outs_0.coarse_1 0.01367f
C1749 3bit_to_8_outs_0.NAND_3in_0.y c2 2.07099f
C1750 VCO3_selection_0.inverter_3.out m2_33199_36803# 0.10665f
C1751 f1 VCO3_selection_0.inverter_5.out 0.0104f
C1752 m2_33137_42661# VCO3_selection_0.NAND_3in_5.y 0.17539f
C1753 3bit_to_8_outs_0.c1_n 3bit_to_8_outs_0.NAND_3in_2.y 0.59595f
C1754 row_section_decoding_0.f1_n m2_31925_23438# 0.09002f
C1755 a_32252_42496# a_32468_42496# 0.02238f
C1756 row_section_decoding_0.after_000011 f4 0.11166f
C1757 a_32258_36164# row_section_decoding_0.after_000011_n 0.04035f
C1758 row_section_decoding_0.after_001111_n 100 0.23496f
C1759 row_section_decoding_0.after_000111_n f3 0.338f
C1760 a_30990_22377# f4 0.01136f
C1761 a_31407_32714# a_31623_32714# 0.02238f
C1762 VCO4_selection_0.NAND_3in_1.y VCO4_11_sel 0.44085f
C1763 m2_33405_42579# m2_33405_42661# 0.39957f
C1764 row_section_decoding_0.after_001111 VCO_selection_0.NAND_2in_2.y 0.06963f
C1765 VCO2_selection_0.inverter_3.in m2_32286_34753# 0.0104f
C1766 f3 f5 0.17412f
C1767 a_31572_42022# VCO3_selection_0.NAND_2in_0.y 0.06997f
C1768 VCO2_selection_0.NOR_2in_2.a VCO2_selection_0.NOR_2in_1.y 0.02033f
C1769 f3 row_section_decoding_0.NAND_2in_0.a 0.55747f
C1770 m2_32989_41929# VCO3_selection_0.NOR_2in_4.b 0.01079f
C1771 a_31060_44464# row_section_decoding_0.after_001111_n 0.0131f
C1772 m2_32661_36721# m2_32933_36721# 0.01344f
C1773 VCO2_selection_0.inverter_0.out VCO2_selection_0.NAND_4in_0.a 0.02581f
C1774 VCO3_selection_0.NAND_3in_5.y VCO3_selection_0.inverter_11.out 0.46336f
C1775 a_33345_40066# a_33561_40066# 0.02238f
C1776 row_section_decoding_0.after_000011 f0 0.31608f
C1777 VCO2_selection_0.NAND_4in_0.d VCO2_selection_0.NAND_4in_0.c 2.09198f
C1778 a_31303_28315# VCO5_selection_0.NAND_2in_0.b 0.01047f
C1779 VCO3_selection_0.NOR_2in_0.y VCO3_selection_0.NAND_3in_0.c 0.03355f
C1780 VCO5_11_sel gd 2.44418f
C1781 VCO2_5_sel gd 2.69446f
C1782 VCO2_11_sel gd 2.96921f
C1783 VCO3_11_sel gd 1.88444f
C1784 VCO3_5_sel gd 2.59996f
C1785 VCO4_5_sel gd 2.2436f
C1786 VCO4_11_sel gd 2.51681f
C1787 VCO_sel gd 1.01007f
C1788 vp gd 80.33954f
C1789 m2_31925_23438# gd 0.01284f ; **FLOATING
C1790 m2_30761_24515# gd 0.01174f ; **FLOATING
C1791 m2_30761_25501# gd 0.01174f ; **FLOATING
C1792 m2_30761_26159# gd 0.0114f ; **FLOATING
C1793 m2_32934_28222# gd 0.03356f ; **FLOATING
C1794 m2_32458_28222# gd 0.01858f ; **FLOATING
C1795 m2_32477_28872# gd 0.06224f ; **FLOATING
C1796 m2_32217_28872# gd 0.01127f ; **FLOATING
C1797 m2_33238_30191# gd 0.04484f ; **FLOATING
C1798 m2_31328_30191# gd 0.06393f ; **FLOATING
C1799 m2_33323_30841# gd 0.01855f ; **FLOATING
C1800 m2_32841_30841# gd 0.03536f ; **FLOATING
C1801 m2_32841_30923# gd 0.01441f ; **FLOATING
C1802 m2_33176_31901# gd 0.01156f ; **FLOATING
C1803 m2_33176_32065# gd 0.01253f ; **FLOATING
C1804 m2_33034_34021# gd 0.02036f ; **FLOATING
C1805 m2_33034_34103# gd 0.04248f ; **FLOATING
C1806 m2_32768_34103# gd 0.01436f ; **FLOATING
C1807 m2_32496_34103# gd 0.01414f ; **FLOATING
C1808 m2_33294_34753# gd 0.0959f ; **FLOATING
C1809 m2_32824_34753# gd 0.0353f ; **FLOATING
C1810 m2_32558_34753# gd 0.01308f ; **FLOATING
C1811 m2_32286_34753# gd 0.01315f ; **FLOATING
C1812 m2_32824_34835# gd 0.01395f ; **FLOATING
C1813 m2_31328_34835# gd 0.01958f ; **FLOATING
C1814 m2_33199_36071# gd 0.04229f ; **FLOATING
C1815 m2_32933_36071# gd 0.01353f ; **FLOATING
C1816 m2_32661_36071# gd 0.01358f ; **FLOATING
C1817 m2_33199_36721# gd 0.04231f ; **FLOATING
C1818 m2_32933_36721# gd 0.01351f ; **FLOATING
C1819 m2_32661_36721# gd 0.0136f ; **FLOATING
C1820 m2_33199_36803# gd 0.02018f ; **FLOATING
C1821 m2_33397_38027# gd 0.08517f ; **FLOATING
C1822 m2_33006_38677# gd 0.04171f ; **FLOATING
C1823 m2_33006_39973# gd 0.01243f ; **FLOATING
C1824 m2_33407_40623# gd 0.04241f ; **FLOATING
C1825 m2_31493_40623# gd 0.02907f ; **FLOATING
C1826 m2_33407_40705# gd 0.02045f ; **FLOATING
C1827 m2_32989_41847# gd 0.02009f ; **FLOATING
C1828 m2_31493_41847# gd 0.01988f ; **FLOATING
C1829 m2_32989_41929# gd 0.04161f ; **FLOATING
C1830 m2_32723_41929# gd 0.01312f ; **FLOATING
C1831 m2_32451_41929# gd 0.01332f ; **FLOATING
C1832 m2_33405_42579# gd 0.04942f ; **FLOATING
C1833 m2_33405_42661# gd 0.02128f ; **FLOATING
C1834 m2_31673_43897# gd 0.01347f ; **FLOATING
C1835 m2_30981_43897# gd 0.0699f ; **FLOATING
C1836 m2_31673_44547# gd 0.01351f ; **FLOATING
C1837 m2_30981_44547# gd 0.0699f ; **FLOATING
C1838 m2_31939_44629# gd 0.01411f ; **FLOATING
C1839 m2_30981_45853# gd 0.06696f ; **FLOATING
C1840 m2_30981_46503# gd 0.04791f ; **FLOATING
C1841 m2_32494_47563# gd 0.01137f ; **FLOATING
C1842 m2_32494_47727# gd 0.01253f ; **FLOATING
C1843 m2_32494_47809# gd 0.01984f ; **FLOATING
C1844 m2_30711_49693# gd 0.02021f ; **FLOATING
C1845 m2_31181_49775# gd 0.0661f ; **FLOATING
C1846 m2_30711_49775# gd 0.03908f ; **FLOATING
C1847 a_31510_22377# gd 0.6326f
C1848 a_30990_22377# gd 0.01517f
C1849 a_31250_23355# gd 0.10492f
C1850 a_30774_23859# gd 1.64044f
C1851 a_32306_24854# gd 0.10513f
C1852 a_32090_24854# gd 0.08448f
C1853 a_31626_24854# gd 0.10512f
C1854 a_31410_24854# gd 0.08446f
C1855 a_32306_25172# gd 0.10513f
C1856 a_32090_25172# gd 0.9493f
C1857 a_31626_25172# gd 0.74037f
C1858 a_31410_25172# gd 0.71972f
C1859 a_32306_26498# gd 0.99003f
C1860 a_32090_26498# gd 0.96939f
C1861 a_31626_26498# gd 0.10512f
C1862 a_31410_26498# gd 0.08446f
C1863 a_32306_26816# gd 0.10513f
C1864 a_32090_26816# gd 0.08448f
C1865 a_31626_26816# gd 0.10512f
C1866 a_31410_26816# gd 0.08446f
C1867 a_33013_28315# gd 0.57141f
C1868 a_31519_28315# gd 0.08447f
C1869 a_31303_28315# gd 0.10512f
C1870 a_30783_28315# gd 0.10693f
C1871 a_32772_28789# gd 0.49068f
C1872 a_32556_28789# gd 0.51139f
C1873 a_31781_28789# gd 0.09853f
C1874 a_31321_28789# gd 0.09914f
C1875 VCO5_selection_0.inverter_2.out gd 0.17074f
C1876 a_31775_29201# gd 0.57678f
C1877 a_33317_29780# gd 1.64668f
C1878 VCO2_selection_0.NOR_2in_0.a gd 0.05806f
C1879 a_32303_30284# gd 0.20059f
C1880 a_32087_30284# gd 3.75898f
C1881 a_31623_30284# gd 0.08448f
C1882 a_31407_30284# gd 0.10513f
C1883 a_32405_30758# gd 0.09853f
C1884 a_31945_30758# gd 0.44215f
C1885 VCO2_selection_0.NOR_2in_0.y gd 0.12258f
C1886 a_32399_31170# gd 0.23761f
C1887 a_31939_31170# gd 6.5281f
C1888 a_32779_32240# gd 0.08448f
C1889 a_32563_32240# gd 0.10512f
C1890 a_32093_32240# gd 0.0822f
C1891 a_31877_32240# gd 0.10267f
C1892 a_31407_32240# gd 0.10696f
C1893 a_33260_32714# gd 1.54967f
C1894 a_33044_32714# gd 1.28409f
C1895 a_32828_32714# gd 0.10253f
C1896 a_32368_32714# gd 0.08109f
C1897 a_32152_32714# gd 0.10513f
C1898 a_31623_32714# gd 0.08445f
C1899 a_31407_32714# gd 0.10512f
C1900 a_33113_33692# gd 0.1203f
C1901 a_32093_34196# gd 0.10466f
C1902 VCO2_selection_0.inverter_1.in gd 0.40725f
C1903 a_31623_34196# gd 0.49173f
C1904 a_31407_34196# gd 6.56059f
C1905 a_33589_34670# gd 0.34074f
C1906 a_33373_34670# gd 0.10508f
C1907 a_31883_34670# gd 2.319f
C1908 a_31407_34670# gd 0.10695f
C1909 VCO2_selection_0.NAND_3in_5.c gd 1.30249f
C1910 a_32903_35174# gd 0.50657f
C1911 VCO2_selection_0.NOR_2in_2.a gd 0.27836f
C1912 VCO2_selection_0.NOR_2in_2.b gd 1.33939f
C1913 VCO3_selection_0.inverter_2.out gd 1.498f
C1914 a_32258_36164# gd 0.10467f
C1915 a_31788_36164# gd 0.08448f
C1916 a_31572_36164# gd 0.10513f
C1917 a_32258_36638# gd 3.48955f
C1918 a_31788_36638# gd 0.08448f
C1919 a_31572_36638# gd 0.10513f
C1920 a_33278_37142# gd 0.57517f
C1921 VCO3_selection_0.inverter_4.in gd 0.19178f
C1922 VCO3_selection_0.NOR_2in_0.y gd 0.96437f
C1923 a_33692_38120# gd 0.22568f
C1924 VCO3_selection_0.NOR_2in_1.y gd 0.3616f
C1925 a_33476_38120# gd 0.49082f
C1926 VCO3_selection_0.NAND_3in_7.y gd 0.19053f
C1927 a_32468_38120# gd 0.08448f
C1928 a_32252_38120# gd 0.10512f
C1929 VCO3_selection_0.NAND_3in_3.y gd 0.18495f
C1930 a_31788_38120# gd 0.08448f
C1931 a_31572_38120# gd 0.10513f
C1932 a_32570_38594# gd 1.86978f
C1933 a_32110_38594# gd 0.43678f
C1934 a_33085_39098# gd 0.8488f
C1935 VCO3_selection_0.NAND_3in_7.c gd 1.77125f
C1936 a_33561_40066# gd 1.17056f
C1937 a_33345_40066# gd 0.10272f
C1938 a_32570_40066# gd 0.32275f
C1939 a_32110_40066# gd 0.43575f
C1940 a_32468_40540# gd 0.08448f
C1941 a_32252_40540# gd 0.10512f
C1942 a_31788_40540# gd 0.08448f
C1943 a_31572_40540# gd 0.32395f
C1944 a_33486_41044# gd 0.55342f
C1945 VCO3_selection_0.inverter_7.out gd 0.33046f
C1946 VCO3_selection_0.inverter_8.out gd 0.515f
C1947 a_33068_41518# gd 0.55043f
C1948 VCO3_selection_0.NOR_2in_4.a gd 0.26893f
C1949 VCO3_selection_0.NOR_2in_4.b gd 0.22203f
C1950 a_32048_42022# gd 0.10467f
C1951 a_31572_42022# gd 0.10695f
C1952 a_32468_42496# gd 4.1001f
C1953 a_32252_42496# gd 4.12074f
C1954 a_31788_42496# gd 0.08448f
C1955 a_31572_42496# gd 0.10513f
C1956 a_33484_43000# gd 1.30104f
C1957 a_32018_43486# gd 1.37736f
C1958 a_32494_43990# gd 0.10695f
C1959 VCO4_selection_0.NAND_2in_0.b gd 0.60823f
C1960 VCO4_selection_0.NAND_3in_0.y gd 0.11637f
C1961 a_31276_43990# gd 0.08448f
C1962 a_31060_43990# gd 0.10512f
C1963 a_31276_44464# gd 0.08448f
C1964 a_31060_44464# gd 0.10512f
C1965 a_32494_44968# gd 1.13286f
C1966 a_32018_44968# gd 1.55489f
C1967 a_31956_45946# gd 0.08448f
C1968 a_31740_45946# gd 0.10512f
C1969 a_31276_45946# gd 0.08448f
C1970 a_31060_45946# gd 0.10513f
C1971 a_31956_46420# gd 0.08448f
C1972 a_31740_46420# gd 0.10512f
C1973 a_31276_46420# gd 0.41597f
C1974 a_31060_46420# gd 5.89078f
C1975 VCO4_selection_0.inverter_4.in gd 1.46622f
C1976 a_32052_47400# gd 0.34639f
C1977 a_32058_47902# gd 0.32338f
C1978 VCO4_selection_0.inverter_5.in gd 0.34238f
C1979 a_31598_47902# gd 0.09914f
C1980 a_32058_48376# gd 0.33261f
C1981 a_31598_48376# gd 0.09914f
C1982 a_32052_48788# gd 0.37371f
C1983 a_31476_49868# gd 1.8216f
C1984 a_31260_49868# gd 1.50344f
C1985 a_30790_49868# gd 0.10696f
C1986 a_31266_50186# gd 0.3017f
C1987 a_30790_50186# gd 0.10695f
C1988 101 gd 1.5672f
.ends
