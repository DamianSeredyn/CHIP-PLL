* PEX produced on Sun Oct  4 04:32:21 PM CEST 2026 using /foss/tools/sak/sak-pex.sh with m=2 and s=1
* NGSPICE file created from VCO_decoder_cells.ext - technology: ihp-sg13g2

.subckt VCO_decoder_cells VCO3_5_sel VCO3_11_sel VCO2_11_sel VCO2_5_sel VCO5_11_sel
+ VCO_sel VCO4_11_sel VCO4_5_sel vp gd c0 c1 c2 f0 f1 f2 f3 f4 f5
X0 gd VCO4_selection_0.NAND_2in_0.y VCO4_11_sel gd sg13_lv_nmos ad=0.1005p pd=1.34u as=0.1005p ps=1.34u w=0.15u l=0.13u
X1 VCO2_11_sel VCO2_selection_0.NAND_4in_1.d vp vp sg13_lv_pmos ad=0.1005p pd=1.34u as=0.1005p ps=1.34u w=0.15u l=0.13u
X2 VCO3_selection_0.NAND_3in_0.y 001 vp vp sg13_lv_pmos ad=0.1005p pd=1.34u as=0.1005p ps=1.34u w=0.15u l=0.13u
X3 vp VCO2_selection_0.NAND_4in_0.a VCO2_5_sel vp sg13_lv_pmos ad=0.1005p pd=1.34u as=0.1005p ps=1.34u w=0.15u l=0.13u
X4 a_61898_28107# 3bit_to_8_outs_0.c1_n a_61682_28107# gd sg13_lv_nmos ad=0.1005p pd=1.34u as=0.1005p ps=1.34u w=0.15u l=0.13u
X5 110 3bit_to_8_outs_0.inverter_1.in gd gd sg13_lv_nmos ad=0.1005p pd=1.34u as=0.1005p ps=1.34u w=0.15u l=0.13u
X6 3bit_to_8_outs_0.inverter_1.in 3bit_to_8_outs_0.c0_n vp vp sg13_lv_pmos ad=0.1005p pd=1.34u as=0.1005p ps=1.34u w=0.15u l=0.13u
X7 row_section_decoding_0.NAND_3in_0.a f3 gd gd sg13_lv_nmos ad=0.1005p pd=1.34u as=0.1005p ps=1.34u w=0.15u l=0.13u
X8 a_67464_30609# after_001111_n a_67248_30609# gd sg13_lv_nmos ad=0.1005p pd=1.34u as=0.1005p ps=1.34u w=0.15u l=0.13u
X9 gd f1 row_section_decoding_0.NAND_3in_0.c gd sg13_lv_nmos ad=0.1005p pd=1.34u as=0.1005p ps=1.34u w=0.15u l=0.13u
X10 000000_n row_section_decoding_0.NAND_3in_0.b vp vp sg13_lv_pmos ad=0.1005p pd=1.34u as=0.1005p ps=1.34u w=0.15u l=0.13u
X11 VCO3_selection_0.NAND_3in_1.y 011 vp vp sg13_lv_pmos ad=0.1005p pd=1.34u as=0.1005p ps=1.34u w=0.15u l=0.13u
X12 111 3bit_to_8_outs_0.NAND_3in_0.y vp vp sg13_lv_pmos ad=0.1005p pd=1.34u as=0.1005p ps=1.34u w=0.15u l=0.13u
X13 gd f2 row_section_decoding_0.NAND_2in_0.a gd sg13_lv_nmos ad=0.1005p pd=1.34u as=0.1005p ps=1.34u w=0.15u l=0.13u
X14 after_000011 row_section_decoding_0.NAND_2in_0.a vp vp sg13_lv_pmos ad=0.1005p pd=1.34u as=0.1005p ps=1.34u w=0.15u l=0.13u
X15 VCO2_5_sel VCO2_selection_0.NAND_4in_0.d vp vp sg13_lv_pmos ad=0.1005p pd=1.34u as=0.1005p ps=1.34u w=0.15u l=0.13u
X16 a_60889_29603# VCO4_selection_0.NAND_3in_1.y VCO4_5_sel gd sg13_lv_nmos ad=0.1005p pd=1.34u as=0.1005p ps=1.34u w=0.15u l=0.13u
X17 VCO3_selection_0.NAND_3in_6.y 100 vp vp sg13_lv_pmos ad=0.1005p pd=1.34u as=0.1005p ps=1.34u w=0.15u l=0.13u
X18 a_67928_28653# after_000111_n gd gd sg13_lv_nmos ad=0.1005p pd=1.34u as=0.1005p ps=1.34u w=0.15u l=0.13u
X19 a_68781_25143# VCO3_selection_0.NAND_2in_3.y a_68565_25143# gd sg13_lv_nmos ad=0.1005p pd=1.34u as=0.1005p ps=1.34u w=0.15u l=0.13u
X20 vp VCO2_selection_0.inverter_0.out VCO2_11_sel vp sg13_lv_pmos ad=0.1005p pd=1.34u as=0.1005p ps=1.34u w=0.15u l=0.13u
X21 a_61717_24561# f0 row_section_decoding_0.NAND_3in_0.c vp sg13_lv_pmos ad=0.1005p pd=1.34u as=0.1005p ps=1.34u w=0.15u l=0.13u
X22 3bit_to_8_outs_0.inverter_6.in 3bit_to_8_outs_0.c0_n vp vp sg13_lv_pmos ad=0.1005p pd=1.34u as=0.1005p ps=1.34u w=0.15u l=0.13u
X23 3bit_to_8_outs_0.NAND_3in_0.y c2 vp vp sg13_lv_pmos ad=0.1005p pd=1.34u as=0.1005p ps=1.34u w=0.15u l=0.13u
X24 VCO3_selection_0.NAND_2in_4.y 000000 vp vp sg13_lv_pmos ad=0.1005p pd=1.34u as=0.1005p ps=1.34u w=0.15u l=0.13u
X25 gd 000000 a_61785_29603# gd sg13_lv_nmos ad=0.1005p pd=1.34u as=0.1005p ps=1.34u w=0.15u l=0.13u
X26 3bit_to_8_outs_0.NAND_3in_6.y 3bit_to_8_outs_0.c0_n a_61898_27789# gd sg13_lv_nmos ad=0.1005p pd=1.34u as=0.1005p ps=1.34u w=0.15u l=0.13u
X27 VCO2_selection_0.NAND_3in_0.y f5_n vp vp sg13_lv_pmos ad=0.1005p pd=1.34u as=0.1005p ps=1.34u w=0.15u l=0.13u
X28 vp 000 VCO5_selection_0.NAND_2in_0.a vp sg13_lv_pmos ad=0.1005p pd=1.34u as=0.1005p ps=1.34u w=0.15u l=0.13u
X29 gd VCO4_selection_0.NAND_4in_0.d a_61321_29603# gd sg13_lv_nmos ad=0.1005p pd=1.34u as=0.1005p ps=1.34u w=0.15u l=0.13u
X30 3bit_to_8_outs_0.NAND_3in_6.y 3bit_to_8_outs_0.c2_n vp vp sg13_lv_pmos ad=0.1005p pd=1.34u as=0.1005p ps=1.34u w=0.15u l=0.13u
X31 3bit_to_8_outs_0.c2_n c2 gd gd sg13_lv_nmos ad=0.1005p pd=1.34u as=0.1005p ps=1.34u w=0.15u l=0.13u
X32 gd VCO_selection_0.NAND_2in_2.y a_62048_31586# gd sg13_lv_nmos ad=0.1005p pd=1.34u as=0.1005p ps=1.34u w=0.15u l=0.13u
X33 vp VCO5_selection_0.NAND_2in_0.a VCO5_11_sel vp sg13_lv_pmos ad=0.1005p pd=1.34u as=0.1005p ps=1.34u w=0.15u l=0.13u
X34 011 3bit_to_8_outs_0.inverter_10.in gd gd sg13_lv_nmos ad=0.1005p pd=1.34u as=0.1005p ps=1.34u w=0.15u l=0.13u
X35 vp after_000111_n VCO2_selection_0.NAND_4in_1.c vp sg13_lv_pmos ad=0.1005p pd=1.34u as=0.1005p ps=1.34u w=0.15u l=0.13u
X36 a_61218_26463# 3bit_to_8_outs_0.c1_n a_61002_26463# gd sg13_lv_nmos ad=0.1005p pd=1.34u as=0.1005p ps=1.34u w=0.15u l=0.13u
X37 VCO3_selection_0.NAND_3in_0.y 001 a_67631_21705# gd sg13_lv_nmos ad=0.1005p pd=1.34u as=0.1005p ps=1.34u w=0.15u l=0.13u
X38 VCO3_selection_0.NAND_3in_2.y 010 a_67631_23187# gd sg13_lv_nmos ad=0.1005p pd=1.34u as=0.1005p ps=1.34u w=0.15u l=0.13u
X39 gd after_000011 a_61740_30077# gd sg13_lv_nmos ad=0.1005p pd=1.34u as=0.1005p ps=1.34u w=0.15u l=0.13u
X40 a_67631_25617# after_000111 a_67415_25617# gd sg13_lv_nmos ad=0.1005p pd=1.34u as=0.1005p ps=1.34u w=0.15u l=0.13u
X41 vp VCO3_selection_0.NAND_4in_1.a VCO3_5_sel vp sg13_lv_pmos ad=0.1005p pd=1.34u as=0.1005p ps=1.34u w=0.15u l=0.13u
X42 vp VCO_selection_0.NAND_2in_1.y VCO_sel vp sg13_lv_pmos ad=0.1005p pd=1.34u as=0.1005p ps=1.34u w=0.15u l=0.13u
X43 VCO2_selection_0.NAND_4in_0.d after_000111_n vp vp sg13_lv_pmos ad=0.1005p pd=1.34u as=0.1005p ps=1.34u w=0.15u l=0.13u
X44 vp VCO4_selection_0.NAND_2in_0.y VCO4_11_sel vp sg13_lv_pmos ad=0.1005p pd=1.34u as=0.1005p ps=1.34u w=0.15u l=0.13u
X45 vp 010 VCO2_selection_0.NAND_3in_1.a vp sg13_lv_pmos ad=0.1005p pd=1.34u as=0.1005p ps=1.34u w=0.15u l=0.13u
X46 VCO3_selection_0.NAND_2in_5.y f5 vp vp sg13_lv_pmos ad=0.1005p pd=1.34u as=0.1005p ps=1.34u w=0.15u l=0.13u
X47 a_61717_23583# row_section_decoding_0.NAND_2in_0.a after_000011 gd sg13_lv_nmos ad=0.1005p pd=1.34u as=0.1005p ps=1.34u w=0.15u l=0.13u
X48 VCO2_selection_0.NAND_3in_2.y 101 vp vp sg13_lv_pmos ad=0.1005p pd=1.34u as=0.1005p ps=1.34u w=0.15u l=0.13u
X49 vp after_000111_n VCO3_selection_0.NAND_3in_1.y vp sg13_lv_pmos ad=0.1005p pd=1.34u as=0.1005p ps=1.34u w=0.15u l=0.13u
X50 vp 3bit_to_8_outs_0.c1_n 3bit_to_8_outs_0.NAND_3in_2.y vp sg13_lv_pmos ad=0.1005p pd=1.34u as=0.1005p ps=1.34u w=0.15u l=0.13u
X51 VCO3_selection_0.NAND_3in_6.y 100 a_67631_23661# gd sg13_lv_nmos ad=0.1005p pd=1.34u as=0.1005p ps=1.34u w=0.15u l=0.13u
X52 vp row_section_decoding_0.NAND_2in_0.b after_000011 vp sg13_lv_pmos ad=0.1005p pd=1.34u as=0.1005p ps=1.34u w=0.15u l=0.13u
X53 a_68899_30609# VCO2_selection_0.NAND_4in_0.b a_68683_30609# gd sg13_lv_nmos ad=0.1005p pd=1.34u as=0.1005p ps=1.34u w=0.15u l=0.13u
X54 3bit_to_8_outs_0.c0_n c0 gd gd sg13_lv_nmos ad=0.1005p pd=1.34u as=0.1005p ps=1.34u w=0.15u l=0.13u
X55 a_61002_27789# 3bit_to_8_outs_0.c2_n gd gd sg13_lv_nmos ad=0.1005p pd=1.34u as=0.1005p ps=1.34u w=0.15u l=0.13u
X56 a_67947_30135# f5_n gd gd sg13_lv_nmos ad=0.1005p pd=1.34u as=0.1005p ps=1.34u w=0.15u l=0.13u
X57 a_67248_28179# 000000_n gd gd sg13_lv_nmos ad=0.1005p pd=1.34u as=0.1005p ps=1.34u w=0.15u l=0.13u
X58 a_61218_28107# 3bit_to_8_outs_0.c1_n a_61002_28107# gd sg13_lv_nmos ad=0.1005p pd=1.34u as=0.1005p ps=1.34u w=0.15u l=0.13u
X59 a_61898_26145# c1 a_61682_26145# gd sg13_lv_nmos ad=0.1005p pd=1.34u as=0.1005p ps=1.34u w=0.15u l=0.13u
X60 VCO3_selection_0.NAND_3in_4.y VCO3_selection_0.NAND_2in_5.y vp vp sg13_lv_pmos ad=0.1005p pd=1.34u as=0.1005p ps=1.34u w=0.15u l=0.13u
X61 110 3bit_to_8_outs_0.inverter_1.in vp vp sg13_lv_pmos ad=0.1005p pd=1.34u as=0.1005p ps=1.34u w=0.15u l=0.13u
X62 a_61241_24561# f3 row_section_decoding_0.NAND_3in_0.a vp sg13_lv_pmos ad=0.1005p pd=1.34u as=0.1005p ps=1.34u w=0.15u l=0.13u
X63 VCO2_selection_0.NAND_3in_1.a 010 a_67248_26697# gd sg13_lv_nmos ad=0.1005p pd=1.34u as=0.1005p ps=1.34u w=0.15u l=0.13u
X64 vp VCO3_selection_0.NAND_3in_1.y VCO3_11_sel vp sg13_lv_pmos ad=0.1005p pd=1.34u as=0.1005p ps=1.34u w=0.15u l=0.13u
X65 vp f1 a_61717_24561# vp sg13_lv_pmos ad=0.1005p pd=1.34u as=0.1005p ps=1.34u w=0.15u l=0.13u
X66 VCO4_5_sel VCO4_selection_0.NAND_3in_1.y vp vp sg13_lv_pmos ad=0.1005p pd=1.34u as=0.1005p ps=1.34u w=0.15u l=0.13u
X67 vp after_001111_n VCO2_selection_0.NAND_4in_0.a vp sg13_lv_pmos ad=0.1005p pd=1.34u as=0.1005p ps=1.34u w=0.15u l=0.13u
X68 a_67248_28653# f5_n gd gd sg13_lv_nmos ad=0.1005p pd=1.34u as=0.1005p ps=1.34u w=0.15u l=0.13u
X69 a_68798_25617# VCO3_selection_0.NAND_3in_5.y a_68582_25617# gd sg13_lv_nmos ad=0.1005p pd=1.34u as=0.1005p ps=1.34u w=0.15u l=0.13u
X70 a_68101_25143# 000000 gd gd sg13_lv_nmos ad=0.1005p pd=1.34u as=0.1005p ps=1.34u w=0.15u l=0.13u
X71 a_67934_28179# after_000011_n gd gd sg13_lv_nmos ad=0.1005p pd=1.34u as=0.1005p ps=1.34u w=0.15u l=0.13u
X72 3bit_to_8_outs_0.inverter_6.in 3bit_to_8_outs_0.c0_n a_61218_26463# gd sg13_lv_nmos ad=0.1005p pd=1.34u as=0.1005p ps=1.34u w=0.15u l=0.13u
X73 after_000111_n f5 gd gd sg13_lv_nmos ad=0.1005p pd=1.34u as=0.1005p ps=1.34u w=0.15u l=0.13u
X74 VCO5_selection_0.NAND_2in_0.a 000 a_67248_32151# gd sg13_lv_nmos ad=0.1005p pd=1.34u as=0.1005p ps=1.34u w=0.15u l=0.13u
X75 a_67248_30609# after_000111 gd gd sg13_lv_nmos ad=0.1005p pd=1.34u as=0.1005p ps=1.34u w=0.15u l=0.13u
X76 a_61321_29603# VCO4_selection_0.NAND_3in_0.y a_61105_29603# gd sg13_lv_nmos ad=0.1005p pd=1.34u as=0.1005p ps=1.34u w=0.15u l=0.13u
X77 VCO5_11_sel VCO5_selection_0.NAND_2in_0.a a_68200_32151# gd sg13_lv_nmos ad=0.1005p pd=1.34u as=0.1005p ps=1.34u w=0.15u l=0.13u
X78 vp 000000 VCO4_selection_0.NAND_4in_0.d vp sg13_lv_pmos ad=0.1005p pd=1.34u as=0.1005p ps=1.34u w=0.15u l=0.13u
X79 a_62471_29603# after_000011_n a_62255_29603# gd sg13_lv_nmos ad=0.1005p pd=1.34u as=0.1005p ps=1.34u w=0.15u l=0.13u
X80 VCO2_selection_0.NAND_3in_2.y 101 a_68144_28653# gd sg13_lv_nmos ad=0.1005p pd=1.34u as=0.1005p ps=1.34u w=0.15u l=0.13u
X81 010 3bit_to_8_outs_0.NAND_3in_6.y gd gd sg13_lv_nmos ad=0.1005p pd=1.34u as=0.1005p ps=1.34u w=0.15u l=0.13u
X82 a_67415_25617# f5_n gd gd sg13_lv_nmos ad=0.1005p pd=1.34u as=0.1005p ps=1.34u w=0.15u l=0.13u
X83 VCO3_5_sel VCO3_selection_0.NAND_4in_1.a a_68997_25143# gd sg13_lv_nmos ad=0.1005p pd=1.34u as=0.1005p ps=1.34u w=0.15u l=0.13u
X84 vp after_000111 VCO3_selection_0.NAND_3in_3.y vp sg13_lv_pmos ad=0.1005p pd=1.34u as=0.1005p ps=1.34u w=0.15u l=0.13u
X85 vp after_000011 VCO4_selection_0.NAND_4in_0.b vp sg13_lv_pmos ad=0.1005p pd=1.34u as=0.1005p ps=1.34u w=0.15u l=0.13u
X86 vp VCO4_selection_0.NAND_4in_0.d VCO4_5_sel vp sg13_lv_pmos ad=0.1005p pd=1.34u as=0.1005p ps=1.34u w=0.15u l=0.13u
X87 a_68781_23187# 000000 gd gd sg13_lv_nmos ad=0.1005p pd=1.34u as=0.1005p ps=1.34u w=0.15u l=0.13u
X88 gd row_section_decoding_0.NAND_2in_0.b a_61717_23583# gd sg13_lv_nmos ad=0.1005p pd=1.34u as=0.1005p ps=1.34u w=0.15u l=0.13u
X89 a_62518_31586# after_001111 VCO_selection_0.NAND_2in_0.y gd sg13_lv_nmos ad=0.1005p pd=1.34u as=0.1005p ps=1.34u w=0.15u l=0.13u
X90 row_section_decoding_0.NAND_3in_0.b f5 gd gd sg13_lv_nmos ad=0.1005p pd=1.34u as=0.1005p ps=1.34u w=0.15u l=0.13u
X91 3bit_to_8_outs_0.NAND_3in_3.y c2 vp vp sg13_lv_pmos ad=0.1005p pd=1.34u as=0.1005p ps=1.34u w=0.15u l=0.13u
X92 VCO3_selection_0.NAND_3in_2.y 010 vp vp sg13_lv_pmos ad=0.1005p pd=1.34u as=0.1005p ps=1.34u w=0.15u l=0.13u
X93 a_62255_30077# 000 VCO4_selection_0.NAND_3in_1.y gd sg13_lv_nmos ad=0.1005p pd=1.34u as=0.1005p ps=1.34u w=0.15u l=0.13u
X94 a_67464_30135# after_000011 a_67248_30135# gd sg13_lv_nmos ad=0.1005p pd=1.34u as=0.1005p ps=1.34u w=0.15u l=0.13u
X95 3bit_to_8_outs_0.inverter_8.in 3bit_to_8_outs_0.c0_n a_61218_28107# gd sg13_lv_nmos ad=0.1005p pd=1.34u as=0.1005p ps=1.34u w=0.15u l=0.13u
X96 gd f4 row_section_decoding_0.NAND_2in_0.b gd sg13_lv_nmos ad=0.1005p pd=1.34u as=0.1005p ps=1.34u w=0.15u l=0.13u
X97 a_67934_30609# f5 gd gd sg13_lv_nmos ad=0.1005p pd=1.34u as=0.1005p ps=1.34u w=0.15u l=0.13u
X98 a_68781_23661# VCO3_selection_0.NAND_3in_1.y a_68565_23661# gd sg13_lv_nmos ad=0.1005p pd=1.34u as=0.1005p ps=1.34u w=0.15u l=0.13u
X99 3bit_to_8_outs_0.c0_n c0 vp vp sg13_lv_pmos ad=0.1005p pd=1.34u as=0.1005p ps=1.34u w=0.15u l=0.13u
X100 3bit_to_8_outs_0.NAND_3in_6.y 3bit_to_8_outs_0.c0_n vp vp sg13_lv_pmos ad=0.1005p pd=1.34u as=0.1005p ps=1.34u w=0.15u l=0.13u
X101 VCO3_selection_0.NAND_2in_0.y after_001111 vp vp sg13_lv_pmos ad=0.1005p pd=1.34u as=0.1005p ps=1.34u w=0.15u l=0.13u
X102 vp 3bit_to_8_outs_0.c1_n 3bit_to_8_outs_0.inverter_8.in vp sg13_lv_pmos ad=0.1005p pd=1.34u as=0.1005p ps=1.34u w=0.15u l=0.13u
X103 vp VCO3_selection_0.NAND_2in_0.y VCO3_selection_0.inverter_0.in vp sg13_lv_pmos ad=0.1005p pd=1.34u as=0.1005p ps=1.34u w=0.15u l=0.13u
X104 gd after_000011_n a_61054_30077# gd sg13_lv_nmos ad=0.1005p pd=1.34u as=0.1005p ps=1.34u w=0.15u l=0.13u
X105 VCO2_selection_0.NAND_3in_1.y VCO2_selection_0.NAND_3in_1.a vp vp sg13_lv_pmos ad=0.1005p pd=1.34u as=0.1005p ps=1.34u w=0.15u l=0.13u
X106 vp after_000111 VCO3_selection_0.NAND_3in_5.y vp sg13_lv_pmos ad=0.1005p pd=1.34u as=0.1005p ps=1.34u w=0.15u l=0.13u
X107 VCO5_selection_0.NAND_2in_0.a after_000011_n vp vp sg13_lv_pmos ad=0.1005p pd=1.34u as=0.1005p ps=1.34u w=0.15u l=0.13u
X108 vp VCO_selection_0.NAND_2in_2.y VCO_sel vp sg13_lv_pmos ad=0.1005p pd=1.34u as=0.1005p ps=1.34u w=0.15u l=0.13u
X109 011 3bit_to_8_outs_0.inverter_10.in vp vp sg13_lv_pmos ad=0.1005p pd=1.34u as=0.1005p ps=1.34u w=0.15u l=0.13u
X110 a_60555_25065# row_section_decoding_0.NAND_3in_0.a 000000_n gd sg13_lv_nmos ad=0.1005p pd=1.34u as=0.1005p ps=1.34u w=0.15u l=0.13u
X111 a_62048_31586# VCO_selection_0.NAND_2in_0.y a_61832_31586# gd sg13_lv_nmos ad=0.1005p pd=1.34u as=0.1005p ps=1.34u w=0.15u l=0.13u
X112 vp 010 VCO5_selection_0.NAND_2in_0.b vp sg13_lv_pmos ad=0.1005p pd=1.34u as=0.1005p ps=1.34u w=0.15u l=0.13u
X113 VCO2_selection_0.NAND_4in_1.c 000000_n vp vp sg13_lv_pmos ad=0.1005p pd=1.34u as=0.1005p ps=1.34u w=0.15u l=0.13u
X114 a_61218_26145# c1 a_61002_26145# gd sg13_lv_nmos ad=0.1005p pd=1.34u as=0.1005p ps=1.34u w=0.15u l=0.13u
X115 vp 111 VCO_selection_0.NAND_2in_1.y vp sg13_lv_pmos ad=0.1005p pd=1.34u as=0.1005p ps=1.34u w=0.15u l=0.13u
X116 gd after_001111_n a_62471_30077# gd sg13_lv_nmos ad=0.1005p pd=1.34u as=0.1005p ps=1.34u w=0.15u l=0.13u
X117 vp c1 3bit_to_8_outs_0.inverter_1.in vp sg13_lv_pmos ad=0.1005p pd=1.34u as=0.1005p ps=1.34u w=0.15u l=0.13u
X118 VCO3_selection_0.NAND_2in_3.y after_000011_n vp vp sg13_lv_pmos ad=0.1005p pd=1.34u as=0.1005p ps=1.34u w=0.15u l=0.13u
X119 VCO2_5_sel VCO2_selection_0.NAND_4in_0.b vp vp sg13_lv_pmos ad=0.1005p pd=1.34u as=0.1005p ps=1.34u w=0.15u l=0.13u
X120 VCO2_selection_0.NAND_3in_1.a f5 vp vp sg13_lv_pmos ad=0.1005p pd=1.34u as=0.1005p ps=1.34u w=0.15u l=0.13u
X121 VCO2_selection_0.NAND_4in_0.b 101 a_68163_30135# gd sg13_lv_nmos ad=0.1005p pd=1.34u as=0.1005p ps=1.34u w=0.15u l=0.13u
X122 vp 011 VCO2_selection_0.NAND_3in_1.b vp sg13_lv_pmos ad=0.1005p pd=1.34u as=0.1005p ps=1.34u w=0.15u l=0.13u
X123 VCO2_selection_0.NAND_3in_1.y VCO2_selection_0.NAND_3in_1.a a_68425_26697# gd sg13_lv_nmos ad=0.1005p pd=1.34u as=0.1005p ps=1.34u w=0.15u l=0.13u
X124 3bit_to_8_outs_0.inverter_10.in 3bit_to_8_outs_0.c2_n vp vp sg13_lv_pmos ad=0.1005p pd=1.34u as=0.1005p ps=1.34u w=0.15u l=0.13u
X125 vp VCO3_selection_0.inverter_0.out VCO3_11_sel vp sg13_lv_pmos ad=0.1005p pd=1.34u as=0.1005p ps=1.34u w=0.15u l=0.13u
X126 gd 110 a_62518_31586# gd sg13_lv_nmos ad=0.1005p pd=1.34u as=0.1005p ps=1.34u w=0.15u l=0.13u
X127 VCO2_selection_0.NAND_4in_1.d after_000011_n vp vp sg13_lv_pmos ad=0.1005p pd=1.34u as=0.1005p ps=1.34u w=0.15u l=0.13u
X128 gd row_section_decoding_0.NAND_3in_0.c a_60771_25065# gd sg13_lv_nmos ad=0.1005p pd=1.34u as=0.1005p ps=1.34u w=0.15u l=0.13u
X129 a_67631_25143# after_000111 a_67415_25143# gd sg13_lv_nmos ad=0.1005p pd=1.34u as=0.1005p ps=1.34u w=0.15u l=0.13u
X130 VCO3_selection_0.NAND_3in_3.y after_001111_n vp vp sg13_lv_pmos ad=0.1005p pd=1.34u as=0.1005p ps=1.34u w=0.15u l=0.13u
X131 vp after_000111_n after_000111 vp sg13_lv_pmos ad=0.1005p pd=1.34u as=0.1005p ps=1.34u w=0.15u l=0.13u
X132 VCO4_5_sel VCO4_selection_0.NAND_3in_0.y vp vp sg13_lv_pmos ad=0.1005p pd=1.34u as=0.1005p ps=1.34u w=0.15u l=0.13u
X133 vp VCO3_selection_0.NAND_3in_5.y VCO3_selection_0.NAND_3in_4.y vp sg13_lv_pmos ad=0.1005p pd=1.34u as=0.1005p ps=1.34u w=0.15u l=0.13u
X134 a_62193_22605# f5 a_61977_22605# vp sg13_lv_pmos ad=0.1005p pd=1.34u as=0.1005p ps=1.34u w=0.15u l=0.13u
X135 after_001111_n f5 gd gd sg13_lv_nmos ad=0.1005p pd=1.34u as=0.1005p ps=1.34u w=0.15u l=0.13u
X136 VCO3_5_sel VCO3_selection_0.NAND_2in_4.y vp vp sg13_lv_pmos ad=0.1005p pd=1.34u as=0.1005p ps=1.34u w=0.15u l=0.13u
X137 VCO4_selection_0.NAND_3in_0.y after_000011_n vp vp sg13_lv_pmos ad=0.1005p pd=1.34u as=0.1005p ps=1.34u w=0.15u l=0.13u
X138 a_68101_21705# after_001111 gd gd sg13_lv_nmos ad=0.1005p pd=1.34u as=0.1005p ps=1.34u w=0.15u l=0.13u
X139 a_62193_24087# f3 row_section_decoding_0.NAND_2in_0.a vp sg13_lv_pmos ad=0.1005p pd=1.34u as=0.1005p ps=1.34u w=0.15u l=0.13u
X140 VCO2_selection_0.NAND_3in_0.y 100 vp vp sg13_lv_pmos ad=0.1005p pd=1.34u as=0.1005p ps=1.34u w=0.15u l=0.13u
X141 a_67248_26697# f5 gd gd sg13_lv_nmos ad=0.1005p pd=1.34u as=0.1005p ps=1.34u w=0.15u l=0.13u
X142 VCO3_selection_0.inverter_0.in VCO3_selection_0.NAND_2in_0.y a_68577_21705# gd sg13_lv_nmos ad=0.1005p pd=1.34u as=0.1005p ps=1.34u w=0.15u l=0.13u
X143 VCO2_selection_0.NAND_3in_1.b 011 a_67724_26697# gd sg13_lv_nmos ad=0.1005p pd=1.34u as=0.1005p ps=1.34u w=0.15u l=0.13u
X144 vp 000 VCO4_selection_0.NAND_3in_1.y vp sg13_lv_pmos ad=0.1005p pd=1.34u as=0.1005p ps=1.34u w=0.15u l=0.13u
X145 3bit_to_8_outs_0.inverter_8.in 3bit_to_8_outs_0.c0_n vp vp sg13_lv_pmos ad=0.1005p pd=1.34u as=0.1005p ps=1.34u w=0.15u l=0.13u
X146 a_61898_27789# c1 a_61682_27789# gd sg13_lv_nmos ad=0.1005p pd=1.34u as=0.1005p ps=1.34u w=0.15u l=0.13u
X147 VCO3_selection_0.NAND_2in_2.y 000000 vp vp sg13_lv_pmos ad=0.1005p pd=1.34u as=0.1005p ps=1.34u w=0.15u l=0.13u
X148 VCO2_selection_0.NAND_4in_0.a after_000111 vp vp sg13_lv_pmos ad=0.1005p pd=1.34u as=0.1005p ps=1.34u w=0.15u l=0.13u
X149 a_61682_26463# c2 gd gd sg13_lv_nmos ad=0.1005p pd=1.34u as=0.1005p ps=1.34u w=0.15u l=0.13u
X150 a_62193_24561# f5 row_section_decoding_0.NAND_3in_0.b vp sg13_lv_pmos ad=0.1005p pd=1.34u as=0.1005p ps=1.34u w=0.15u l=0.13u
X151 VCO2_selection_0.NAND_4in_0.d 111 vp vp sg13_lv_pmos ad=0.1005p pd=1.34u as=0.1005p ps=1.34u w=0.15u l=0.13u
X152 VCO3_selection_0.NAND_3in_5.y f5_n vp vp sg13_lv_pmos ad=0.1005p pd=1.34u as=0.1005p ps=1.34u w=0.15u l=0.13u
X153 a_68101_23661# after_000011_n gd gd sg13_lv_nmos ad=0.1005p pd=1.34u as=0.1005p ps=1.34u w=0.15u l=0.13u
X154 gd 111 a_62042_31904# gd sg13_lv_nmos ad=0.1005p pd=1.34u as=0.1005p ps=1.34u w=0.15u l=0.13u
X155 vp VCO2_selection_0.NAND_3in_1.b VCO2_selection_0.NAND_3in_1.y vp sg13_lv_pmos ad=0.1005p pd=1.34u as=0.1005p ps=1.34u w=0.15u l=0.13u
X156 3bit_to_8_outs_0.NAND_3in_0.y c0 a_61218_26145# gd sg13_lv_nmos ad=0.1005p pd=1.34u as=0.1005p ps=1.34u w=0.15u l=0.13u
X157 vp f4 a_61457_22605# vp sg13_lv_pmos ad=0.1005p pd=1.34u as=0.1005p ps=1.34u w=0.15u l=0.13u
X158 VCO3_5_sel VCO3_selection_0.NAND_3in_6.y vp vp sg13_lv_pmos ad=0.1005p pd=1.34u as=0.1005p ps=1.34u w=0.15u l=0.13u
X159 a_67248_32151# after_000011_n gd gd sg13_lv_nmos ad=0.1005p pd=1.34u as=0.1005p ps=1.34u w=0.15u l=0.13u
X160 vp after_000011_n VCO4_selection_0.NAND_2in_0.y vp sg13_lv_pmos ad=0.1005p pd=1.34u as=0.1005p ps=1.34u w=0.15u l=0.13u
X161 a_68095_23187# 000000_n gd gd sg13_lv_nmos ad=0.1005p pd=1.34u as=0.1005p ps=1.34u w=0.15u l=0.13u
X162 VCO5_selection_0.NAND_2in_0.b 010 a_67724_32151# gd sg13_lv_nmos ad=0.1005p pd=1.34u as=0.1005p ps=1.34u w=0.15u l=0.13u
X163 VCO5_selection_0.NAND_2in_0.b 000000 vp vp sg13_lv_pmos ad=0.1005p pd=1.34u as=0.1005p ps=1.34u w=0.15u l=0.13u
X164 vp after_000111 VCO2_selection_0.NAND_4in_0.b vp sg13_lv_pmos ad=0.1005p pd=1.34u as=0.1005p ps=1.34u w=0.15u l=0.13u
X165 010 3bit_to_8_outs_0.NAND_3in_6.y vp vp sg13_lv_pmos ad=0.1005p pd=1.34u as=0.1005p ps=1.34u w=0.15u l=0.13u
X166 3bit_to_8_outs_0.NAND_3in_3.y c0 vp vp sg13_lv_pmos ad=0.1005p pd=1.34u as=0.1005p ps=1.34u w=0.15u l=0.13u
X167 VCO3_selection_0.NAND_2in_5.y 001 a_68101_25617# gd sg13_lv_nmos ad=0.1005p pd=1.34u as=0.1005p ps=1.34u w=0.15u l=0.13u
X168 VCO_selection_0.NAND_2in_0.y after_001111 vp vp sg13_lv_pmos ad=0.1005p pd=1.34u as=0.1005p ps=1.34u w=0.15u l=0.13u
X169 vp after_001111_n VCO4_selection_0.NAND_3in_1.y vp sg13_lv_pmos ad=0.1005p pd=1.34u as=0.1005p ps=1.34u w=0.15u l=0.13u
X170 VCO2_selection_0.NAND_4in_1.c 110 a_67464_28179# gd sg13_lv_nmos ad=0.1005p pd=1.34u as=0.1005p ps=1.34u w=0.15u l=0.13u
X171 vp after_000111 VCO3_selection_0.NAND_3in_0.y vp sg13_lv_pmos ad=0.1005p pd=1.34u as=0.1005p ps=1.34u w=0.15u l=0.13u
X172 VCO2_selection_0.NAND_2in_0.y f5 vp vp sg13_lv_pmos ad=0.1005p pd=1.34u as=0.1005p ps=1.34u w=0.15u l=0.13u
X173 a_61682_28107# 3bit_to_8_outs_0.c2_n gd gd sg13_lv_nmos ad=0.1005p pd=1.34u as=0.1005p ps=1.34u w=0.15u l=0.13u
X174 a_68830_28179# VCO2_selection_0.NAND_3in_2.y a_68614_28179# gd sg13_lv_nmos ad=0.1005p pd=1.34u as=0.1005p ps=1.34u w=0.15u l=0.13u
X175 vp c1 3bit_to_8_outs_0.NAND_3in_0.y vp sg13_lv_pmos ad=0.1005p pd=1.34u as=0.1005p ps=1.34u w=0.15u l=0.13u
X176 vp row_section_decoding_0.NAND_3in_0.a 000000_n vp sg13_lv_pmos ad=0.1005p pd=1.34u as=0.1005p ps=1.34u w=0.15u l=0.13u
X177 VCO3_11_sel VCO3_selection_0.inverter_0.out a_68997_23661# gd sg13_lv_nmos ad=0.1005p pd=1.34u as=0.1005p ps=1.34u w=0.15u l=0.13u
X178 VCO2_selection_0.NAND_3in_1.b after_001111 vp vp sg13_lv_pmos ad=0.1005p pd=1.34u as=0.1005p ps=1.34u w=0.15u l=0.13u
X179 100 3bit_to_8_outs_0.inverter_6.in vp vp sg13_lv_pmos ad=0.1005p pd=1.34u as=0.1005p ps=1.34u w=0.15u l=0.13u
X180 a_68425_26697# VCO2_selection_0.NAND_3in_1.b a_68209_26697# gd sg13_lv_nmos ad=0.1005p pd=1.34u as=0.1005p ps=1.34u w=0.15u l=0.13u
X181 gd after_000111_n after_000111 gd sg13_lv_nmos ad=0.1005p pd=1.34u as=0.1005p ps=1.34u w=0.15u l=0.13u
X182 a_67248_30135# after_000111_n gd gd sg13_lv_nmos ad=0.1005p pd=1.34u as=0.1005p ps=1.34u w=0.15u l=0.13u
X183 row_section_decoding_0.NAND_2in_0.b f5 gd gd sg13_lv_nmos ad=0.1005p pd=1.34u as=0.1005p ps=1.34u w=0.15u l=0.13u
X184 row_section_decoding_0.NAND_2in_0.a f3 gd gd sg13_lv_nmos ad=0.1005p pd=1.34u as=0.1005p ps=1.34u w=0.15u l=0.13u
X185 VCO2_selection_0.NAND_3in_0.y 100 a_67464_28653# gd sg13_lv_nmos ad=0.1005p pd=1.34u as=0.1005p ps=1.34u w=0.15u l=0.13u
X186 vp 000000_n VCO3_selection_0.NAND_3in_6.y vp sg13_lv_pmos ad=0.1005p pd=1.34u as=0.1005p ps=1.34u w=0.15u l=0.13u
X187 a_67415_25143# after_001111_n gd gd sg13_lv_nmos ad=0.1005p pd=1.34u as=0.1005p ps=1.34u w=0.15u l=0.13u
X188 a_68565_25143# VCO3_selection_0.NAND_2in_4.y gd gd sg13_lv_nmos ad=0.1005p pd=1.34u as=0.1005p ps=1.34u w=0.15u l=0.13u
X189 VCO3_selection_0.inverter_0.in VCO3_selection_0.NAND_3in_0.y vp vp sg13_lv_pmos ad=0.1005p pd=1.34u as=0.1005p ps=1.34u w=0.15u l=0.13u
X190 3bit_to_8_outs_0.inverter_6.in c2 vp vp sg13_lv_pmos ad=0.1005p pd=1.34u as=0.1005p ps=1.34u w=0.15u l=0.13u
X191 VCO_sel VCO_selection_0.NAND_2in_0.y vp vp sg13_lv_pmos ad=0.1005p pd=1.34u as=0.1005p ps=1.34u w=0.15u l=0.13u
X192 gd f2 row_section_decoding_0.NAND_3in_0.a gd sg13_lv_nmos ad=0.1005p pd=1.34u as=0.1005p ps=1.34u w=0.15u l=0.13u
X193 vp row_section_decoding_0.NAND_3in_0.c 000000_n vp sg13_lv_pmos ad=0.1005p pd=1.34u as=0.1005p ps=1.34u w=0.15u l=0.13u
X194 VCO2_selection_0.NAND_4in_0.a 110 a_67464_30609# gd sg13_lv_nmos ad=0.1005p pd=1.34u as=0.1005p ps=1.34u w=0.15u l=0.13u
X195 a_67724_26697# after_001111 gd gd sg13_lv_nmos ad=0.1005p pd=1.34u as=0.1005p ps=1.34u w=0.15u l=0.13u
X196 a_60981_22605# f5 after_001111_n vp sg13_lv_pmos ad=0.1005p pd=1.34u as=0.1005p ps=1.34u w=0.15u l=0.13u
X197 a_61785_29603# 011 VCO4_selection_0.NAND_4in_0.d gd sg13_lv_nmos ad=0.1005p pd=1.34u as=0.1005p ps=1.34u w=0.15u l=0.13u
X198 gd f4 after_000111_n gd sg13_lv_nmos ad=0.1005p pd=1.34u as=0.1005p ps=1.34u w=0.15u l=0.13u
X199 3bit_to_8_outs_0.c1_n c1 gd gd sg13_lv_nmos ad=0.1005p pd=1.34u as=0.1005p ps=1.34u w=0.15u l=0.13u
X200 a_61218_27789# c1 a_61002_27789# gd sg13_lv_nmos ad=0.1005p pd=1.34u as=0.1005p ps=1.34u w=0.15u l=0.13u
X201 VCO3_selection_0.NAND_4in_1.a VCO3_selection_0.NAND_3in_4.y gd gd sg13_lv_nmos ad=0.1005p pd=1.34u as=0.1005p ps=1.34u w=0.15u l=0.13u
X202 VCO5_11_sel VCO5_selection_0.NAND_2in_0.b vp vp sg13_lv_pmos ad=0.1005p pd=1.34u as=0.1005p ps=1.34u w=0.15u l=0.13u
X203 a_67631_21705# after_000111 a_67415_21705# gd sg13_lv_nmos ad=0.1005p pd=1.34u as=0.1005p ps=1.34u w=0.15u l=0.13u
X204 a_61740_30077# after_000111_n a_61524_30077# gd sg13_lv_nmos ad=0.1005p pd=1.34u as=0.1005p ps=1.34u w=0.15u l=0.13u
X205 a_68997_25143# VCO3_selection_0.NAND_3in_6.y a_68781_25143# gd sg13_lv_nmos ad=0.1005p pd=1.34u as=0.1005p ps=1.34u w=0.15u l=0.13u
X206 a_67631_23187# after_000011 a_67415_23187# gd sg13_lv_nmos ad=0.1005p pd=1.34u as=0.1005p ps=1.34u w=0.15u l=0.13u
X207 a_67724_32151# 000000 gd gd sg13_lv_nmos ad=0.1005p pd=1.34u as=0.1005p ps=1.34u w=0.15u l=0.13u
X208 vp 110 VCO_selection_0.NAND_2in_0.y vp sg13_lv_pmos ad=0.1005p pd=1.34u as=0.1005p ps=1.34u w=0.15u l=0.13u
X209 VCO3_selection_0.NAND_3in_0.y f5_n vp vp sg13_lv_pmos ad=0.1005p pd=1.34u as=0.1005p ps=1.34u w=0.15u l=0.13u
X210 vp 110 VCO3_selection_0.NAND_2in_4.y vp sg13_lv_pmos ad=0.1005p pd=1.34u as=0.1005p ps=1.34u w=0.15u l=0.13u
X211 vp after_000011 VCO2_selection_0.NAND_3in_2.y vp sg13_lv_pmos ad=0.1005p pd=1.34u as=0.1005p ps=1.34u w=0.15u l=0.13u
X212 3bit_to_8_outs_0.NAND_3in_0.y c0 vp vp sg13_lv_pmos ad=0.1005p pd=1.34u as=0.1005p ps=1.34u w=0.15u l=0.13u
X213 a_68614_28179# VCO2_selection_0.NAND_4in_1.c a_68398_28179# gd sg13_lv_nmos ad=0.1005p pd=1.34u as=0.1005p ps=1.34u w=0.15u l=0.13u
X214 VCO3_selection_0.NAND_3in_1.y 000000_n vp vp sg13_lv_pmos ad=0.1005p pd=1.34u as=0.1005p ps=1.34u w=0.15u l=0.13u
X215 a_67631_23661# 000000_n a_67415_23661# gd sg13_lv_nmos ad=0.1005p pd=1.34u as=0.1005p ps=1.34u w=0.15u l=0.13u
X216 a_68683_30609# VCO2_selection_0.NAND_2in_0.y a_68467_30609# gd sg13_lv_nmos ad=0.1005p pd=1.34u as=0.1005p ps=1.34u w=0.15u l=0.13u
X217 3bit_to_8_outs_0.NAND_3in_2.y 3bit_to_8_outs_0.c2_n vp vp sg13_lv_pmos ad=0.1005p pd=1.34u as=0.1005p ps=1.34u w=0.15u l=0.13u
X218 3bit_to_8_outs_0.NAND_3in_3.y c0 a_61898_26463# gd sg13_lv_nmos ad=0.1005p pd=1.34u as=0.1005p ps=1.34u w=0.15u l=0.13u
X219 vp c1 3bit_to_8_outs_0.NAND_3in_6.y vp sg13_lv_pmos ad=0.1005p pd=1.34u as=0.1005p ps=1.34u w=0.15u l=0.13u
X220 101 3bit_to_8_outs_0.NAND_3in_3.y vp vp sg13_lv_pmos ad=0.1005p pd=1.34u as=0.1005p ps=1.34u w=0.15u l=0.13u
X221 a_68577_21705# VCO3_selection_0.NAND_3in_0.y gd gd sg13_lv_nmos ad=0.1005p pd=1.34u as=0.1005p ps=1.34u w=0.15u l=0.13u
X222 VCO2_selection_0.NAND_4in_1.d 111 a_67934_28179# gd sg13_lv_nmos ad=0.1005p pd=1.34u as=0.1005p ps=1.34u w=0.15u l=0.13u
X223 VCO2_selection_0.NAND_4in_1.c 110 vp vp sg13_lv_pmos ad=0.1005p pd=1.34u as=0.1005p ps=1.34u w=0.15u l=0.13u
X224 VCO3_selection_0.NAND_3in_6.y after_000111_n vp vp sg13_lv_pmos ad=0.1005p pd=1.34u as=0.1005p ps=1.34u w=0.15u l=0.13u
X225 VCO2_11_sel VCO2_selection_0.NAND_3in_2.y vp vp sg13_lv_pmos ad=0.1005p pd=1.34u as=0.1005p ps=1.34u w=0.15u l=0.13u
X226 100 3bit_to_8_outs_0.inverter_6.in gd gd sg13_lv_nmos ad=0.1005p pd=1.34u as=0.1005p ps=1.34u w=0.15u l=0.13u
X227 a_61682_26145# c2 gd gd sg13_lv_nmos ad=0.1005p pd=1.34u as=0.1005p ps=1.34u w=0.15u l=0.13u
X228 VCO3_selection_0.NAND_3in_5.y 010 a_67631_25617# gd sg13_lv_nmos ad=0.1005p pd=1.34u as=0.1005p ps=1.34u w=0.15u l=0.13u
X229 VCO3_11_sel VCO3_selection_0.NAND_2in_2.y vp vp sg13_lv_pmos ad=0.1005p pd=1.34u as=0.1005p ps=1.34u w=0.15u l=0.13u
X230 VCO2_selection_0.NAND_3in_1.y VCO2_selection_0.NAND_3in_0.y vp vp sg13_lv_pmos ad=0.1005p pd=1.34u as=0.1005p ps=1.34u w=0.15u l=0.13u
X231 vp 001 VCO3_selection_0.NAND_2in_5.y vp sg13_lv_pmos ad=0.1005p pd=1.34u as=0.1005p ps=1.34u w=0.15u l=0.13u
X232 a_61457_22605# f5 row_section_decoding_0.NAND_2in_0.b vp sg13_lv_pmos ad=0.1005p pd=1.34u as=0.1005p ps=1.34u w=0.15u l=0.13u
X233 VCO2_selection_0.inverter_0.out VCO2_selection_0.NAND_3in_1.y vp vp sg13_lv_pmos ad=0.1005p pd=1.34u as=0.1005p ps=1.34u w=0.15u l=0.13u
X234 a_68582_25617# VCO3_selection_0.NAND_3in_3.y gd gd sg13_lv_nmos ad=0.1005p pd=1.34u as=0.1005p ps=1.34u w=0.15u l=0.13u
X235 3bit_to_8_outs_0.NAND_3in_2.y c0 a_61898_28107# gd sg13_lv_nmos ad=0.1005p pd=1.34u as=0.1005p ps=1.34u w=0.15u l=0.13u
X236 3bit_to_8_outs_0.inverter_10.in c0 a_61218_27789# gd sg13_lv_nmos ad=0.1005p pd=1.34u as=0.1005p ps=1.34u w=0.15u l=0.13u
X237 a_61002_26463# c2 gd gd sg13_lv_nmos ad=0.1005p pd=1.34u as=0.1005p ps=1.34u w=0.15u l=0.13u
X238 VCO_selection_0.NAND_2in_2.y 101 vp vp sg13_lv_pmos ad=0.1005p pd=1.34u as=0.1005p ps=1.34u w=0.15u l=0.13u
X239 VCO2_selection_0.NAND_2in_0.y 100 a_67934_30609# gd sg13_lv_nmos ad=0.1005p pd=1.34u as=0.1005p ps=1.34u w=0.15u l=0.13u
X240 a_61105_29603# VCO4_selection_0.NAND_4in_0.b a_60889_29603# gd sg13_lv_nmos ad=0.1005p pd=1.34u as=0.1005p ps=1.34u w=0.15u l=0.13u
X241 000 3bit_to_8_outs_0.inverter_8.in gd gd sg13_lv_nmos ad=0.1005p pd=1.34u as=0.1005p ps=1.34u w=0.15u l=0.13u
X242 vp f2 a_61241_24561# vp sg13_lv_pmos ad=0.1005p pd=1.34u as=0.1005p ps=1.34u w=0.15u l=0.13u
X243 a_68200_32151# VCO5_selection_0.NAND_2in_0.b gd gd sg13_lv_nmos ad=0.1005p pd=1.34u as=0.1005p ps=1.34u w=0.15u l=0.13u
X244 VCO4_selection_0.NAND_4in_0.d 011 vp vp sg13_lv_pmos ad=0.1005p pd=1.34u as=0.1005p ps=1.34u w=0.15u l=0.13u
X245 a_68209_26697# VCO2_selection_0.NAND_3in_0.y gd gd sg13_lv_nmos ad=0.1005p pd=1.34u as=0.1005p ps=1.34u w=0.15u l=0.13u
X246 a_67415_21705# f5_n gd gd sg13_lv_nmos ad=0.1005p pd=1.34u as=0.1005p ps=1.34u w=0.15u l=0.13u
X247 VCO3_11_sel VCO3_selection_0.NAND_3in_2.y vp vp sg13_lv_pmos ad=0.1005p pd=1.34u as=0.1005p ps=1.34u w=0.15u l=0.13u
X248 a_61524_30077# 001 VCO4_selection_0.NAND_4in_0.b gd sg13_lv_nmos ad=0.1005p pd=1.34u as=0.1005p ps=1.34u w=0.15u l=0.13u
X249 a_62255_29603# 010 VCO4_selection_0.NAND_3in_0.y gd sg13_lv_nmos ad=0.1005p pd=1.34u as=0.1005p ps=1.34u w=0.15u l=0.13u
X250 a_68144_28653# after_000011 a_67928_28653# gd sg13_lv_nmos ad=0.1005p pd=1.34u as=0.1005p ps=1.34u w=0.15u l=0.13u
X251 VCO2_selection_0.inverter_0.out VCO2_selection_0.NAND_3in_1.y gd gd sg13_lv_nmos ad=0.1005p pd=1.34u as=0.1005p ps=1.34u w=0.15u l=0.13u
X252 a_67415_23187# after_000111_n gd gd sg13_lv_nmos ad=0.1005p pd=1.34u as=0.1005p ps=1.34u w=0.15u l=0.13u
X253 vp after_000011 after_000011_n vp sg13_lv_pmos ad=0.1005p pd=1.34u as=0.1005p ps=1.34u w=0.15u l=0.13u
X254 VCO4_selection_0.NAND_4in_0.b after_000111_n vp vp sg13_lv_pmos ad=0.1005p pd=1.34u as=0.1005p ps=1.34u w=0.15u l=0.13u
X255 a_61977_22605# f4 after_000111_n vp sg13_lv_pmos ad=0.1005p pd=1.34u as=0.1005p ps=1.34u w=0.15u l=0.13u
X256 VCO2_selection_0.NAND_4in_0.a 110 vp vp sg13_lv_pmos ad=0.1005p pd=1.34u as=0.1005p ps=1.34u w=0.15u l=0.13u
X257 VCO3_selection_0.NAND_2in_4.y 110 a_68101_25143# gd sg13_lv_nmos ad=0.1005p pd=1.34u as=0.1005p ps=1.34u w=0.15u l=0.13u
X258 gd f5 f5_n gd sg13_lv_nmos ad=0.1005p pd=1.34u as=0.1005p ps=1.34u w=0.15u l=0.13u
X259 a_61002_28107# 3bit_to_8_outs_0.c2_n gd gd sg13_lv_nmos ad=0.1005p pd=1.34u as=0.1005p ps=1.34u w=0.15u l=0.13u
X260 vp after_000011 VCO3_selection_0.NAND_3in_2.y vp sg13_lv_pmos ad=0.1005p pd=1.34u as=0.1005p ps=1.34u w=0.15u l=0.13u
X261 a_67415_23661# after_000111_n gd gd sg13_lv_nmos ad=0.1005p pd=1.34u as=0.1005p ps=1.34u w=0.15u l=0.13u
X262 VCO3_selection_0.NAND_4in_1.a VCO3_selection_0.NAND_3in_4.y vp vp sg13_lv_pmos ad=0.1005p pd=1.34u as=0.1005p ps=1.34u w=0.15u l=0.13u
X263 gd f3 after_000111_n gd sg13_lv_nmos ad=0.1005p pd=1.34u as=0.1005p ps=1.34u w=0.15u l=0.13u
X264 a_68565_23661# VCO3_selection_0.NAND_2in_2.y gd gd sg13_lv_nmos ad=0.1005p pd=1.34u as=0.1005p ps=1.34u w=0.15u l=0.13u
X265 gd 000000_n a_62471_29603# gd sg13_lv_nmos ad=0.1005p pd=1.34u as=0.1005p ps=1.34u w=0.15u l=0.13u
X266 vp 000000_n 000000 vp sg13_lv_pmos ad=0.1005p pd=1.34u as=0.1005p ps=1.34u w=0.15u l=0.13u
X267 VCO3_selection_0.NAND_3in_3.y 011 vp vp sg13_lv_pmos ad=0.1005p pd=1.34u as=0.1005p ps=1.34u w=0.15u l=0.13u
X268 a_61054_30077# 001 VCO4_selection_0.NAND_2in_0.y gd sg13_lv_nmos ad=0.1005p pd=1.34u as=0.1005p ps=1.34u w=0.15u l=0.13u
X269 vp VCO2_selection_0.NAND_4in_1.c VCO2_11_sel vp sg13_lv_pmos ad=0.1005p pd=1.34u as=0.1005p ps=1.34u w=0.15u l=0.13u
X270 3bit_to_8_outs_0.c1_n c1 vp vp sg13_lv_pmos ad=0.1005p pd=1.34u as=0.1005p ps=1.34u w=0.15u l=0.13u
X271 vp c1 3bit_to_8_outs_0.inverter_10.in vp sg13_lv_pmos ad=0.1005p pd=1.34u as=0.1005p ps=1.34u w=0.15u l=0.13u
X272 VCO3_selection_0.NAND_2in_2.y 100 a_68781_23187# gd sg13_lv_nmos ad=0.1005p pd=1.34u as=0.1005p ps=1.34u w=0.15u l=0.13u
X273 VCO2_selection_0.NAND_4in_0.b f5_n vp vp sg13_lv_pmos ad=0.1005p pd=1.34u as=0.1005p ps=1.34u w=0.15u l=0.13u
X274 101 3bit_to_8_outs_0.NAND_3in_3.y gd gd sg13_lv_nmos ad=0.1005p pd=1.34u as=0.1005p ps=1.34u w=0.15u l=0.13u
X275 vp 111 VCO2_selection_0.NAND_4in_1.d vp sg13_lv_pmos ad=0.1005p pd=1.34u as=0.1005p ps=1.34u w=0.15u l=0.13u
X276 vp 3bit_to_8_outs_0.c1_n 3bit_to_8_outs_0.NAND_3in_3.y vp sg13_lv_pmos ad=0.1005p pd=1.34u as=0.1005p ps=1.34u w=0.15u l=0.13u
X277 gd f4 row_section_decoding_0.NAND_3in_0.b gd sg13_lv_nmos ad=0.1005p pd=1.34u as=0.1005p ps=1.34u w=0.15u l=0.13u
X278 a_62518_31904# 101 VCO_selection_0.NAND_2in_2.y gd sg13_lv_nmos ad=0.1005p pd=1.34u as=0.1005p ps=1.34u w=0.15u l=0.13u
X279 a_62471_30077# after_000011 a_62255_30077# gd sg13_lv_nmos ad=0.1005p pd=1.34u as=0.1005p ps=1.34u w=0.15u l=0.13u
X280 3bit_to_8_outs_0.inverter_1.in c2 vp vp sg13_lv_pmos ad=0.1005p pd=1.34u as=0.1005p ps=1.34u w=0.15u l=0.13u
X281 gd f4 after_001111_n gd sg13_lv_nmos ad=0.1005p pd=1.34u as=0.1005p ps=1.34u w=0.15u l=0.13u
X282 VCO_selection_0.NAND_2in_1.y after_000111 vp vp sg13_lv_pmos ad=0.1005p pd=1.34u as=0.1005p ps=1.34u w=0.15u l=0.13u
X283 vp VCO2_selection_0.NAND_2in_0.y VCO2_5_sel vp sg13_lv_pmos ad=0.1005p pd=1.34u as=0.1005p ps=1.34u w=0.15u l=0.13u
X284 VCO2_selection_0.NAND_4in_0.d 111 a_67464_30135# gd sg13_lv_nmos ad=0.1005p pd=1.34u as=0.1005p ps=1.34u w=0.15u l=0.13u
X285 vp f5 VCO_selection_0.NAND_2in_2.y vp sg13_lv_pmos ad=0.1005p pd=1.34u as=0.1005p ps=1.34u w=0.15u l=0.13u
X286 VCO2_5_sel VCO2_selection_0.NAND_4in_0.a a_68899_30609# gd sg13_lv_nmos ad=0.1005p pd=1.34u as=0.1005p ps=1.34u w=0.15u l=0.13u
X287 3bit_to_8_outs_0.NAND_3in_2.y c0 vp vp sg13_lv_pmos ad=0.1005p pd=1.34u as=0.1005p ps=1.34u w=0.15u l=0.13u
X288 vp 000 VCO3_selection_0.NAND_2in_0.y vp sg13_lv_pmos ad=0.1005p pd=1.34u as=0.1005p ps=1.34u w=0.15u l=0.13u
X289 a_68997_23661# VCO3_selection_0.NAND_3in_2.y a_68781_23661# gd sg13_lv_nmos ad=0.1005p pd=1.34u as=0.1005p ps=1.34u w=0.15u l=0.13u
X290 gd after_000011 after_000011_n gd sg13_lv_nmos ad=0.1005p pd=1.34u as=0.1005p ps=1.34u w=0.15u l=0.13u
X291 a_68163_30135# after_000111 a_67947_30135# gd sg13_lv_nmos ad=0.1005p pd=1.34u as=0.1005p ps=1.34u w=0.15u l=0.13u
X292 a_68398_28179# VCO2_selection_0.NAND_4in_1.d gd gd sg13_lv_nmos ad=0.1005p pd=1.34u as=0.1005p ps=1.34u w=0.15u l=0.13u
X293 VCO3_selection_0.NAND_3in_5.y 010 vp vp sg13_lv_pmos ad=0.1005p pd=1.34u as=0.1005p ps=1.34u w=0.15u l=0.13u
X294 a_68467_30609# VCO2_selection_0.NAND_4in_0.d gd gd sg13_lv_nmos ad=0.1005p pd=1.34u as=0.1005p ps=1.34u w=0.15u l=0.13u
X295 000 3bit_to_8_outs_0.inverter_8.in vp vp sg13_lv_pmos ad=0.1005p pd=1.34u as=0.1005p ps=1.34u w=0.15u l=0.13u
X296 001 3bit_to_8_outs_0.NAND_3in_2.y gd gd sg13_lv_nmos ad=0.1005p pd=1.34u as=0.1005p ps=1.34u w=0.15u l=0.13u
X297 3bit_to_8_outs_0.inverter_1.in 3bit_to_8_outs_0.c0_n a_61898_26145# gd sg13_lv_nmos ad=0.1005p pd=1.34u as=0.1005p ps=1.34u w=0.15u l=0.13u
X298 VCO3_selection_0.inverter_0.out VCO3_selection_0.inverter_0.in vp vp sg13_lv_pmos ad=0.1005p pd=1.34u as=0.1005p ps=1.34u w=0.15u l=0.13u
X299 a_60771_25065# row_section_decoding_0.NAND_3in_0.b a_60555_25065# gd sg13_lv_nmos ad=0.1005p pd=1.34u as=0.1005p ps=1.34u w=0.15u l=0.13u
X300 VCO3_selection_0.NAND_3in_1.y 011 a_68311_23187# gd sg13_lv_nmos ad=0.1005p pd=1.34u as=0.1005p ps=1.34u w=0.15u l=0.13u
X301 vp 001 VCO4_selection_0.NAND_4in_0.b vp sg13_lv_pmos ad=0.1005p pd=1.34u as=0.1005p ps=1.34u w=0.15u l=0.13u
X302 vp VCO4_selection_0.NAND_4in_0.b VCO4_5_sel vp sg13_lv_pmos ad=0.1005p pd=1.34u as=0.1005p ps=1.34u w=0.15u l=0.13u
X303 VCO3_selection_0.NAND_3in_4.y VCO3_selection_0.NAND_3in_3.y vp vp sg13_lv_pmos ad=0.1005p pd=1.34u as=0.1005p ps=1.34u w=0.15u l=0.13u
X304 vp 101 VCO3_selection_0.NAND_2in_3.y vp sg13_lv_pmos ad=0.1005p pd=1.34u as=0.1005p ps=1.34u w=0.15u l=0.13u
X305 vp after_001111_n after_001111 vp sg13_lv_pmos ad=0.1005p pd=1.34u as=0.1005p ps=1.34u w=0.15u l=0.13u
X306 111 3bit_to_8_outs_0.NAND_3in_0.y gd gd sg13_lv_nmos ad=0.1005p pd=1.34u as=0.1005p ps=1.34u w=0.15u l=0.13u
X307 vp 010 VCO4_selection_0.NAND_3in_0.y vp sg13_lv_pmos ad=0.1005p pd=1.34u as=0.1005p ps=1.34u w=0.15u l=0.13u
X308 vp after_000111 VCO2_selection_0.NAND_3in_0.y vp sg13_lv_pmos ad=0.1005p pd=1.34u as=0.1005p ps=1.34u w=0.15u l=0.13u
X309 VCO3_selection_0.NAND_3in_2.y after_000111_n vp vp sg13_lv_pmos ad=0.1005p pd=1.34u as=0.1005p ps=1.34u w=0.15u l=0.13u
X310 3bit_to_8_outs_0.inverter_8.in 3bit_to_8_outs_0.c2_n vp vp sg13_lv_pmos ad=0.1005p pd=1.34u as=0.1005p ps=1.34u w=0.15u l=0.13u
X311 gd 000000_n 000000 gd sg13_lv_nmos ad=0.1005p pd=1.34u as=0.1005p ps=1.34u w=0.15u l=0.13u
X312 a_61682_27789# 3bit_to_8_outs_0.c2_n gd gd sg13_lv_nmos ad=0.1005p pd=1.34u as=0.1005p ps=1.34u w=0.15u l=0.13u
X313 vp 100 VCO2_selection_0.NAND_2in_0.y vp sg13_lv_pmos ad=0.1005p pd=1.34u as=0.1005p ps=1.34u w=0.15u l=0.13u
X314 3bit_to_8_outs_0.inverter_10.in c0 vp vp sg13_lv_pmos ad=0.1005p pd=1.34u as=0.1005p ps=1.34u w=0.15u l=0.13u
X315 row_section_decoding_0.NAND_3in_0.c f0 gd gd sg13_lv_nmos ad=0.1005p pd=1.34u as=0.1005p ps=1.34u w=0.15u l=0.13u
X316 vp f5 f5_n vp sg13_lv_pmos ad=0.1005p pd=1.34u as=0.1005p ps=1.34u w=0.15u l=0.13u
X317 vp after_000011 VCO2_selection_0.NAND_4in_0.d vp sg13_lv_pmos ad=0.1005p pd=1.34u as=0.1005p ps=1.34u w=0.15u l=0.13u
X318 VCO2_11_sel VCO2_selection_0.inverter_0.out a_68830_28179# gd sg13_lv_nmos ad=0.1005p pd=1.34u as=0.1005p ps=1.34u w=0.15u l=0.13u
X319 a_61002_26145# c2 gd gd sg13_lv_nmos ad=0.1005p pd=1.34u as=0.1005p ps=1.34u w=0.15u l=0.13u
X320 a_62042_31904# after_000111 VCO_selection_0.NAND_2in_1.y gd sg13_lv_nmos ad=0.1005p pd=1.34u as=0.1005p ps=1.34u w=0.15u l=0.13u
X321 a_61832_31586# VCO_selection_0.NAND_2in_1.y VCO_sel gd sg13_lv_nmos ad=0.1005p pd=1.34u as=0.1005p ps=1.34u w=0.15u l=0.13u
X322 VCO3_selection_0.NAND_3in_3.y 011 a_67631_25143# gd sg13_lv_nmos ad=0.1005p pd=1.34u as=0.1005p ps=1.34u w=0.15u l=0.13u
X323 gd f5 a_62518_31904# gd sg13_lv_nmos ad=0.1005p pd=1.34u as=0.1005p ps=1.34u w=0.15u l=0.13u
X324 VCO4_selection_0.NAND_2in_0.y 001 vp vp sg13_lv_pmos ad=0.1005p pd=1.34u as=0.1005p ps=1.34u w=0.15u l=0.13u
X325 vp f3 a_62193_22605# vp sg13_lv_pmos ad=0.1005p pd=1.34u as=0.1005p ps=1.34u w=0.15u l=0.13u
X326 vp f2 a_62193_24087# vp sg13_lv_pmos ad=0.1005p pd=1.34u as=0.1005p ps=1.34u w=0.15u l=0.13u
X327 vp VCO3_selection_0.NAND_2in_3.y VCO3_5_sel vp sg13_lv_pmos ad=0.1005p pd=1.34u as=0.1005p ps=1.34u w=0.15u l=0.13u
X328 vp 000000_n VCO4_selection_0.NAND_3in_0.y vp sg13_lv_pmos ad=0.1005p pd=1.34u as=0.1005p ps=1.34u w=0.15u l=0.13u
X329 VCO3_selection_0.NAND_2in_0.y 000 a_68101_21705# gd sg13_lv_nmos ad=0.1005p pd=1.34u as=0.1005p ps=1.34u w=0.15u l=0.13u
X330 a_68101_25617# f5 gd gd sg13_lv_nmos ad=0.1005p pd=1.34u as=0.1005p ps=1.34u w=0.15u l=0.13u
X331 VCO4_selection_0.NAND_3in_1.y after_000011 vp vp sg13_lv_pmos ad=0.1005p pd=1.34u as=0.1005p ps=1.34u w=0.15u l=0.13u
X332 VCO2_selection_0.NAND_3in_2.y after_000111_n vp vp sg13_lv_pmos ad=0.1005p pd=1.34u as=0.1005p ps=1.34u w=0.15u l=0.13u
X333 a_67464_28179# after_000111_n a_67248_28179# gd sg13_lv_nmos ad=0.1005p pd=1.34u as=0.1005p ps=1.34u w=0.15u l=0.13u
X334 3bit_to_8_outs_0.c2_n c2 vp vp sg13_lv_pmos ad=0.1005p pd=1.34u as=0.1005p ps=1.34u w=0.15u l=0.13u
X335 vp 100 VCO3_selection_0.NAND_2in_2.y vp sg13_lv_pmos ad=0.1005p pd=1.34u as=0.1005p ps=1.34u w=0.15u l=0.13u
X336 vp 3bit_to_8_outs_0.c1_n 3bit_to_8_outs_0.inverter_6.in vp sg13_lv_pmos ad=0.1005p pd=1.34u as=0.1005p ps=1.34u w=0.15u l=0.13u
X337 a_61898_26463# 3bit_to_8_outs_0.c1_n a_61682_26463# gd sg13_lv_nmos ad=0.1005p pd=1.34u as=0.1005p ps=1.34u w=0.15u l=0.13u
X338 VCO3_selection_0.inverter_0.out VCO3_selection_0.inverter_0.in gd gd sg13_lv_nmos ad=0.1005p pd=1.34u as=0.1005p ps=1.34u w=0.15u l=0.13u
X339 gd after_001111_n after_001111 gd sg13_lv_nmos ad=0.1005p pd=1.34u as=0.1005p ps=1.34u w=0.15u l=0.13u
X340 vp f4 a_62193_24561# vp sg13_lv_pmos ad=0.1005p pd=1.34u as=0.1005p ps=1.34u w=0.15u l=0.13u
X341 vp f4 a_60981_22605# vp sg13_lv_pmos ad=0.1005p pd=1.34u as=0.1005p ps=1.34u w=0.15u l=0.13u
X342 VCO3_selection_0.NAND_2in_3.y 101 a_68101_23661# gd sg13_lv_nmos ad=0.1005p pd=1.34u as=0.1005p ps=1.34u w=0.15u l=0.13u
X343 VCO2_selection_0.NAND_4in_0.b 101 vp vp sg13_lv_pmos ad=0.1005p pd=1.34u as=0.1005p ps=1.34u w=0.15u l=0.13u
X344 001 3bit_to_8_outs_0.NAND_3in_2.y vp vp sg13_lv_pmos ad=0.1005p pd=1.34u as=0.1005p ps=1.34u w=0.15u l=0.13u
X345 a_67464_28653# after_000111 a_67248_28653# gd sg13_lv_nmos ad=0.1005p pd=1.34u as=0.1005p ps=1.34u w=0.15u l=0.13u
X346 VCO3_selection_0.NAND_3in_4.y VCO3_selection_0.NAND_2in_5.y a_68798_25617# gd sg13_lv_nmos ad=0.1005p pd=1.34u as=0.1005p ps=1.34u w=0.15u l=0.13u
X347 a_68311_23187# after_000111_n a_68095_23187# gd sg13_lv_nmos ad=0.1005p pd=1.34u as=0.1005p ps=1.34u w=0.15u l=0.13u
C0 VCO4_5_sel VCO4_selection_0.NAND_2in_0.y 0.01169f
C1 after_000011_n m2_61360_23912# 0.21677f
C2 101 000000 0.26715f
C3 000 after_001111 0.69753f
C4 VCO3_selection_0.NAND_2in_4.y VCO3_5_sel 0.14925f
C5 110 after_001111 2.70038f
C6 VCO3_selection_0.NAND_2in_2.y after_000011_n 0.01793f
C7 VCO3_selection_0.NAND_3in_2.y after_000111 0.04747f
C8 a_67724_32151# VCO5_selection_0.NAND_2in_0.b 0.06997f
C9 VCO3_selection_0.NAND_3in_1.y VCO3_11_sel 0.81247f
C10 vp a_60981_22605# 0.0977f
C11 VCO4_selection_0.NAND_4in_0.d VCO4_selection_0.NAND_2in_0.y 0.01318f
C12 f2 3bit_to_8_outs_0.c0_n 0.05276f
C13 VCO2_selection_0.NAND_3in_1.y VCO2_selection_0.NAND_3in_1.a 0.6326f
C14 a_68798_25617# VCO3_selection_0.NAND_3in_5.y 0.03328f
C15 a_67415_25617# a_67631_25617# 0.02238f
C16 after_001111_n after_000011 1.07416f
C17 f5_n after_001111 1.71198f
C18 a_67415_23661# a_67631_23661# 0.02238f
C19 VCO_selection_0.NAND_2in_1.y a_61832_31586# 0.01693f
C20 VCO2_selection_0.NAND_4in_0.a vp 0.65992f
C21 m2_68498_21788# after_001111 0.01395f
C22 VCO2_selection_0.NAND_4in_0.d VCO2_selection_0.NAND_4in_0.b 0.14646f
C23 VCO3_selection_0.NAND_3in_0.y VCO3_selection_0.NAND_3in_2.y 0.02971f
C24 VCO_selection_0.NAND_2in_1.y 001 0.02262f
C25 a_62193_22605# f3 0.04464f
C26 101 VCO3_selection_0.NAND_3in_6.y 0.47235f
C27 VCO_selection_0.NAND_2in_0.y m2_61750_31493# 0.01316f
C28 f3 f1 0.68775f
C29 f2 f1 12.2807f
C30 after_000111 011 1.14509f
C31 vp 000000 0.84713f
C32 101 100 16.5356f
C33 000000 c0 0.02692f
C34 3bit_to_8_outs_0.inverter_10.in a_61218_27789# 0.07661f
C35 vp VCO2_selection_0.NAND_4in_1.c 0.4697f
C36 111 VCO2_selection_0.inverter_0.out 0.01749f
C37 f0 row_section_decoding_0.NAND_3in_0.b 0.75575f
C38 VCO4_selection_0.NAND_3in_1.y a_62255_30077# 0.06657f
C39 a_68798_25617# a_68582_25617# 0.02238f
C40 vp VCO3_selection_0.NAND_3in_6.y 0.77829f
C41 VCO2_selection_0.NAND_3in_0.y 011 0.06413f
C42 111 m2_61750_31493# 0.02609f
C43 a_67415_23187# 000000_n 0.01053f
C44 f4 f1 0.22423f
C45 3bit_to_8_outs_0.NAND_3in_0.y 3bit_to_8_outs_0.inverter_6.in 0.17759f
C46 VCO3_selection_0.NAND_3in_4.y VCO3_5_sel 0.01343f
C47 VCO2_5_sel VCO2_selection_0.NAND_4in_0.d 0.11489f
C48 vp 100 2.20251f
C49 3bit_to_8_outs_0.inverter_10.in a_61002_27789# 0.02085f
C50 3bit_to_8_outs_0.c2_n a_61682_27789# 0.01312f
C51 3bit_to_8_outs_0.inverter_1.in a_61682_26145# 0.01087f
C52 f5_n a_67248_30135# 0.01093f
C53 after_000111 f5 1.80682f
C54 m2_62321_26792# m2_62593_26792# 0.01344f
C55 3bit_to_8_outs_0.c2_n 001 0.01135f
C56 VCO3_selection_0.NAND_4in_1.a VCO3_selection_0.NAND_2in_3.y 0.09571f
C57 001 after_000011 0.16938f
C58 VCO3_selection_0.NAND_3in_4.y a_68798_25617# 0.06635f
C59 a_67464_28653# VCO2_selection_0.NAND_3in_0.y 0.0667f
C60 after_000011_n VCO4_selection_0.NAND_4in_0.d 0.04239f
C61 VCO2_selection_0.NAND_3in_1.a 001 0.02414f
C62 000000 after_000111_n 0.46941f
C63 after_000011_n after_000011 0.5153f
C64 f5_n VCO2_selection_0.NAND_4in_0.d 0.43615f
C65 a_61740_30077# after_000011 0.0131f
C66 a_67947_30135# a_68163_30135# 0.02238f
C67 101 VCO3_selection_0.NAND_2in_2.y 0.07097f
C68 111 010 0.12632f
C69 VCO3_selection_0.NAND_2in_4.y 000000 0.39771f
C70 000000_n 000 0.12822f
C71 VCO2_selection_0.NAND_4in_1.c after_000111_n 0.56973f
C72 c2 a_61682_26463# 0.0131f
C73 110 000000_n 0.22267f
C74 3bit_to_8_outs_0.NAND_3in_0.y row_section_decoding_0.NAND_3in_0.a 0.01035f
C75 m2_62173_30160# after_000111_n 0.15536f
C76 a_68899_30609# VCO2_selection_0.NAND_4in_0.d 0.01079f
C77 VCO3_selection_0.NAND_3in_6.y after_000111_n 0.74306f
C78 f2 011 0.06254f
C79 f3 011 0.06226f
C80 000000_n f5_n 0.33624f
C81 m2_62593_27450# 3bit_to_8_outs_0.inverter_10.in 0.17547f
C82 111 f0 0.07465f
C83 row_section_decoding_0.NAND_3in_0.c vp 0.27001f
C84 000000 VCO4_selection_0.NAND_4in_0.b 0.01536f
C85 m2_68980_22034# VCO3_selection_0.inverter_0.in 0.22093f
C86 a_68144_28653# VCO2_selection_0.NAND_3in_2.y 0.06657f
C87 a_61717_24561# f0 0.01114f
C88 after_000111_n 100 0.27837f
C89 VCO_selection_0.NAND_2in_0.y after_001111 0.31615f
C90 VCO3_selection_0.NAND_2in_4.y VCO3_selection_0.NAND_3in_6.y 0.18247f
C91 VCO3_selection_0.inverter_0.in 100 0.03145f
C92 vp VCO3_selection_0.NAND_2in_2.y 0.30607f
C93 a_67631_25143# 000000 0.01066f
C94 VCO3_selection_0.NAND_3in_4.y m2_69195_25782# 0.01152f
C95 a_68565_25143# VCO3_selection_0.NAND_2in_3.y 0.01193f
C96 m2_68702_23094# m2_68702_23012# 0.39957f
C97 after_000111 VCO2_selection_0.NAND_4in_0.b 0.85965f
C98 a_68614_28179# a_68830_28179# 0.02238f
C99 m2_62321_26792# 3bit_to_8_outs_0.NAND_3in_3.y 0.2121f
C100 m2_68822_26780# VCO2_selection_0.NAND_3in_0.y 0.16392f
C101 vp row_section_decoding_0.NAND_2in_0.a 0.29937f
C102 after_000111 a_67248_30609# 0.01506f
C103 f4 011 0.06205f
C104 vp a_61241_24561# 0.09771f
C105 a_61002_26145# a_61218_26145# 0.02238f
C106 vp VCO_selection_0.NAND_2in_1.y 0.43383f
C107 VCO3_selection_0.NAND_2in_0.y 100 0.05271f
C108 f2 f5 0.95122f
C109 f3 f5 0.28189f
C110 VCO2_selection_0.NAND_4in_1.d VCO2_selection_0.NAND_3in_0.y 0.09617f
C111 VCO3_selection_0.NAND_3in_2.y VCO3_selection_0.NAND_2in_3.y 0.19453f
C112 VCO2_selection_0.NAND_3in_1.a VCO3_selection_0.NAND_2in_5.y 0.02327f
C113 VCO3_selection_0.NAND_2in_2.y a_68781_23661# 0.01049f
C114 111 after_001111 0.14621f
C115 VCO3_selection_0.inverter_0.out VCO3_selection_0.NAND_3in_1.y 0.02685f
C116 a_68683_30609# a_68467_30609# 0.02238f
C117 VCO2_selection_0.inverter_0.out VCO2_selection_0.NAND_4in_1.c 0.02632f
C118 m2_62321_27450# 010 0.17579f
C119 VCO4_11_sel m2_60697_30242# 0.17624f
C120 101 after_000011 1.60982f
C121 m2_62321_28436# 3bit_to_8_outs_0.NAND_3in_2.y 0.2121f
C122 c2 3bit_to_8_outs_0.c2_n 0.739f
C123 a_61717_23583# row_section_decoding_0.NAND_2in_0.b 0.03777f
C124 VCO3_selection_0.NAND_2in_2.y VCO3_selection_0.inverter_0.in 0.01414f
C125 row_section_decoding_0.NAND_2in_0.b row_section_decoding_0.NAND_2in_0.a 0.78429f
C126 3bit_to_8_outs_0.inverter_8.in a_61682_28107# 0.01403f
C127 after_000111 000 0.18398f
C128 110 after_000111 0.23714f
C129 vp VCO3_11_sel 0.39313f
C130 f4 f5 17.2003f
C131 vp VCO4_5_sel 0.41967f
C132 vp VCO2_11_sel 0.41316f
C133 m2_67169_31976# 000000 0.40008f
C134 3bit_to_8_outs_0.NAND_3in_6.y 3bit_to_8_outs_0.c2_n 0.52425f
C135 row_section_decoding_0.NAND_2in_0.a after_000111_n 0.02971f
C136 VCO2_selection_0.NAND_4in_0.a VCO5_selection_0.NAND_2in_0.a 0.02061f
C137 3bit_to_8_outs_0.NAND_3in_3.y 3bit_to_8_outs_0.c1_n 0.59597f
C138 row_section_decoding_0.NAND_3in_0.b 000000_n 0.66125f
C139 after_000111 f5_n 1.09378f
C140 VCO2_selection_0.NAND_3in_1.b VCO2_selection_0.NAND_3in_0.y 0.21153f
C141 000000 010 0.75991f
C142 vp 3bit_to_8_outs_0.c2_n 0.52501f
C143 VCO4_5_sel c0 0.03883f
C144 3bit_to_8_outs_0.inverter_8.in 3bit_to_8_outs_0.c0_n 0.48759f
C145 VCO3_selection_0.NAND_3in_0.y 000 0.48488f
C146 vp VCO4_selection_0.NAND_4in_0.d 0.30097f
C147 vp after_000011 1.33191f
C148 VCO3_selection_0.NAND_2in_4.y m2_68022_24968# 0.26013f
C149 000000 VCO5_selection_0.NAND_2in_0.a 0.72253f
C150 vp VCO2_selection_0.NAND_3in_1.a 0.45697f
C151 m2_61360_23748# after_000011_n 0.17612f
C152 c0 VCO4_selection_0.NAND_4in_0.d 0.01734f
C153 VCO2_selection_0.NAND_3in_1.a a_67248_26697# 0.06997f
C154 c0 3bit_to_8_outs_0.c2_n 1.04353f
C155 000000 f0 0.05236f
C156 c0 after_000011 0.0207f
C157 VCO3_selection_0.NAND_3in_0.y f5_n 0.54119f
C158 f2 3bit_to_8_outs_0.NAND_3in_0.y 0.01908f
C159 a_68163_30135# VCO2_selection_0.NAND_4in_0.b 0.06561f
C160 a_68614_28179# VCO2_selection_0.NAND_4in_1.c 0.01188f
C161 VCO_selection_0.NAND_2in_0.y VCO_sel 0.61615f
C162 VCO3_selection_0.NAND_3in_0.y m2_68498_21788# 0.41185f
C163 VCO2_selection_0.NAND_3in_2.y after_000011_n 0.0157f
C164 VCO2_selection_0.NAND_3in_0.y f5_n 0.68875f
C165 c1 c2 9.42586f
C166 111 VCO2_selection_0.NAND_4in_0.d 0.35757f
C167 VCO2_selection_0.NAND_2in_0.y a_68683_30609# 0.01188f
C168 010 100 0.29037f
C169 VCO4_selection_0.NAND_2in_0.y 001 0.42444f
C170 row_section_decoding_0.NAND_2in_0.b after_000011 1.09284f
C171 row_section_decoding_0.NAND_3in_0.b row_section_decoding_0.NAND_3in_0.a 0.94364f
C172 after_001111_n 001 0.19407f
C173 after_000011_n VCO4_selection_0.NAND_2in_0.y 0.42215f
C174 VCO3_selection_0.NAND_3in_5.y a_67631_25617# 0.06651f
C175 f0 100 0.03304f
C176 c1 3bit_to_8_outs_0.NAND_3in_6.y 0.59599f
C177 after_001111_n after_000011_n 0.43348f
C178 3bit_to_8_outs_0.inverter_6.in a_61898_26463# 0.01203f
C179 vp a_61977_22605# 0.07613f
C180 after_000111_n VCO4_selection_0.NAND_4in_0.d 0.01011f
C181 after_000111_n after_000011 22.808f
C182 vp c1 0.46023f
C183 111 000000_n 12.3087f
C184 101 VCO_selection_0.NAND_2in_2.y 0.32288f
C185 f2 000 0.04806f
C186 f3 000 0.04771f
C187 f3 110 0.06232f
C188 000000 after_001111 0.33174f
C189 f2 110 0.07776f
C190 f1 011 0.06304f
C191 c1 c0 11.4454f
C192 VCO4_5_sel VCO4_selection_0.NAND_4in_0.b 0.95963f
C193 3bit_to_8_outs_0.c0_n 3bit_to_8_outs_0.c1_n 6.37934f
C194 VCO3_selection_0.NAND_3in_5.y VCO2_selection_0.NAND_3in_1.a 0.0109f
C195 a_61682_27789# a_61898_27789# 0.02238f
C196 f3 f5_n 0.02591f
C197 f2 f5_n 0.02419f
C198 m2_68980_21788# VCO3_selection_0.inverter_0.out 0.09002f
C199 VCO3_selection_0.NAND_3in_0.y m2_68980_21870# 0.01311f
C200 a_68163_30135# f5_n 0.01187f
C201 VCO4_selection_0.NAND_4in_0.b VCO4_selection_0.NAND_4in_0.d 0.05578f
C202 m2_61088_23748# m2_61360_23748# 0.01344f
C203 m2_60697_30406# VCO4_selection_0.NAND_2in_0.y 0.22093f
C204 m2_62593_25806# m2_62321_25806# 0.01344f
C205 VCO2_selection_0.NAND_2in_0.y a_68467_30609# 0.01193f
C206 after_000111 a_62042_31904# 0.01521f
C207 a_67464_30135# a_67248_30135# 0.02238f
C208 VCO4_selection_0.NAND_4in_0.b after_000011 0.53524f
C209 VCO4_selection_0.NAND_3in_1.y 011 0.02899f
C210 m2_61750_31493# VCO_selection_0.NAND_2in_1.y 0.04997f
C211 m2_62436_31411# after_001111 0.0111f
C212 f5 a_67464_30609# 0.01096f
C213 row_section_decoding_0.NAND_3in_0.c f0 0.51475f
C214 vp VCO_selection_0.NAND_2in_2.y 0.4004f
C215 a_67464_30135# VCO2_selection_0.NAND_4in_0.d 0.06661f
C216 after_001111 100 1.31465f
C217 a_61977_22605# after_000111_n 0.0659f
C218 f4 000 0.0475f
C219 after_001111_n VCO3_selection_0.NAND_3in_3.y 0.5232f
C220 000000 a_68781_23187# 0.01098f
C221 110 f4 0.0626f
C222 VCO2_11_sel VCO2_selection_0.inverter_0.out 0.58208f
C223 f1 f5 0.16872f
C224 101 VCO3_selection_0.inverter_0.out 0.01676f
C225 f2 3bit_to_8_outs_0.inverter_1.in 0.03917f
C226 after_000011_n 001 1.18811f
C227 101 VCO2_selection_0.NAND_3in_2.y 0.47562f
C228 f4 f5_n 0.05013f
C229 VCO3_selection_0.NAND_3in_2.y 011 0.39777f
C230 a_67248_28653# after_000111_n 0.01174f
C231 VCO2_selection_0.NAND_4in_0.a VCO2_selection_0.NAND_4in_0.d 0.18241f
C232 after_001111_n m2_61088_23748# 0.1764f
C233 3bit_to_8_outs_0.inverter_8.in 3bit_to_8_outs_0.c1_n 0.70113f
C234 VCO5_selection_0.NAND_2in_0.a m2_68121_32058# 0.41182f
C235 VCO3_selection_0.NAND_2in_4.y a_68781_25143# 0.01276f
C236 vp VCO5_11_sel 0.22193f
C237 a_68095_23187# 000000_n 0.04194f
C238 after_001111_n 101 0.10378f
C239 a_61218_28107# 3bit_to_8_outs_0.c0_n 0.01039f
C240 3bit_to_8_outs_0.NAND_3in_0.y m2_62593_25806# 0.17547f
C241 vp VCO3_selection_0.inverter_0.out 0.40984f
C242 111 after_000111 3.86709f
C243 3bit_to_8_outs_0.c2_n 3bit_to_8_outs_0.NAND_3in_2.y 0.52425f
C244 000000 VCO4_selection_0.NAND_3in_0.y 0.71559f
C245 vp VCO2_selection_0.NAND_3in_2.y 0.47176f
C246 3bit_to_8_outs_0.NAND_3in_2.y VCO4_selection_0.NAND_4in_0.d 0.01591f
C247 vp a_62193_24561# 0.09771f
C248 3bit_to_8_outs_0.NAND_3in_0.y 3bit_to_8_outs_0.c0_n 0.45465f
C249 000000 000000_n 4.04431f
C250 VCO2_selection_0.NAND_3in_1.y vp 0.59955f
C251 f2 row_section_decoding_0.NAND_3in_0.b 0.30781f
C252 a_67248_30609# a_67464_30609# 0.02238f
C253 f3 row_section_decoding_0.NAND_3in_0.b 0.03622f
C254 VCO3_selection_0.NAND_3in_3.y 001 0.0663f
C255 vp VCO4_selection_0.NAND_2in_0.y 0.30968f
C256 VCO3_selection_0.NAND_2in_2.y a_68565_23661# 0.04379f
C257 m2_61360_23748# row_section_decoding_0.NAND_2in_0.b 0.16634f
C258 VCO2_selection_0.NAND_4in_0.d 100 0.0479f
C259 010 3bit_to_8_outs_0.c2_n 0.01131f
C260 010 after_000011 1.08812f
C261 a_68209_26697# VCO2_selection_0.NAND_3in_1.b 0.01024f
C262 after_001111_n vp 0.69947f
C263 a_68200_32151# VCO5_selection_0.NAND_2in_0.b 0.01075f
C264 000000_n VCO2_selection_0.NAND_4in_1.c 0.53772f
C265 3bit_to_8_outs_0.inverter_1.in 3bit_to_8_outs_0.NAND_3in_3.y 0.05633f
C266 010 VCO2_selection_0.NAND_3in_1.a 0.31677f
C267 f0 m2_62111_24890# 0.40021f
C268 vp VCO3_selection_0.NAND_3in_1.y 0.48683f
C269 VCO3_selection_0.NAND_2in_5.y 001 0.39386f
C270 after_001111_n c0 0.01978f
C271 a_68144_28653# after_000111_n 0.01189f
C272 VCO_selection_0.NAND_2in_1.y after_001111 0.01595f
C273 VCO3_selection_0.NAND_3in_6.y 000000_n 0.56826f
C274 f0 after_000011 0.04857f
C275 f5 011 0.58479f
C276 a_62255_29603# a_62471_29603# 0.02238f
C277 VCO3_selection_0.NAND_2in_2.y a_68781_23187# 0.07003f
C278 000000_n 100 7.10382f
C279 3bit_to_8_outs_0.NAND_3in_6.y a_61898_27789# 0.06651f
C280 3bit_to_8_outs_0.inverter_8.in a_61218_28107# 0.07661f
C281 VCO2_selection_0.NAND_3in_2.y after_000111_n 0.61302f
C282 VCO3_selection_0.inverter_0.out VCO3_selection_0.inverter_0.in 0.39502f
C283 row_section_decoding_0.NAND_3in_0.b f4 0.13008f
C284 VCO3_selection_0.NAND_4in_1.a 110 0.01679f
C285 101 001 0.13489f
C286 m2_62436_31493# m2_61750_31493# 0.01451f
C287 a_67415_23661# after_000111_n 0.01515f
C288 3bit_to_8_outs_0.inverter_6.in 100 0.38549f
C289 101 after_000011_n 0.68411f
C290 after_001111_n row_section_decoding_0.NAND_2in_0.b 0.18446f
C291 VCO3_selection_0.NAND_3in_1.y a_68781_23661# 0.01291f
C292 a_60555_25065# 000000_n 0.06697f
C293 3bit_to_8_outs_0.inverter_8.in a_61002_28107# 0.02085f
C294 f1 000 0.04868f
C295 3bit_to_8_outs_0.NAND_3in_6.y a_61682_27789# 0.01087f
C296 110 f1 0.0607f
C297 a_68398_28179# a_68614_28179# 0.02238f
C298 VCO3_selection_0.inverter_0.in a_68577_21705# 0.06997f
C299 after_001111_n after_000111_n 19.6219f
C300 111 f2 0.08572f
C301 111 f3 0.06078f
C302 VCO3_selection_0.NAND_3in_1.y after_000111_n 0.7483f
C303 f1 f5_n 0.02295f
C304 m2_61750_31493# VCO_selection_0.NAND_2in_2.y 0.67854f
C305 vp 001 1.80149f
C306 a_61002_26145# c2 0.0131f
C307 VCO3_selection_0.NAND_3in_3.y VCO3_selection_0.NAND_2in_5.y 0.27169f
C308 after_001111 after_000011 18.2475f
C309 VCO2_selection_0.NAND_4in_0.a after_000111 0.84593f
C310 a_68997_25143# VCO3_5_sel 0.07413f
C311 row_section_decoding_0.NAND_3in_0.c 000000_n 0.52423f
C312 VCO4_selection_0.NAND_3in_1.y 000 0.36958f
C313 vp after_000011_n 0.94832f
C314 VCO2_selection_0.NAND_3in_1.a after_001111 1.03384f
C315 VCO4_selection_0.NAND_4in_0.b VCO4_selection_0.NAND_2in_0.y 0.53535f
C316 a_67248_28179# 000000_n 0.0131f
C317 a_61682_28107# a_61898_28107# 0.02238f
C318 000000 after_000111 21.4022f
C319 VCO3_selection_0.NAND_2in_0.y a_68577_21705# 0.01253f
C320 3bit_to_8_outs_0.c0_n 3bit_to_8_outs_0.inverter_1.in 0.54004f
C321 c0 after_000011_n 0.03282f
C322 3bit_to_8_outs_0.inverter_8.in 000 0.56379f
C323 vp VCO2_selection_0.NAND_2in_0.y 0.3016f
C324 VCO3_selection_0.NAND_3in_5.y a_67415_25617# 0.01087f
C325 vp a_61457_22605# 0.09777f
C326 111 f4 0.06077f
C327 after_000011_n a_62255_29603# 0.01543f
C328 VCO2_selection_0.inverter_0.out VCO2_selection_0.NAND_3in_2.y 1.08719f
C329 3bit_to_8_outs_0.inverter_6.in a_61682_26463# 0.01403f
C330 VCO3_selection_0.NAND_2in_0.y VCO3_selection_0.NAND_3in_1.y 0.01502f
C331 a_61898_26463# 3bit_to_8_outs_0.NAND_3in_3.y 0.06651f
C332 VCO3_selection_0.NAND_3in_6.y after_000111 0.06986f
C333 VCO3_selection_0.NAND_3in_5.y m2_69195_25700# 0.01387f
C334 VCO2_selection_0.NAND_3in_1.y VCO2_selection_0.inverter_0.out 0.46977f
C335 row_section_decoding_0.NAND_2in_0.b after_000011_n 0.21363f
C336 VCO_selection_0.NAND_2in_1.y VCO_sel 0.61001f
C337 after_000111 100 6.21183f
C338 VCO2_selection_0.NAND_3in_1.b 011 0.35023f
C339 after_000111_n 001 0.88598f
C340 row_section_decoding_0.NAND_3in_0.c row_section_decoding_0.NAND_3in_0.a 0.42072f
C341 VCO2_selection_0.NAND_3in_1.y VCO3_selection_0.NAND_3in_4.y 0.02124f
C342 a_67947_30135# f5_n 0.04193f
C343 after_000011_n after_000111_n 5.60495f
C344 vp VCO3_selection_0.NAND_3in_3.y 0.45714f
C345 a_68311_23187# a_68095_23187# 0.02238f
C346 VCO3_selection_0.NAND_3in_0.y a_67631_21705# 0.06651f
C347 a_61740_30077# after_000111_n 0.01609f
C348 VCO2_selection_0.NAND_3in_0.y VCO2_selection_0.NAND_4in_1.c 0.0402f
C349 f5 VCO2_selection_0.NAND_4in_0.b 0.01361f
C350 VCO3_selection_0.NAND_3in_5.y 001 0.4262f
C351 VCO2_selection_0.NAND_2in_0.y a_67934_30609# 0.06997f
C352 m2_60697_30160# VCO4_selection_0.NAND_2in_0.y 0.0104f
C353 011 000 0.30484f
C354 101 c2 0.01131f
C355 row_section_decoding_0.NAND_2in_0.b a_61457_22605# 0.07281f
C356 VCO3_selection_0.NAND_2in_3.y VCO3_5_sel 1.01338f
C357 row_section_decoding_0.NAND_3in_0.b 3bit_to_8_outs_0.c0_n 0.0563f
C358 f5 a_67248_30609# 0.01247f
C359 VCO4_5_sel VCO4_selection_0.NAND_3in_0.y 0.79561f
C360 110 011 0.84238f
C361 vp VCO3_selection_0.NAND_2in_5.y 0.41094f
C362 VCO2_selection_0.NAND_4in_0.d after_000011 0.76252f
C363 VCO5_selection_0.NAND_2in_0.a VCO5_11_sel 0.58931f
C364 VCO4_selection_0.NAND_4in_0.b 001 0.54158f
C365 f5_n 011 4.88778f
C366 m2_62593_27450# 011 0.17552f
C367 VCO2_selection_0.NAND_3in_0.y 100 0.38242f
C368 VCO4_selection_0.NAND_4in_0.d VCO4_selection_0.NAND_3in_0.y 1.49699f
C369 row_section_decoding_0.NAND_3in_0.b f1 0.23387f
C370 3bit_to_8_outs_0.inverter_8.in a_61898_28107# 0.01203f
C371 VCO2_selection_0.NAND_3in_2.y a_68614_28179# 0.01274f
C372 after_000011_n VCO4_selection_0.NAND_4in_0.b 0.64626f
C373 a_61241_24561# row_section_decoding_0.NAND_3in_0.a 0.06952f
C374 vp 101 2.85805f
C375 f2 000000 0.04357f
C376 3bit_to_8_outs_0.inverter_10.in 3bit_to_8_outs_0.c2_n 2.06995f
C377 000000 f3 0.04403f
C378 VCO_selection_0.NAND_2in_2.y after_001111 0.06963f
C379 row_section_decoding_0.NAND_2in_0.a m2_62111_23748# 0.26371f
C380 000000_n after_000011 0.28556f
C381 vp c2 0.4296f
C382 a_61524_30077# a_61740_30077# 0.02238f
C383 VCO3_selection_0.NAND_3in_4.y m2_69195_25700# 0.0105f
C384 after_001111_n 010 0.10828f
C385 a_60981_22605# f4 0.04379f
C386 a_61321_29603# VCO4_selection_0.NAND_3in_0.y 0.01193f
C387 3bit_to_8_outs_0.inverter_6.in 3bit_to_8_outs_0.c2_n 0.07444f
C388 f5 000 0.39453f
C389 111 m2_62593_25806# 0.17552f
C390 c0 c2 0.49422f
C391 110 f5 0.27602f
C392 m2_68980_21788# VCO3_selection_0.inverter_0.in 0.0104f
C393 a_67631_23187# 000000_n 0.01028f
C394 after_001111_n f0 0.06436f
C395 vp 3bit_to_8_outs_0.NAND_3in_6.y 0.50587f
C396 a_61218_28107# a_61002_28107# 0.02238f
C397 VCO3_selection_0.NAND_2in_4.y VCO3_selection_0.NAND_3in_3.y 0.13243f
C398 VCO3_selection_0.NAND_3in_3.y VCO3_selection_0.NAND_3in_5.y 1.29921f
C399 f5 f5_n 13.3563f
C400 m2_62593_26792# 100 0.17552f
C401 110 m2_62321_25806# 0.17579f
C402 VCO_selection_0.NAND_2in_0.y VCO4_selection_0.NAND_3in_1.y 0.0131f
C403 f3 100 0.03024f
C404 f2 100 0.03047f
C405 000000 f4 0.04408f
C406 VCO3_selection_0.NAND_4in_1.a VCO3_5_sel 0.65824f
C407 VCO_selection_0.NAND_2in_1.y after_000111 0.58851f
C408 VCO3_selection_0.NAND_3in_5.y VCO3_selection_0.NAND_2in_5.y 1.33651f
C409 VCO3_selection_0.NAND_2in_4.y VCO3_selection_0.NAND_2in_5.y 0.0193f
C410 vp c0 1.62793f
C411 VCO2_selection_0.NAND_3in_1.b VCO2_selection_0.NAND_4in_1.d 0.01286f
C412 m2_60697_30160# after_000011_n 0.01321f
C413 a_68101_23661# VCO3_selection_0.NAND_2in_3.y 0.0695f
C414 101 after_000111_n 0.19141f
C415 a_61002_27789# a_61218_27789# 0.02238f
C416 3bit_to_8_outs_0.NAND_3in_2.y 001 0.41505f
C417 111 f1 0.06553f
C418 after_001111 a_67724_26697# 0.04021f
C419 c1 3bit_to_8_outs_0.inverter_10.in 0.70106f
C420 c1 000000_n 0.0161f
C421 VCO3_selection_0.NAND_3in_3.y a_67631_25143# 0.06661f
C422 a_61717_24561# f1 0.04969f
C423 000000 a_67724_32151# 0.04021f
C424 VCO3_selection_0.NAND_3in_3.y a_68582_25617# 0.01917f
C425 vp row_section_decoding_0.NAND_2in_0.b 0.26693f
C426 000000 VCO5_selection_0.NAND_2in_0.b 0.3934f
C427 m2_67169_31976# after_000011_n 0.0624f
C428 000000 a_61785_29603# 0.04021f
C429 010 001 13.0866f
C430 f4 100 0.03009f
C431 after_001111_n after_001111 0.86256f
C432 VCO2_5_sel VCO2_selection_0.NAND_4in_0.b 0.92006f
C433 row_section_decoding_0.NAND_3in_0.c f2 0.33681f
C434 row_section_decoding_0.NAND_3in_0.c f3 0.23766f
C435 010 after_000011_n 3.5541f
C436 m2_62321_25806# 3bit_to_8_outs_0.inverter_1.in 0.2121f
C437 vp after_000111_n 1.18129f
C438 VCO5_selection_0.NAND_2in_0.a after_000011_n 0.28767f
C439 3bit_to_8_outs_0.NAND_3in_0.y 110 0.65524f
C440 vp VCO3_selection_0.inverter_0.in 0.34118f
C441 f0 001 0.06272f
C442 a_68425_26697# VCO2_selection_0.NAND_3in_1.a 0.0444f
C443 VCO3_selection_0.NAND_3in_4.y VCO3_selection_0.NAND_3in_3.y 0.54634f
C444 after_000111 after_000011 0.4145f
C445 VCO3_selection_0.NAND_3in_6.y VCO3_selection_0.NAND_2in_3.y 0.74977f
C446 f5_n VCO2_selection_0.NAND_4in_0.b 0.60603f
C447 f0 after_000011_n 0.04807f
C448 VCO3_selection_0.NAND_3in_1.y a_68565_23661# 0.01643f
C449 c0 after_000111_n 0.02071f
C450 vp VCO3_selection_0.NAND_3in_5.y 0.44986f
C451 VCO3_selection_0.NAND_2in_4.y vp 0.25809f
C452 VCO_selection_0.NAND_2in_2.y VCO_sel 0.5235f
C453 VCO3_selection_0.NAND_4in_1.a m2_69195_25782# 0.17628f
C454 VCO5_selection_0.NAND_2in_0.b 100 0.01755f
C455 VCO3_selection_0.NAND_3in_4.y VCO3_selection_0.NAND_2in_5.y 0.53984f
C456 f2 row_section_decoding_0.NAND_2in_0.a 0.16499f
C457 f3 row_section_decoding_0.NAND_2in_0.a 0.6426f
C458 a_68683_30609# VCO2_selection_0.NAND_4in_0.d 0.01168f
C459 VCO2_11_sel VCO2_selection_0.NAND_3in_0.y 0.232f
C460 vp VCO4_selection_0.NAND_4in_0.b 0.53072f
C461 vp VCO3_selection_0.NAND_2in_0.y 0.339f
C462 f2 a_61241_24561# 0.04446f
C463 a_61241_24561# f3 0.02293f
C464 row_section_decoding_0.NAND_3in_0.b f5 0.33584f
C465 a_62193_24087# row_section_decoding_0.NAND_2in_0.a 0.07247f
C466 row_section_decoding_0.NAND_2in_0.b after_000111_n 0.43753f
C467 a_60771_25065# 000000_n 0.01064f
C468 VCO2_selection_0.NAND_3in_0.y after_000011 0.03396f
C469 VCO2_selection_0.NAND_4in_0.a a_67464_30609# 0.06473f
C470 VCO2_selection_0.NAND_3in_1.a VCO2_selection_0.NAND_3in_0.y 0.73656f
C471 after_001111_n a_62471_30077# 0.0131f
C472 110 000 0.12368f
C473 111 011 0.26013f
C474 3bit_to_8_outs_0.NAND_3in_0.y 3bit_to_8_outs_0.inverter_1.in 0.36477f
C475 m2_68702_23012# 000000_n 0.01451f
C476 001 after_001111 0.37584f
C477 f5_n 000 0.49667f
C478 110 f5_n 0.15814f
C479 after_000011_n after_001111 0.65604f
C480 VCO_selection_0.NAND_2in_2.y a_62518_31904# 0.07006f
C481 vp VCO2_selection_0.inverter_0.out 0.54882f
C482 m2_60775_23748# m2_61088_23748# 0.01006f
C483 a_61682_26463# 3bit_to_8_outs_0.NAND_3in_3.y 0.01087f
C484 000000 f1 0.04354f
C485 VCO3_selection_0.NAND_2in_0.y a_68101_21705# 0.06997f
C486 VCO2_5_sel a_68899_30609# 0.07413f
C487 m2_68702_23094# 000000_n 0.0146f
C488 VCO3_selection_0.NAND_4in_1.a VCO3_selection_0.NAND_3in_6.y 1.02816f
C489 vp VCO3_selection_0.NAND_3in_4.y 0.51239f
C490 VCO3_selection_0.NAND_2in_4.y VCO3_selection_0.NAND_3in_5.y 0.02455f
C491 a_68467_30609# VCO2_selection_0.NAND_4in_0.d 0.04918f
C492 VCO4_selection_0.NAND_4in_0.b after_000111_n 0.76706f
C493 101 010 0.25699f
C494 3bit_to_8_outs_0.NAND_3in_6.y 3bit_to_8_outs_0.NAND_3in_2.y 0.05633f
C495 VCO3_selection_0.NAND_2in_0.y VCO3_selection_0.inverter_0.in 0.5084f
C496 a_62471_29603# 000000_n 0.0131f
C497 f2 after_000011 0.04206f
C498 f3 after_000011 0.13493f
C499 after_001111_n 000000_n 0.19109f
C500 000000 VCO4_selection_0.NAND_3in_1.y 0.03155f
C501 111 f5 5.35283f
C502 VCO3_selection_0.NAND_3in_0.y a_67415_21705# 0.01087f
C503 VCO3_selection_0.NAND_2in_3.y m2_68022_24968# 0.01532f
C504 vp 3bit_to_8_outs_0.NAND_3in_2.y 0.54746f
C505 a_61524_30077# after_000111_n 0.02091f
C506 VCO3_selection_0.NAND_3in_1.y 000000_n 0.61074f
C507 110 3bit_to_8_outs_0.inverter_1.in 0.41505f
C508 101 f0 0.05181f
C509 VCO_selection_0.NAND_2in_2.y after_000111 0.54593f
C510 m2_60697_30242# VCO4_selection_0.NAND_2in_0.y 0.01142f
C511 c0 3bit_to_8_outs_0.NAND_3in_2.y 0.54002f
C512 f1 100 0.03085f
C513 3bit_to_8_outs_0.NAND_3in_6.y 010 0.41508f
C514 VCO5_selection_0.NAND_2in_0.b m2_68121_32058# 0.01484f
C515 a_67248_28653# VCO2_selection_0.NAND_3in_0.y 0.01091f
C516 m2_62173_30160# VCO4_selection_0.NAND_3in_1.y 0.11396f
C517 vp 010 1.49294f
C518 a_68582_25617# VCO3_selection_0.NAND_3in_5.y 0.04871f
C519 m2_62111_24890# f4 0.01313f
C520 a_61105_29603# VCO4_selection_0.NAND_4in_0.d 0.01157f
C521 3bit_to_8_outs_0.inverter_10.in a_61898_27789# 0.01203f
C522 vp VCO5_selection_0.NAND_2in_0.a 0.33879f
C523 a_61524_30077# VCO4_selection_0.NAND_4in_0.b 0.06565f
C524 f4 after_000011 0.09f
C525 000000 VCO3_selection_0.NAND_3in_2.y 0.35479f
C526 a_60889_29603# VCO4_5_sel 0.07413f
C527 vp f0 5.40801f
C528 a_67934_28179# VCO2_selection_0.NAND_4in_1.d 0.07028f
C529 row_section_decoding_0.NAND_2in_0.a m2_61635_23748# 0.01265f
C530 m2_61088_23748# after_001111 0.1789f
C531 VCO3_selection_0.NAND_2in_3.y VCO3_11_sel 0.08271f
C532 111 VCO2_selection_0.NAND_4in_1.d 0.41901f
C533 a_61105_29603# a_61321_29603# 0.02238f
C534 VCO3_selection_0.NAND_2in_4.y VCO3_selection_0.NAND_3in_4.y 0.01493f
C535 VCO3_selection_0.NAND_3in_4.y VCO3_selection_0.NAND_3in_5.y 0.70104f
C536 a_60889_29603# VCO4_selection_0.NAND_4in_0.d 0.01073f
C537 3bit_to_8_outs_0.inverter_10.in a_61682_27789# 0.01403f
C538 after_000011_n VCO4_selection_0.NAND_3in_0.y 0.78721f
C539 a_61832_31586# VCO_sel 0.06545f
C540 VCO2_selection_0.NAND_2in_0.y VCO2_selection_0.NAND_4in_0.d 1.05275f
C541 101 after_001111 0.1297f
C542 000000_n 001 0.12098f
C543 row_section_decoding_0.NAND_3in_0.c f1 0.1273f
C544 VCO3_selection_0.NAND_3in_2.y VCO3_selection_0.NAND_3in_6.y 0.32823f
C545 001 VCO_sel 0.02312f
C546 000000 011 0.85034f
C547 after_000011_n 000000_n 24.7463f
C548 a_61785_29603# VCO4_selection_0.NAND_4in_0.d 0.07028f
C549 VCO2_selection_0.NAND_3in_1.y a_68425_26697# 0.06627f
C550 111 3bit_to_8_outs_0.NAND_3in_0.y 0.38549f
C551 a_68997_25143# a_68781_25143# 0.02238f
C552 m2_60775_23748# after_000111_n 0.01439f
C553 VCO_selection_0.NAND_2in_0.y 110 0.29972f
C554 a_68144_28653# VCO2_selection_0.NAND_3in_0.y 0.0116f
C555 010 after_000111_n 0.15003f
C556 a_60981_22605# f5 0.0109f
C557 a_61977_22605# f4 0.01136f
C558 c2 a_61682_26145# 0.0131f
C559 a_67464_28179# VCO2_selection_0.NAND_4in_1.c 0.06651f
C560 after_001111_n after_000111 1.44676f
C561 VCO2_selection_0.NAND_4in_1.d a_68830_28179# 0.01073f
C562 VCO3_selection_0.NAND_3in_5.y 010 0.37816f
C563 f0 after_000111_n 0.06438f
C564 vp after_001111 0.68996f
C565 VCO2_selection_0.NAND_3in_2.y VCO2_selection_0.NAND_3in_0.y 0.62653f
C566 after_001111 a_67248_26697# 0.01182f
C567 VCO2_selection_0.NAND_4in_0.a f5 0.71896f
C568 111 VCO2_selection_0.NAND_3in_1.b 0.02046f
C569 VCO3_selection_0.NAND_3in_0.y a_68577_21705# 0.01292f
C570 011 100 13.8412f
C571 c0 after_001111 0.02231f
C572 after_000011 m2_61635_23748# 0.26015f
C573 000000 f5 0.81081f
C574 VCO2_selection_0.NAND_3in_1.y VCO2_selection_0.NAND_3in_0.y 0.67454f
C575 111 000 0.08449f
C576 a_61682_28107# 3bit_to_8_outs_0.c2_n 0.01312f
C577 111 110 21.074f
C578 a_68101_25617# VCO3_selection_0.NAND_2in_5.y 0.06997f
C579 111 f5_n 0.23751f
C580 a_68209_26697# VCO2_selection_0.NAND_3in_1.a 0.01022f
C581 a_68101_21705# after_001111 0.04021f
C582 101 VCO2_selection_0.NAND_4in_0.d 0.40436f
C583 a_68565_23661# a_68781_23661# 0.02238f
C584 3bit_to_8_outs_0.c2_n 3bit_to_8_outs_0.c0_n 1.80627f
C585 a_68781_25143# VCO3_selection_0.NAND_2in_3.y 0.01427f
C586 VCO3_selection_0.NAND_3in_2.y VCO3_selection_0.NAND_2in_2.y 0.28438f
C587 after_000111_n after_001111 0.55982f
C588 f5 100 0.72465f
C589 a_61682_26145# a_61898_26145# 0.02238f
C590 after_000111 001 1.50961f
C591 a_61002_26463# c2 0.0131f
C592 f1 after_000011 0.03943f
C593 a_67248_28179# a_67464_28179# 0.02238f
C594 101 000000_n 0.16395f
C595 after_000111 after_000011_n 0.81784f
C596 VCO2_selection_0.NAND_4in_0.a VCO2_selection_0.NAND_4in_0.b 1.06117f
C597 VCO4_5_sel VCO4_selection_0.NAND_3in_1.y 0.57522f
C598 vp VCO2_selection_0.NAND_4in_0.d 0.44089f
C599 VCO3_selection_0.NAND_3in_1.y a_68311_23187# 0.06661f
C600 after_001111_n f2 0.05194f
C601 after_001111_n f3 0.05653f
C602 a_68101_25143# 000000 0.0403f
C603 101 3bit_to_8_outs_0.inverter_6.in 0.65524f
C604 VCO3_selection_0.NAND_3in_0.y 001 0.36736f
C605 a_68144_28653# a_67928_28653# 0.02238f
C606 VCO2_selection_0.NAND_4in_1.d VCO2_selection_0.NAND_4in_1.c 1.50192f
C607 VCO2_selection_0.NAND_2in_0.y after_000111 0.29059f
C608 VCO4_selection_0.NAND_3in_1.y VCO4_selection_0.NAND_4in_0.d 0.5617f
C609 c2 3bit_to_8_outs_0.inverter_6.in 2.06986f
C610 vp VCO4_selection_0.NAND_3in_0.y 0.50548f
C611 VCO4_selection_0.NAND_3in_1.y after_000011 1.48307f
C612 VCO3_selection_0.NAND_2in_0.y after_001111 0.42305f
C613 3bit_to_8_outs_0.inverter_10.in 3bit_to_8_outs_0.NAND_3in_6.y 0.36477f
C614 3bit_to_8_outs_0.inverter_8.in VCO4_5_sel 0.01228f
C615 000000 a_67415_23187# 0.01018f
C616 a_67415_25143# 000000 0.01109f
C617 vp 3bit_to_8_outs_0.inverter_10.in 0.48467f
C618 a_67928_28653# VCO2_selection_0.NAND_3in_2.y 0.01086f
C619 vp 000000_n 1.40314f
C620 a_62193_24561# f4 0.04548f
C621 after_000011_n VCO2_selection_0.NAND_3in_0.y 0.03218f
C622 3bit_to_8_outs_0.inverter_8.in 3bit_to_8_outs_0.c2_n 2.06966f
C623 c1 3bit_to_8_outs_0.c0_n 1.86971f
C624 vp VCO_sel 0.37242f
C625 m2_67169_31976# VCO5_selection_0.NAND_2in_0.a 0.27335f
C626 a_67464_30135# f5_n 0.01024f
C627 VCO3_selection_0.NAND_3in_2.y VCO3_11_sel 0.92894f
C628 a_62193_22605# a_61977_22605# 0.02238f
C629 m2_62321_27450# m2_62593_27450# 0.01344f
C630 3bit_to_8_outs_0.inverter_10.in c0 0.41738f
C631 a_62255_29603# VCO4_selection_0.NAND_3in_0.y 0.06561f
C632 VCO5_11_sel VCO5_selection_0.NAND_2in_0.b 0.36919f
C633 vp 3bit_to_8_outs_0.inverter_6.in 0.48465f
C634 c0 000000_n 0.78997f
C635 a_67248_30135# after_000111_n 0.0131f
C636 VCO5_selection_0.NAND_2in_0.a 010 0.23478f
C637 after_001111_n f4 0.17645f
C638 VCO2_selection_0.NAND_4in_0.a VCO2_5_sel 0.45278f
C639 VCO3_selection_0.NAND_3in_3.y after_000111 0.64962f
C640 VCO3_selection_0.inverter_0.out VCO3_selection_0.NAND_2in_3.y 0.05444f
C641 f0 010 0.05128f
C642 VCO2_selection_0.NAND_4in_0.a 110 0.37081f
C643 c0 3bit_to_8_outs_0.inverter_6.in 0.45306f
C644 VCO3_selection_0.NAND_3in_2.y after_000011 0.56407f
C645 m2_62321_28436# 000 0.01344f
C646 after_000111_n VCO2_selection_0.NAND_4in_0.d 0.52315f
C647 111 a_62042_31904# 0.04006f
C648 000000 000 0.2165f
C649 000000 110 0.68178f
C650 row_section_decoding_0.NAND_2in_0.b 000000_n 0.02212f
C651 VCO3_selection_0.NAND_3in_2.y a_67631_23187# 0.0655f
C652 f3 001 0.05915f
C653 f2 001 0.05925f
C654 000000 f5_n 0.17807f
C655 m2_61360_23748# m2_61635_23748# 0.01311f
C656 f2 after_000011_n 0.04467f
C657 f3 after_000011_n 0.08094f
C658 110 VCO2_selection_0.NAND_4in_1.c 0.3676f
C659 VCO4_selection_0.NAND_4in_0.d 011 0.41901f
C660 011 after_000011 0.2111f
C661 vp row_section_decoding_0.NAND_3in_0.a 0.46867f
C662 m2_62173_30160# 000 0.01001f
C663 000000_n after_000111_n 4.02631f
C664 VCO2_selection_0.NAND_3in_1.a 011 0.23678f
C665 VCO3_selection_0.NAND_3in_1.y VCO3_selection_0.NAND_2in_3.y 0.0696f
C666 101 after_000111 1.117f
C667 m2_62436_31411# 110 0.0624f
C668 110 VCO3_selection_0.NAND_3in_6.y 0.31752f
C669 000 100 0.40519f
C670 a_68565_25143# a_68781_25143# 0.02238f
C671 VCO4_selection_0.NAND_4in_0.b VCO4_selection_0.NAND_3in_0.y 0.18701f
C672 110 100 0.35483f
C673 a_67631_25617# f5 0.01168f
C674 m2_60775_23748# after_001111 0.16629f
C675 010 after_001111 0.35495f
C676 3bit_to_8_outs_0.c2_n 3bit_to_8_outs_0.c1_n 4.74896f
C677 f4 001 0.05906f
C678 f5_n 100 0.60485f
C679 m2_62111_24890# f5 0.06037f
C680 after_000011_n f4 0.04034f
C681 VCO3_selection_0.NAND_4in_1.a VCO3_selection_0.inverter_0.out 0.03057f
C682 VCO4_selection_0.NAND_4in_0.b VCO_sel 0.01641f
C683 f0 after_001111 0.05479f
C684 101 VCO2_selection_0.NAND_3in_0.y 0.08675f
C685 vp after_000111 1.20669f
C686 f5 after_000011 0.99464f
C687 VCO2_selection_0.NAND_3in_1.y a_68209_26697# 0.01087f
C688 a_61002_26463# a_61218_26463# 0.02238f
C689 VCO2_selection_0.NAND_3in_1.a f5 0.28957f
C690 c0 after_000111 0.02374f
C691 row_section_decoding_0.NAND_2in_0.b m2_62111_23748# 0.40008f
C692 m2_60697_30242# VCO4_selection_0.NAND_4in_0.b 0.01311f
C693 VCO3_selection_0.NAND_3in_0.y vp 0.47232f
C694 a_61457_22605# f4 0.04379f
C695 a_62193_24561# f1 0.01043f
C696 VCO3_selection_0.NAND_2in_3.y after_000011_n 0.37569f
C697 a_61218_26463# 3bit_to_8_outs_0.inverter_6.in 0.07661f
C698 vp VCO2_selection_0.NAND_3in_0.y 0.5774f
C699 VCO_selection_0.NAND_2in_0.y a_62518_31586# 0.06997f
C700 c1 3bit_to_8_outs_0.c1_n 0.90128f
C701 VCO2_11_sel VCO2_selection_0.NAND_4in_1.d 0.15898f
C702 3bit_to_8_outs_0.NAND_3in_2.y VCO4_selection_0.NAND_3in_0.y 0.01178f
C703 VCO2_selection_0.NAND_3in_1.a m2_68822_26780# 0.01471f
C704 after_001111_n f1 0.05162f
C705 101 f3 0.04839f
C706 a_67248_28653# a_67464_28653# 0.02238f
C707 VCO2_selection_0.NAND_2in_0.y VCO5_selection_0.NAND_2in_0.b 0.01252f
C708 101 f2 0.04847f
C709 m2_61750_31493# VCO_sel 0.08648f
C710 after_000111 after_000111_n 5.83375f
C711 110 m2_68022_24968# 0.0111f
C712 VCO2_selection_0.NAND_3in_1.y m2_68822_27026# 0.22234f
C713 VCO3_selection_0.NAND_4in_1.a m2_69195_25700# 0.09011f
C714 VCO3_selection_0.NAND_3in_5.y after_000111 0.60025f
C715 m2_60697_30242# m2_60697_30160# 0.16392f
C716 010 VCO4_selection_0.NAND_3in_0.y 0.3664f
C717 after_001111_n VCO4_selection_0.NAND_3in_1.y 0.5475f
C718 VCO2_selection_0.NAND_4in_0.b after_000011 0.05992f
C719 3bit_to_8_outs_0.NAND_3in_0.y 3bit_to_8_outs_0.c2_n 0.02839f
C720 3bit_to_8_outs_0.c2_n a_61002_28107# 0.01315f
C721 row_section_decoding_0.NAND_3in_0.c 3bit_to_8_outs_0.inverter_1.in 0.01144f
C722 VCO3_selection_0.NAND_3in_0.y VCO3_selection_0.inverter_0.in 0.58392f
C723 VCO3_selection_0.inverter_0.out VCO3_selection_0.NAND_3in_2.y 1.0227f
C724 vp f3 0.92223f
C725 3bit_to_8_outs_0.inverter_10.in 010 0.65526f
C726 vp f2 1.16699f
C727 010 000000_n 5.04659f
C728 VCO2_selection_0.NAND_3in_0.y after_000111_n 0.37514f
C729 101 f4 0.04834f
C730 VCO_selection_0.NAND_2in_0.y m2_62436_31411# 0.25957f
C731 3bit_to_8_outs_0.c2_n a_61002_27789# 0.01315f
C732 vp a_62193_24087# 0.09771f
C733 a_60555_25065# row_section_decoding_0.NAND_3in_0.b 0.04155f
C734 m2_68702_23094# VCO3_selection_0.NAND_3in_2.y 0.01538f
C735 f0 000000_n 0.06205f
C736 VCO2_selection_0.NAND_4in_1.d a_68398_28179# 0.05076f
C737 a_61054_30077# VCO4_selection_0.NAND_2in_0.y 0.06668f
C738 VCO_selection_0.NAND_2in_2.y f5 0.28664f
C739 a_67415_23187# a_67631_23187# 0.02238f
C740 111 000000 0.56922f
C741 VCO3_selection_0.NAND_3in_0.y VCO3_selection_0.NAND_2in_0.y 1.08473f
C742 VCO2_selection_0.NAND_3in_1.b VCO2_selection_0.NAND_3in_1.a 1.29005f
C743 101 3bit_to_8_outs_0.NAND_3in_3.y 0.41505f
C744 f1 001 0.05944f
C745 VCO3_selection_0.NAND_3in_2.y VCO3_selection_0.NAND_3in_1.y 0.30413f
C746 after_000011_n f1 0.03904f
C747 c2 3bit_to_8_outs_0.NAND_3in_3.y 0.52431f
C748 a_61218_26145# 3bit_to_8_outs_0.NAND_3in_0.y 0.07661f
C749 000 after_000011 2.88883f
C750 101 VCO3_selection_0.NAND_2in_3.y 0.36941f
C751 VCO3_selection_0.NAND_3in_4.y m2_69195_25946# 0.22234f
C752 vp f4 0.70294f
C753 f2 row_section_decoding_0.NAND_2in_0.b 0.01542f
C754 f3 row_section_decoding_0.NAND_2in_0.b 0.10152f
C755 110 after_000011 0.12551f
C756 111 VCO2_selection_0.NAND_4in_1.c 0.41759f
C757 row_section_decoding_0.NAND_3in_0.c row_section_decoding_0.NAND_3in_0.b 1.87161f
C758 c1 3bit_to_8_outs_0.NAND_3in_0.y 0.70372f
C759 VCO4_selection_0.NAND_3in_1.y 001 0.42357f
C760 f5_n after_000011 1.21702f
C761 after_001111_n 011 0.43084f
C762 3bit_to_8_outs_0.NAND_3in_6.y 3bit_to_8_outs_0.NAND_3in_3.y 0.10377f
C763 f2 after_000111_n 0.05492f
C764 f3 after_000111_n 0.35683f
C765 after_000011_n VCO4_selection_0.NAND_3in_1.y 0.17663f
C766 VCO3_selection_0.NAND_3in_6.y VCO3_5_sel 0.87884f
C767 VCO3_selection_0.NAND_3in_1.y 011 0.39814f
C768 a_61740_30077# VCO4_selection_0.NAND_3in_1.y 0.01863f
C769 111 100 0.14159f
C770 vp 3bit_to_8_outs_0.NAND_3in_3.y 0.50587f
C771 VCO3_selection_0.NAND_4in_1.a VCO3_selection_0.NAND_3in_3.y 0.01311f
C772 3bit_to_8_outs_0.inverter_8.in 001 0.65529f
C773 000000_n after_001111 0.18648f
C774 vp VCO3_selection_0.NAND_2in_3.y 0.70602f
C775 VCO2_selection_0.inverter_0.out VCO2_selection_0.NAND_3in_0.y 0.40076f
C776 vp VCO5_selection_0.NAND_2in_0.b 0.32037f
C777 c0 3bit_to_8_outs_0.NAND_3in_3.y 0.53998f
C778 VCO3_selection_0.NAND_2in_4.y a_68997_25143# 0.0115f
C779 row_section_decoding_0.NAND_3in_0.b row_section_decoding_0.NAND_2in_0.a 0.01815f
C780 row_section_decoding_0.NAND_2in_0.b f4 0.21194f
C781 a_62193_24561# f5 0.0109f
C782 VCO3_selection_0.NAND_3in_4.y VCO2_selection_0.NAND_3in_0.y 0.01493f
C783 VCO_selection_0.NAND_2in_1.y a_62042_31904# 0.06983f
C784 m2_60775_23748# after_000111 0.21723f
C785 after_000111 010 5.54311f
C786 f4 after_000111_n 0.78529f
C787 after_001111_n f5 0.98077f
C788 after_000011_n a_61054_30077# 0.0453f
C789 VCO3_selection_0.NAND_3in_2.y after_000011_n 0.12136f
C790 a_67928_28653# after_000111_n 0.04195f
C791 a_67248_30135# VCO2_selection_0.NAND_4in_0.d 0.01089f
C792 a_61682_26463# a_61898_26463# 0.02238f
C793 m2_62436_31493# 110 0.01068f
C794 f0 after_000111 0.04756f
C795 VCO_selection_0.NAND_2in_0.y VCO_selection_0.NAND_2in_1.y 0.79532f
C796 VCO3_selection_0.NAND_3in_0.y 010 0.01947f
C797 row_section_decoding_0.NAND_3in_0.c a_61717_24561# 0.07285f
C798 c2 3bit_to_8_outs_0.c0_n 4.58889f
C799 011 001 4.84246f
C800 a_61105_29603# VCO4_selection_0.NAND_4in_0.b 0.01139f
C801 VCO2_selection_0.NAND_4in_1.d VCO2_selection_0.NAND_3in_2.y 0.08659f
C802 a_67248_28653# f5_n 0.01334f
C803 a_67415_25617# f5 0.01537f
C804 row_section_decoding_0.NAND_3in_0.a after_001111 0.02458f
C805 a_67415_21705# f5_n 0.0131f
C806 VCO2_selection_0.NAND_3in_1.y m2_68822_26780# 0.0105f
C807 after_000011_n 011 0.16441f
C808 VCO3_selection_0.NAND_2in_3.y after_000111_n 0.30465f
C809 101 f1 0.04861f
C810 m2_62111_24890# row_section_decoding_0.NAND_3in_0.b 0.27906f
C811 3bit_to_8_outs_0.NAND_3in_6.y 3bit_to_8_outs_0.c0_n 0.54004f
C812 VCO2_selection_0.NAND_3in_2.y VCO2_selection_0.NAND_4in_0.b 0.04175f
C813 VCO3_selection_0.NAND_2in_4.y VCO3_selection_0.NAND_2in_3.y 1.06606f
C814 VCO3_selection_0.NAND_2in_2.y a_68997_23661# 0.01736f
C815 vp VCO3_selection_0.NAND_4in_1.a 0.35163f
C816 vp 3bit_to_8_outs_0.c0_n 1.59531f
C817 c1 3bit_to_8_outs_0.inverter_1.in 0.59595f
C818 111 VCO_selection_0.NAND_2in_1.y 0.37561f
C819 row_section_decoding_0.NAND_2in_0.b m2_61635_23748# 0.46433f
C820 000000_n VCO4_selection_0.NAND_3in_0.y 0.53385f
C821 c0 3bit_to_8_outs_0.c0_n 2.31986f
C822 000000 VCO3_selection_0.NAND_3in_6.y 0.052f
C823 a_62193_22605# vp 0.09933f
C824 VCO2_selection_0.NAND_4in_0.a 100 0.60314f
C825 after_000111 after_001111 21.0702f
C826 f5 001 0.69828f
C827 vp f1 0.40017f
C828 after_000011_n f5 0.15241f
C829 000000 100 5.32147f
C830 a_61002_26463# 3bit_to_8_outs_0.inverter_6.in 0.02085f
C831 VCO2_selection_0.NAND_3in_1.b a_67724_26697# 0.06997f
C832 f2 010 0.04839f
C833 f3 010 0.04839f
C834 VCO3_selection_0.NAND_3in_3.y 011 0.36501f
C835 3bit_to_8_outs_0.inverter_10.in 3bit_to_8_outs_0.inverter_6.in 0.05233f
C836 after_001111_n a_67415_25143# 0.0131f
C837 VCO3_selection_0.NAND_3in_0.y after_001111 0.72033f
C838 101 m2_62321_26792# 0.17579f
C839 vp VCO4_selection_0.NAND_3in_1.y 0.65839f
C840 VCO2_selection_0.NAND_3in_1.y VCO2_selection_0.NAND_3in_1.b 0.68469f
C841 VCO2_selection_0.NAND_4in_1.c 100 0.06073f
C842 VCO2_selection_0.NAND_2in_0.y f5 0.3784f
C843 f2 f0 0.41437f
C844 f3 f0 0.05085f
C845 a_61457_22605# f5 0.0109f
C846 VCO3_11_sel VCO3_5_sel 0.04813f
C847 c0 VCO4_selection_0.NAND_3in_1.y 0.05336f
C848 VCO3_selection_0.NAND_3in_6.y 100 0.36514f
C849 vp 3bit_to_8_outs_0.inverter_8.in 0.50968f
C850 111 after_000011 3.12707f
C851 a_68997_23661# VCO3_11_sel 0.07127f
C852 VCO3_selection_0.NAND_2in_4.y VCO3_selection_0.NAND_4in_1.a 0.02181f
C853 after_001111_n 000 0.1255f
C854 a_68899_30609# a_68683_30609# 0.02238f
C855 3bit_to_8_outs_0.inverter_8.in c0 0.45239f
C856 a_62193_22605# after_000111_n 0.0101f
C857 VCO5_11_sel a_68200_32151# 0.06973f
C858 010 f4 0.04839f
C859 after_001111_n 110 3.10614f
C860 101 011 0.15607f
C861 f1 after_000111_n 0.05541f
C862 VCO2_selection_0.NAND_4in_1.d after_000011_n 0.39696f
C863 row_section_decoding_0.NAND_3in_0.a 000000_n 0.48943f
C864 VCO3_selection_0.NAND_3in_3.y f5 0.11286f
C865 vp VCO3_selection_0.NAND_3in_2.y 0.49204f
C866 after_001111_n f5_n 18.5117f
C867 VCO_selection_0.NAND_2in_0.y m2_62436_31493# 0.09359f
C868 000000 VCO3_selection_0.NAND_2in_2.y 0.41828f
C869 f0 f4 0.05384f
C870 VCO2_11_sel a_68830_28179# 0.07413f
C871 after_000111 VCO2_selection_0.NAND_4in_0.d 0.84001f
C872 a_67248_28179# VCO2_selection_0.NAND_4in_1.c 0.01087f
C873 f5 VCO3_selection_0.NAND_2in_5.y 0.41804f
C874 VCO4_selection_0.NAND_3in_1.y after_000111_n 0.52767f
C875 f2 after_001111 0.04605f
C876 f3 after_001111 0.0465f
C877 a_67415_25617# f5_n 0.0131f
C878 000000 m2_68022_24968# 0.4644f
C879 c2 3bit_to_8_outs_0.c1_n 0.98377f
C880 vp 011 2.11728f
C881 010 VCO5_selection_0.NAND_2in_0.b 0.41637f
C882 VCO2_selection_0.NAND_2in_0.y VCO2_selection_0.NAND_4in_0.b 0.34279f
C883 VCO3_selection_0.NAND_3in_2.y a_68781_23661# 0.02306f
C884 VCO5_selection_0.NAND_2in_0.a VCO5_selection_0.NAND_2in_0.b 1.135f
C885 VCO4_11_sel VCO4_selection_0.NAND_2in_0.y 0.39465f
C886 101 f5 1.21231f
C887 000000 m2_68121_32058# 0.01395f
C888 VCO2_selection_0.NAND_3in_1.b 001 0.01448f
C889 VCO_selection_0.NAND_2in_0.y VCO_selection_0.NAND_2in_2.y 0.36823f
C890 after_000111 000000_n 0.34621f
C891 c0 011 0.0117f
C892 a_61002_26145# 3bit_to_8_outs_0.NAND_3in_0.y 0.02085f
C893 VCO3_selection_0.inverter_0.out m2_68980_21870# 0.17624f
C894 a_60771_25065# row_section_decoding_0.NAND_3in_0.b 0.03965f
C895 a_68565_25143# VCO3_selection_0.NAND_2in_4.y 0.05076f
C896 VCO3_selection_0.NAND_2in_2.y 100 0.34775f
C897 VCO2_selection_0.NAND_3in_0.y VCO2_selection_0.NAND_4in_0.d 0.02796f
C898 VCO4_selection_0.NAND_3in_1.y VCO4_selection_0.NAND_4in_0.b 1.27715f
C899 111 m2_62436_31493# 0.02497f
C900 a_61682_28107# 3bit_to_8_outs_0.NAND_3in_2.y 0.01087f
C901 VCO3_selection_0.NAND_3in_2.y after_000111_n 0.94851f
C902 vp 3bit_to_8_outs_0.c1_n 0.53984f
C903 VCO3_selection_0.NAND_3in_4.y VCO3_selection_0.NAND_4in_1.a 0.43134f
C904 001 000 19.848f
C905 110 001 0.12916f
C906 a_61524_30077# VCO4_selection_0.NAND_3in_1.y 0.0117f
C907 f4 after_001111 0.04664f
C908 after_000011_n 000 1.1386f
C909 c0 3bit_to_8_outs_0.c1_n 2.52554f
C910 110 after_000011_n 0.32454f
C911 f5_n 001 0.28105f
C912 vp f5 3.61151f
C913 VCO2_selection_0.NAND_2in_0.y VCO2_5_sel 0.83413f
C914 row_section_decoding_0.NAND_3in_0.b a_62193_24561# 0.07285f
C915 after_000011_n f5_n 0.13799f
C916 111 VCO_selection_0.NAND_2in_2.y 0.32806f
C917 a_62255_30077# a_62471_30077# 0.02238f
C918 after_000111_n 011 0.9093f
C919 VCO3_selection_0.NAND_3in_3.y a_67415_25143# 0.01095f
C920 VCO2_selection_0.inverter_0.out m2_68822_27026# 0.1765f
C921 000000 VCO4_selection_0.NAND_4in_0.d 0.39696f
C922 000000 after_000011 0.27215f
C923 VCO2_11_sel VCO2_selection_0.NAND_4in_1.c 0.7955f
C924 a_67464_28653# after_000111_n 0.01097f
C925 101 VCO2_selection_0.NAND_4in_0.b 0.43767f
C926 a_68311_23187# 000000_n 0.01189f
C927 VCO2_selection_0.NAND_3in_1.a VCO2_selection_0.NAND_4in_1.c 0.01659f
C928 row_section_decoding_0.NAND_2in_0.b f5 0.41735f
C929 m2_62173_30160# after_000011 0.0134f
C930 f5 a_67934_30609# 0.04033f
C931 010 f1 0.04839f
C932 3bit_to_8_outs_0.NAND_3in_0.y c2 2.07099f
C933 VCO3_selection_0.NAND_3in_3.y 110 0.39313f
C934 f3 000000_n 0.11943f
C935 f2 000000_n 0.05191f
C936 vp VCO2_selection_0.NAND_4in_1.d 0.30685f
C937 f5 after_000111_n 1.34264f
C938 after_000011 100 0.13509f
C939 m2_62593_26792# 3bit_to_8_outs_0.inverter_6.in 0.17547f
C940 f0 f1 12.7554f
C941 3bit_to_8_outs_0.inverter_8.in 3bit_to_8_outs_0.NAND_3in_2.y 0.36477f
C942 VCO2_selection_0.NAND_3in_1.a 100 0.07321f
C943 a_67631_23661# VCO3_selection_0.NAND_3in_6.y 0.06545f
C944 vp VCO2_selection_0.NAND_4in_0.b 0.44691f
C945 a_61105_29603# VCO4_selection_0.NAND_3in_0.y 0.01188f
C946 VCO3_selection_0.NAND_3in_5.y f5 0.76525f
C947 a_61717_23583# row_section_decoding_0.NAND_2in_0.a 0.01073f
C948 m2_68498_21788# m2_68980_21788# 0.01311f
C949 vp 3bit_to_8_outs_0.NAND_3in_0.y 0.48102f
C950 VCO3_selection_0.NAND_3in_0.y after_000111 0.59825f
C951 a_68398_28179# VCO2_selection_0.NAND_4in_1.c 0.01193f
C952 3bit_to_8_outs_0.NAND_3in_0.y c0 0.37871f
C953 101 000 0.13179f
C954 m2_60697_30406# VCO4_11_sel 0.17579f
C955 101 110 12.8635f
C956 111 after_001111_n 0.13114f
C957 f4 000000_n 0.22077f
C958 110 c2 0.01131f
C959 after_000111 VCO2_selection_0.NAND_3in_0.y 0.56281f
C960 101 f5_n 0.23308f
C961 f3 row_section_decoding_0.NAND_3in_0.a 0.55162f
C962 vp VCO2_selection_0.NAND_3in_1.b 0.34055f
C963 f2 row_section_decoding_0.NAND_3in_0.a 0.26726f
C964 VCO3_selection_0.NAND_2in_2.y VCO3_11_sel 0.23685f
C965 row_section_decoding_0.NAND_3in_0.c after_000011 0.0159f
C966 VCO3_selection_0.NAND_3in_2.y 010 0.37072f
C967 3bit_to_8_outs_0.NAND_3in_2.y 011 0.04063f
C968 m2_62436_31493# m2_62436_31411# 0.39957f
C969 m2_61360_23912# after_000011 0.22093f
C970 VCO_selection_0.NAND_2in_0.y 001 0.02534f
C971 3bit_to_8_outs_0.NAND_3in_0.y a_61898_26145# 0.01203f
C972 f1 after_001111 0.04593f
C973 vp VCO2_5_sel 0.36812f
C974 f2 m2_62111_23748# 0.01317f
C975 f3 m2_62111_23748# 0.07431f
C976 vp 000 5.27126f
C977 vp 110 1.40839f
C978 a_67415_21705# a_67631_21705# 0.02238f
C979 3bit_to_8_outs_0.inverter_6.in 3bit_to_8_outs_0.NAND_3in_3.y 0.36477f
C980 a_68101_25143# VCO3_selection_0.NAND_2in_4.y 0.07028f
C981 m2_68980_21788# m2_68980_21870# 0.16392f
C982 vp f5_n 2.61433f
C983 010 011 18.9073f
C984 a_61717_23583# after_000011 0.07078f
C985 3bit_to_8_outs_0.NAND_3in_2.y 3bit_to_8_outs_0.c1_n 0.59595f
C986 row_section_decoding_0.NAND_2in_0.a after_000011 0.52374f
C987 a_67415_23187# after_000111_n 0.01515f
C988 m2_62436_31411# VCO_selection_0.NAND_2in_2.y 0.0155f
C989 f2 after_000111 0.03877f
C990 c2 3bit_to_8_outs_0.inverter_1.in 0.52425f
C991 f3 after_000111 0.03923f
C992 c0 f5_n 0.01861f
C993 after_000111 a_68163_30135# 0.0127f
C994 VCO2_selection_0.NAND_4in_0.a VCO5_11_sel 0.01006f
C995 f0 011 0.06687f
C996 a_67934_28179# after_000011_n 0.04021f
C997 111 001 0.07156f
C998 m2_68702_23012# 000000 0.07992f
C999 111 after_000011_n 0.85607f
C1000 VCO2_selection_0.inverter_0.out m2_68822_26780# 0.09024f
C1001 VCO2_selection_0.NAND_3in_1.b VCO3_selection_0.NAND_3in_5.y 0.01003f
C1002 after_001111_n a_60981_22605# 0.07296f
C1003 vp 3bit_to_8_outs_0.inverter_1.in 0.50126f
C1004 after_000111_n 000 0.09915f
C1005 VCO4_11_sel vp 0.15646f
C1006 VCO2_selection_0.NAND_4in_1.d VCO2_selection_0.inverter_0.out 0.02274f
C1007 110 after_000111_n 6.31819f
C1008 010 f5 1.47292f
C1009 VCO3_selection_0.NAND_3in_1.y a_68095_23187# 0.01081f
C1010 after_000111 f4 0.03931f
C1011 m2_68702_23094# 000000 0.0659f
C1012 a_67631_25143# a_67415_25143# 0.02238f
C1013 f5_n after_000111_n 3.5272f
C1014 VCO3_selection_0.NAND_3in_2.y a_68565_23661# 0.01152f
C1015 VCO2_selection_0.NAND_3in_2.y VCO2_selection_0.NAND_4in_1.c 0.18889f
C1016 after_001111_n VCO2_selection_0.NAND_4in_0.a 0.56345f
C1017 VCO4_5_sel VCO4_selection_0.NAND_4in_0.d 0.13627f
C1018 VCO3_selection_0.NAND_2in_4.y 110 0.41909f
C1019 VCO_selection_0.NAND_2in_2.y a_62048_31586# 0.01626f
C1020 VCO5_selection_0.NAND_2in_0.a a_67248_32151# 0.06997f
C1021 VCO4_selection_0.NAND_3in_1.y a_62471_30077# 0.01091f
C1022 f0 f5 0.14846f
C1023 3bit_to_8_outs_0.inverter_10.in 3bit_to_8_outs_0.c0_n 0.45314f
C1024 VCO2_11_sel VCO2_selection_0.NAND_3in_1.a 0.01286f
C1025 m2_68702_23012# 100 0.0111f
C1026 after_001111_n 000000 3.6788f
C1027 000000_n 3bit_to_8_outs_0.c0_n 0.01719f
C1028 VCO3_selection_0.inverter_0.out m2_68980_22034# 0.17579f
C1029 m2_68498_21788# VCO3_selection_0.inverter_0.in 0.09409f
C1030 a_60771_25065# a_60555_25065# 0.02238f
C1031 VCO3_selection_0.NAND_3in_5.y f5_n 0.53784f
C1032 011 after_001111 0.76686f
C1033 m2_69195_25700# m2_69195_25782# 0.16392f
C1034 000000 VCO3_selection_0.NAND_3in_1.y 0.37476f
C1035 VCO3_selection_0.NAND_2in_0.y 000 0.3995f
C1036 3bit_to_8_outs_0.inverter_6.in 3bit_to_8_outs_0.c0_n 0.41745f
C1037 3bit_to_8_outs_0.inverter_1.in a_61898_26145# 0.06651f
C1038 f1 000000_n 0.05248f
C1039 after_001111_n m2_62173_30160# 0.65862f
C1040 VCO4_selection_0.NAND_3in_1.y VCO4_selection_0.NAND_3in_0.y 0.07568f
C1041 a_67928_28653# VCO2_selection_0.NAND_3in_0.y 0.01365f
C1042 a_61321_29603# VCO4_selection_0.NAND_4in_0.d 0.04896f
C1043 vp row_section_decoding_0.NAND_3in_0.b 0.277f
C1044 f2 f3 14.5624f
C1045 m2_61635_23748# m2_62111_23748# 0.01378f
C1046 a_60771_25065# row_section_decoding_0.NAND_3in_0.c 0.01271f
C1047 m2_68498_21788# VCO3_selection_0.NAND_2in_0.y 0.01413f
C1048 after_001111_n 100 0.11252f
C1049 VCO2_selection_0.NAND_4in_1.d a_68614_28179# 0.0123f
C1050 a_62193_24087# f2 0.04549f
C1051 a_62193_24087# f3 0.01721f
C1052 VCO3_selection_0.NAND_3in_1.y 100 0.15222f
C1053 VCO_selection_0.NAND_2in_2.y VCO_selection_0.NAND_2in_1.y 0.25355f
C1054 f5 after_001111 0.43297f
C1055 VCO_selection_0.NAND_2in_0.y vp 0.39139f
C1056 a_68101_23661# after_000011_n 0.04021f
C1057 row_section_decoding_0.NAND_3in_0.a 3bit_to_8_outs_0.c0_n 0.01466f
C1058 111 101 0.87415f
C1059 3bit_to_8_outs_0.inverter_8.in 3bit_to_8_outs_0.inverter_10.in 0.17759f
C1060 c1 3bit_to_8_outs_0.c2_n 0.46692f
C1061 m2_68702_23012# VCO3_selection_0.NAND_2in_2.y 0.25893f
C1062 m2_68980_21870# VCO3_selection_0.inverter_0.in 0.01142f
C1063 m2_62321_28436# 001 0.17579f
C1064 000000 001 4.80436f
C1065 VCO3_selection_0.inverter_0.out VCO3_selection_0.NAND_2in_2.y 0.15677f
C1066 a_68209_26697# a_68425_26697# 0.02238f
C1067 f2 f4 0.06665f
C1068 f3 f4 13.4161f
C1069 000000 after_000011_n 21.7489f
C1070 VCO3_selection_0.NAND_4in_1.a m2_69195_25946# 0.17582f
C1071 VCO2_selection_0.NAND_4in_0.a VCO2_selection_0.NAND_2in_0.y 0.66305f
C1072 VCO3_selection_0.NAND_3in_2.y 000000_n 0.18908f
C1073 m2_68702_23094# VCO3_selection_0.NAND_2in_2.y 0.09296f
C1074 after_000011_n VCO2_selection_0.NAND_4in_1.c 0.71898f
C1075 m2_67169_31976# 000 0.01118f
C1076 VCO5_11_sel m2_68121_32058# 0.09359f
C1077 011 VCO4_selection_0.NAND_3in_0.y 0.41768f
C1078 111 vp 1.24437f
C1079 VCO3_selection_0.NAND_3in_3.y m2_69195_25782# 0.01378f
C1080 after_000111 a_67464_30609# 0.01845f
C1081 vp a_61717_24561# 0.09771f
C1082 010 000 0.9863f
C1083 VCO3_selection_0.NAND_3in_6.y after_000011_n 0.16633f
C1084 vp VCO3_5_sel 0.39142f
C1085 110 010 0.23612f
C1086 001 100 0.20834f
C1087 3bit_to_8_outs_0.inverter_10.in 011 0.3855f
C1088 VCO5_selection_0.NAND_2in_0.a 000 0.33553f
C1089 000000_n 011 0.21465f
C1090 VCO3_selection_0.NAND_2in_2.y VCO3_selection_0.NAND_3in_1.y 1.11545f
C1091 after_000011_n 100 0.2261f
C1092 after_000111 f1 0.03867f
C1093 a_68209_26697# VCO2_selection_0.NAND_3in_0.y 0.0131f
C1094 010 f5_n 0.41336f
C1095 f0 000 0.05282f
C1096 f0 110 0.06452f
C1097 after_001111_n m2_68022_24968# 0.01451f
C1098 VCO4_11_sel m2_60697_30160# 0.09002f
C1099 a_60889_29603# a_61105_29603# 0.02238f
C1100 f5 VCO2_selection_0.NAND_4in_0.d 0.01319f
C1101 VCO3_selection_0.NAND_3in_3.y 000000 0.23022f
C1102 f0 f5_n 0.03011f
C1103 VCO2_selection_0.NAND_2in_0.y 100 0.34819f
C1104 3bit_to_8_outs_0.inverter_10.in 3bit_to_8_outs_0.c1_n 0.07709f
C1105 a_62048_31586# a_61832_31586# 0.02238f
C1106 VCO3_selection_0.inverter_0.out VCO3_11_sel 0.67429f
C1107 a_68101_25617# f5 0.04035f
C1108 m2_61360_23748# after_000011 0.01142f
C1109 3bit_to_8_outs_0.NAND_3in_0.y a_61682_26145# 0.01403f
C1110 a_68997_23661# a_68781_23661# 0.02238f
C1111 a_61898_28107# 3bit_to_8_outs_0.NAND_3in_2.y 0.06651f
C1112 VCO2_11_sel VCO2_selection_0.NAND_3in_2.y 0.94659f
C1113 111 after_000111_n 0.17858f
C1114 3bit_to_8_outs_0.inverter_6.in 3bit_to_8_outs_0.c1_n 0.70099f
C1115 VCO5_selection_0.NAND_2in_0.a a_68200_32151# 0.01559f
C1116 VCO2_selection_0.NAND_3in_1.b after_001111 0.39115f
C1117 VCO3_selection_0.NAND_3in_3.y VCO3_selection_0.NAND_3in_6.y 0.06676f
C1118 f5 000000_n 0.18957f
C1119 m2_62321_27450# 3bit_to_8_outs_0.NAND_3in_6.y 0.2121f
C1120 VCO2_selection_0.NAND_3in_2.y after_000011 0.75905f
C1121 VCO3_11_sel gd 3.91913f
C1122 VCO3_5_sel gd 3.31686f
C1123 VCO2_11_sel gd 1.86334f
C1124 VCO4_5_sel gd 0.81484f
C1125 VCO4_11_sel gd 0.67368f
C1126 VCO2_5_sel gd 1.39783f
C1127 VCO_sel gd 1.45896f
C1128 VCO5_11_sel gd 1.45507f
C1129 vp gd 50.17028f
C1130 m2_68980_21788# gd 0.0253f ; **FLOATING
C1131 m2_68498_21788# gd 0.06493f ; **FLOATING
C1132 m2_68980_21870# gd 0.01271f ; **FLOATING
C1133 m2_68980_22034# gd 0.01169f ; **FLOATING
C1134 m2_68702_23012# gd 0.02054f ; **FLOATING
C1135 m2_68702_23094# gd 0.03291f ; **FLOATING
C1136 m2_62111_23748# gd 0.02079f ; **FLOATING
C1137 m2_61635_23748# gd 0.01366f ; **FLOATING
C1138 m2_68022_24968# gd 0.01348f ; **FLOATING
C1139 m2_62111_24890# gd 0.02016f ; **FLOATING
C1140 m2_69195_25700# gd 0.02043f ; **FLOATING
C1141 m2_69195_25782# gd 0.01359f ; **FLOATING
C1142 m2_69195_25946# gd 0.01263f ; **FLOATING
C1143 m2_62593_25806# gd 0.01174f ; **FLOATING
C1144 m2_68822_26780# gd 0.01834f ; **FLOATING
C1145 m2_62593_26792# gd 0.01174f ; **FLOATING
C1146 m2_68822_27026# gd 0.01172f ; **FLOATING
C1147 m2_62593_27450# gd 0.01174f ; **FLOATING
C1148 m2_62173_30160# gd 0.02826f ; **FLOATING
C1149 m2_60697_30160# gd 0.01927f ; **FLOATING
C1150 m2_60697_30242# gd 0.01239f ; **FLOATING
C1151 m2_60697_30406# gd 0.01138f ; **FLOATING
C1152 m2_62436_31411# gd 0.02021f ; **FLOATING
C1153 m2_62436_31493# gd 0.03913f ; **FLOATING
C1154 m2_61750_31493# gd 0.068f ; **FLOATING
C1155 m2_67169_31976# gd 0.02026f ; **FLOATING
C1156 m2_68121_32058# gd 0.06772f ; **FLOATING
C1157 a_68577_21705# gd 0.10808f
C1158 a_68101_21705# gd 0.10713f
C1159 a_67631_21705# gd 0.08691f
C1160 a_67415_21705# gd 0.10756f
C1161 VCO3_selection_0.NAND_2in_0.y gd 0.1913f
C1162 a_61977_22605# gd 0.01517f
C1163 a_68781_23187# gd 0.10685f
C1164 a_68311_23187# gd 0.08448f
C1165 a_68095_23187# gd 0.10419f
C1166 a_67631_23187# gd 1.52787f
C1167 a_67415_23187# gd 0.10513f
C1168 a_68997_23661# gd 0.08452f
C1169 a_68781_23661# gd 0.08285f
C1170 a_68565_23661# gd 0.10253f
C1171 a_68101_23661# gd 0.10468f
C1172 a_67631_23661# gd 0.08448f
C1173 a_61717_23583# gd 0.10492f
C1174 a_67415_23661# gd 0.10513f
C1175 VCO3_selection_0.inverter_0.out gd 0.89651f
C1176 row_section_decoding_0.NAND_2in_0.b gd 0.80094f
C1177 a_61717_24561# gd 0.50817f
C1178 a_68997_25143# gd 0.08452f
C1179 a_68781_25143# gd 0.33844f
C1180 a_68565_25143# gd 0.35811f
C1181 a_68101_25143# gd 0.10468f
C1182 a_67631_25143# gd 0.08448f
C1183 a_60771_25065# gd 0.79545f
C1184 a_60555_25065# gd 0.72009f
C1185 a_67415_25143# gd 0.10513f
C1186 a_68798_25617# gd 0.38884f
C1187 a_68582_25617# gd 0.86456f
C1188 a_68101_25617# gd 0.10467f
C1189 a_67631_25617# gd 2.27783f
C1190 a_67415_25617# gd 2.29848f
C1191 VCO3_selection_0.NAND_4in_1.a gd 1.04779f
C1192 a_61898_26145# gd 0.87577f
C1193 a_61682_26145# gd 0.89643f
C1194 a_61218_26145# gd 0.08449f
C1195 a_61002_26145# gd 0.10513f
C1196 a_61898_26463# gd 0.08446f
C1197 a_61682_26463# gd 0.10512f
C1198 a_61218_26463# gd 1.24821f
C1199 a_61002_26463# gd 0.10513f
C1200 a_68425_26697# gd 0.08161f
C1201 a_68209_26697# gd 0.10515f
C1202 a_67724_26697# gd 0.10469f
C1203 a_67248_26697# gd 0.10695f
C1204 a_61898_27789# gd 0.08446f
C1205 a_61682_27789# gd 0.10512f
C1206 a_61218_27789# gd 0.08448f
C1207 a_61002_27789# gd 0.10513f
C1208 a_68830_28179# gd 2.24867f
C1209 a_68614_28179# gd 1.7283f
C1210 a_68398_28179# gd 0.54167f
C1211 a_67934_28179# gd 2.189f
C1212 a_67464_28179# gd 0.08448f
C1213 a_61898_28107# gd 0.73305f
C1214 a_61682_28107# gd 0.75371f
C1215 a_61218_28107# gd 0.08448f
C1216 a_61002_28107# gd 0.10513f
C1217 a_67248_28179# gd 2.39539f
C1218 a_68144_28653# gd 0.08453f
C1219 a_67928_28653# gd 2.66246f
C1220 a_67464_28653# gd 0.56647f
C1221 a_67248_28653# gd 0.10513f
C1222 a_62471_29603# gd 0.10513f
C1223 a_62255_29603# gd 0.08448f
C1224 a_61785_29603# gd 0.10468f
C1225 a_61321_29603# gd 0.6506f
C1226 a_61105_29603# gd 0.79666f
C1227 a_60889_29603# gd 0.92229f
C1228 a_68163_30135# gd 0.08509f
C1229 a_67947_30135# gd 0.10449f
C1230 a_67464_30135# gd 0.08457f
C1231 a_67248_30135# gd 0.10519f
C1232 a_62471_30077# gd 0.10512f
C1233 a_62255_30077# gd 0.08446f
C1234 a_61740_30077# gd 2.18141f
C1235 a_61524_30077# gd 0.08448f
C1236 a_61054_30077# gd 0.10493f
C1237 a_68899_30609# gd 0.49958f
C1238 a_68683_30609# gd 0.71203f
C1239 a_68467_30609# gd 0.31784f
C1240 a_67934_30609# gd 0.10465f
C1241 a_67464_30609# gd 1.62003f
C1242 a_67248_30609# gd 1.64068f
C1243 a_62518_31586# gd 3.90364f
C1244 a_62048_31586# gd 1.64487f
C1245 a_61832_31586# gd 2.02483f
C1246 a_62518_31904# gd 0.10695f
C1247 a_62042_31904# gd 0.10266f
C1248 a_68200_32151# gd 0.10497f
C1249 a_67724_32151# gd 0.10469f
C1250 a_67248_32151# gd 0.10695f
C1251 VCO_selection_0.NAND_2in_2.y gd 0.11637f
C1252 111 gd 0.70517f
.ends
