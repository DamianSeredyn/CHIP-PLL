* PEX produced on Sun Sep 20 08:19:08 PM CEST 2026 using /foss/tools/sak/sak-pex.sh with m=2 and s=1
* NGSPICE file created from VCO_decoder_cells.ext - technology: ihp-sg13cmos5l

.subckt VCO_decoder_cells VCO_sel VCO4_11_sel VCO4_5_sel VCO3_5_sel VCO3_11_sel VCO2_11_sel
+ VCO2_5_sel VCO5_11_sel f0 f2 f1 f5 f4 f3 c2 c1 c0 gd vp
X0 vp after_000111 VCO3_selection_0.NAND_3in_2.y vp sg13_lv_pmos ad=0.1005p pd=1.34u as=0.1005p ps=1.34u w=0.15u l=0.13u
X1 VCO3_selection_0.NAND_3in_8.y 110 a_32468_40540# gd sg13_lv_nmos ad=0.1005p pd=1.34u as=0.1005p ps=1.34u w=0.15u l=0.13u
X2 VCO3_selection_0.NAND_3in_5.y 011 a_31788_42496# gd sg13_lv_nmos ad=0.1005p pd=1.34u as=0.1005p ps=1.34u w=0.15u l=0.13u
X3 VCO2_selection_0.inverter_2.in f5 vp vp sg13_lv_pmos ad=0.1005p pd=1.34u as=0.1005p ps=1.34u w=0.15u l=0.13u
X4 VCO4_selection_0.NAND_3in_2.y 011 a_31956_46420# gd sg13_lv_nmos ad=0.1005p pd=1.34u as=0.1005p ps=1.34u w=0.15u l=0.13u
X5 VCO4_selection_0.inverter_2.in after_001111_n vp vp sg13_lv_pmos ad=0.1005p pd=1.34u as=0.1005p ps=1.34u w=0.15u l=0.13u
X6 VCO2_selection_0.inverter_3.in 111 a_31883_34670# gd sg13_lv_nmos ad=0.1005p pd=1.34u as=0.1005p ps=1.34u w=0.15u l=0.13u
X7 VCO3_selection_0.NAND_3in_0.c VCO3_selection_0.inverter_5.out a_33085_39098# vp sg13_lv_pmos ad=0.1005p pd=1.34u as=0.1005p ps=1.34u w=0.15u l=0.13u
X8 VCO5_selection_0.inverter_1.in after_000011_n vp vp sg13_lv_pmos ad=0.1005p pd=1.34u as=0.1005p ps=1.34u w=0.15u l=0.13u
X9 VCO2_selection_0.NAND_3in_3.c f1 a_31939_31170# vp sg13_lv_pmos ad=0.204p pd=1.88u as=0.204p ps=1.88u w=0.6u l=0.13u
X10 VCO3_selection_0.NAND_2in_1.y 100 a_32258_36164# gd sg13_lv_nmos ad=0.1005p pd=1.34u as=0.1005p ps=1.34u w=0.15u l=0.13u
X11 VCO4_selection_0.inverter_2.out VCO4_selection_0.inverter_2.in vp vp sg13_lv_pmos ad=0.1005p pd=1.34u as=0.1005p ps=1.34u w=0.15u l=0.13u
X12 VCO5_selection_0.XNOR_0._b f1 vp vp sg13_lv_pmos ad=0.1005p pd=1.34u as=0.1005p ps=1.34u w=0.15u l=0.13u
X13 VCO3_selection_0.NAND_3in_1.y 010 vp vp sg13_lv_pmos ad=0.1005p pd=1.34u as=0.1005p ps=1.34u w=0.15u l=0.13u
X14 VCO4_selection_0.XNOR_0.y VCO4_selection_0.XNOR_0._b a_32052_48788# vp sg13_lv_pmos ad=0.204p pd=1.88u as=0.204p ps=1.88u w=0.6u l=0.13u
X15 vp after_000111 VCO2_selection_0.inverter_1.in vp sg13_lv_pmos ad=0.1005p pd=1.34u as=0.1005p ps=1.34u w=0.15u l=0.13u
X16 a_32093_34196# after_001111 gd gd sg13_lv_nmos ad=0.1005p pd=1.34u as=0.1005p ps=1.34u w=0.15u l=0.13u
X17 VCO_selection_0.NAND_2in_1.y after_000111 a_31266_50186# gd sg13_lv_nmos ad=0.1005p pd=1.34u as=0.1005p ps=1.34u w=0.15u l=0.13u
X18 VCO3_selection_0.XNOR_1.y VCO3_selection_0.XNOR_1._a a_32570_40066# gd sg13_lv_nmos ad=0.1005p pd=1.34u as=0.1005p ps=1.34u w=0.15u l=0.13u
X19 vp 3bit_to_8_outs_0.NAND_3in_0.y 111 vp sg13_lv_pmos ad=0.1005p pd=1.34u as=0.1005p ps=1.34u w=0.15u l=0.13u
X20 VCO2_selection_0.NOR_2in_0.b VCO2_selection_0.NAND_3in_7.y gd gd sg13_lv_nmos ad=0.1005p pd=1.34u as=0.1005p ps=1.34u w=0.15u l=0.13u
X21 VCO4_selection_0.inverter_5.in VCO4_selection_0.XNOR_1._a a_32058_47902# gd sg13_lv_nmos ad=0.1005p pd=1.34u as=0.1005p ps=1.34u w=0.15u l=0.13u
X22 VCO5_selection_0.inverter_2.out VCO5_selection_0.inverter_2.in vp vp sg13_lv_pmos ad=0.1005p pd=1.34u as=0.1005p ps=1.34u w=0.15u l=0.13u
X23 vp c2 3bit_to_8_outs_0.c2_n vp sg13_lv_pmos ad=0.1005p pd=1.34u as=0.1005p ps=1.34u w=0.15u l=0.13u
X24 gd c2 a_31626_24854# gd sg13_lv_nmos ad=0.1005p pd=1.34u as=0.1005p ps=1.34u w=0.15u l=0.13u
X25 a_31945_30758# VCO2_selection_0.XNOR_0._b gd gd sg13_lv_nmos ad=0.1005p pd=1.34u as=0.1005p ps=1.34u w=0.15u l=0.13u
X26 VCO5_selection_0.inverter_0.in 001 vp vp sg13_lv_pmos ad=0.1005p pd=1.34u as=0.1005p ps=1.34u w=0.15u l=0.13u
X27 vp VCO3_selection_0.NAND_3in_6.b VCO3_5_sel vp sg13_lv_pmos ad=0.1005p pd=1.34u as=0.1005p ps=1.34u w=0.15u l=0.13u
X28 gd 3bit_to_8_outs_0.NAND_3in_3.y 101 gd sg13_lv_nmos ad=0.1005p pd=1.34u as=0.1005p ps=1.34u w=0.15u l=0.13u
X29 VCO5_11_sel VCO5_selection_0.NAND_2in_0.b vp vp sg13_lv_pmos ad=0.1005p pd=1.34u as=0.1005p ps=1.34u w=0.15u l=0.13u
X30 VCO4_selection_0.XNOR_0.y VCO4_selection_0.XNOR_0._a a_32058_48376# gd sg13_lv_nmos ad=0.1005p pd=1.34u as=0.1005p ps=1.34u w=0.15u l=0.13u
X31 VCO4_selection_0.inverter_5.out VCO4_selection_0.inverter_5.in gd gd sg13_lv_nmos ad=0.1005p pd=1.34u as=0.1005p ps=1.34u w=0.15u l=0.13u
X32 a_32303_30284# after_000011_n a_32087_30284# gd sg13_lv_nmos ad=0.1005p pd=1.34u as=0.1005p ps=1.34u w=0.15u l=0.13u
X33 gd 3bit_to_8_outs_0.NAND_3in_2.y 001 gd sg13_lv_nmos ad=0.1005p pd=1.34u as=0.1005p ps=1.34u w=0.15u l=0.13u
X34 VCO2_selection_0.inverter_1.out VCO2_selection_0.inverter_1.in gd gd sg13_lv_nmos ad=0.1005p pd=1.34u as=0.1005p ps=1.34u w=0.15u l=0.13u
X35 a_32494_43990# VCO4_selection_0.NAND_2in_0.b gd gd sg13_lv_nmos ad=0.1005p pd=1.34u as=0.1005p ps=1.34u w=0.15u l=0.13u
X36 vp c0 3bit_to_8_outs_0.NAND_3in_3.y vp sg13_lv_pmos ad=0.1005p pd=1.34u as=0.1005p ps=1.34u w=0.15u l=0.13u
X37 vp 3bit_to_8_outs_0.c2_n 3bit_to_8_outs_0.NAND_3in_2.y vp sg13_lv_pmos ad=0.1005p pd=1.34u as=0.1005p ps=1.34u w=0.15u l=0.13u
X38 VCO4_selection_0.NOR_2in_1.a VCO4_selection_0.inverter_4.in vp vp sg13_lv_pmos ad=0.1005p pd=1.34u as=0.1005p ps=1.34u w=0.15u l=0.13u
X39 VCO3_selection_0.XNOR_0._a f0 vp vp sg13_lv_pmos ad=0.1005p pd=1.34u as=0.1005p ps=1.34u w=0.15u l=0.13u
X40 VCO5_selection_0.inverter_2.in f1 a_31315_29201# vp sg13_lv_pmos ad=0.204p pd=1.88u as=0.204p ps=1.88u w=0.6u l=0.13u
X41 a_31788_36164# after_000011 a_31572_36164# gd sg13_lv_nmos ad=0.1005p pd=1.34u as=0.1005p ps=1.34u w=0.15u l=0.13u
X42 a_31407_32714# after_000111 gd gd sg13_lv_nmos ad=0.1005p pd=1.34u as=0.1005p ps=1.34u w=0.15u l=0.13u
X43 a_32252_38120# VCO3_selection_0.NAND_3in_7.c gd gd sg13_lv_nmos ad=0.1005p pd=1.34u as=0.1005p ps=1.34u w=0.15u l=0.13u
X44 a_31407_34196# f5_n gd gd sg13_lv_nmos ad=0.1005p pd=1.34u as=0.1005p ps=1.34u w=0.15u l=0.13u
X45 a_32779_32240# after_000011 a_32563_32240# gd sg13_lv_nmos ad=0.1005p pd=1.34u as=0.1005p ps=1.34u w=0.15u l=0.13u
X46 VCO2_selection_0.NOR_2in_2.y VCO2_selection_0.NOR_2in_2.a gd gd sg13_lv_nmos ad=0.1005p pd=1.34u as=0.1005p ps=1.34u w=0.15u l=0.13u
X47 a_31592_48788# f0 vp vp sg13_lv_pmos ad=0.204p pd=1.88u as=0.204p ps=1.88u w=0.6u l=0.13u
X48 VCO3_selection_0.inverter_0.out VCO3_selection_0.NAND_3in_7.y gd gd sg13_lv_nmos ad=0.1005p pd=1.34u as=0.1005p ps=1.34u w=0.15u l=0.13u
X49 VCO2_selection_0.NAND_4in_0.b f5_n vp vp sg13_lv_pmos ad=0.1005p pd=1.34u as=0.1005p ps=1.34u w=0.15u l=0.13u
X50 VCO4_selection_0.inverter_3.in after_000111_n vp vp sg13_lv_pmos ad=0.1005p pd=1.34u as=0.1005p ps=1.34u w=0.15u l=0.13u
X51 a_31626_25172# 3bit_to_8_outs_0.c1_n a_31410_25172# gd sg13_lv_nmos ad=0.1005p pd=1.34u as=0.1005p ps=1.34u w=0.15u l=0.13u
X52 VCO2_selection_0.NOR_2in_0.y VCO2_selection_0.NOR_2in_0.b a_33317_29780# vp sg13_lv_pmos ad=0.1005p pd=1.34u as=0.1005p ps=1.34u w=0.15u l=0.13u
X53 gd VCO3_selection_0.inverter_8.out VCO3_selection_0.NAND_3in_6.c gd sg13_lv_nmos ad=0.1005p pd=1.34u as=0.1005p ps=1.34u w=0.15u l=0.13u
X54 a_31626_26816# 3bit_to_8_outs_0.c1_n a_31410_26816# gd sg13_lv_nmos ad=0.1005p pd=1.34u as=0.1005p ps=1.34u w=0.15u l=0.13u
X55 VCO5_selection_0.inverter_0.out VCO5_selection_0.inverter_0.in gd gd sg13_lv_nmos ad=0.1005p pd=1.34u as=0.1005p ps=1.34u w=0.15u l=0.13u
X56 a_32405_30758# f1 gd gd sg13_lv_nmos ad=0.1005p pd=1.34u as=0.1005p ps=1.34u w=0.15u l=0.13u
X57 VCO3_selection_0.inverter_5.out VCO3_selection_0.NAND_3in_3.y vp vp sg13_lv_pmos ad=0.1005p pd=1.34u as=0.1005p ps=1.34u w=0.15u l=0.13u
X58 gd VCO3_selection_0.NOR_2in_4.b VCO3_selection_0.NAND_3in_6.b gd sg13_lv_nmos ad=0.1005p pd=1.34u as=0.1005p ps=1.34u w=0.15u l=0.13u
X59 vp c2 3bit_to_8_outs_0.inverter_6.in vp sg13_lv_pmos ad=0.1005p pd=1.34u as=0.1005p ps=1.34u w=0.15u l=0.13u
X60 VCO4_selection_0.inverter_4.in 001 vp vp sg13_lv_pmos ad=0.1005p pd=1.34u as=0.1005p ps=1.34u w=0.15u l=0.13u
X61 gd 3bit_to_8_outs_0.inverter_10.in 011 gd sg13_lv_nmos ad=0.1005p pd=1.34u as=0.1005p ps=1.34u w=0.15u l=0.13u
X62 3bit_to_8_outs_0.inverter_10.in c1 vp vp sg13_lv_pmos ad=0.1005p pd=1.34u as=0.1005p ps=1.34u w=0.15u l=0.13u
X63 a_31407_34670# f5 gd gd sg13_lv_nmos ad=0.1005p pd=1.34u as=0.1005p ps=1.34u w=0.15u l=0.13u
X64 VCO3_selection_0.inverter_3.out VCO3_selection_0.NAND_3in_2.y vp vp sg13_lv_pmos ad=0.1005p pd=1.34u as=0.1005p ps=1.34u w=0.15u l=0.13u
X65 VCO3_11_sel VCO3_selection_0.NOR_2in_0.y vp vp sg13_lv_pmos ad=0.1005p pd=1.34u as=0.1005p ps=1.34u w=0.15u l=0.13u
X66 row_section_decoding_0.NAND_2in_0.a f3 a_30774_23859# vp sg13_lv_pmos ad=0.1005p pd=1.34u as=0.1005p ps=1.34u w=0.15u l=0.13u
X67 vp after_000011_n VCO3_selection_0.NAND_3in_8.y vp sg13_lv_pmos ad=0.1005p pd=1.34u as=0.1005p ps=1.34u w=0.15u l=0.13u
X68 vp 001 VCO3_selection_0.NAND_2in_0.y vp sg13_lv_pmos ad=0.1005p pd=1.34u as=0.1005p ps=1.34u w=0.15u l=0.13u
X69 gd VCO3_selection_0.inverter_5.out VCO3_selection_0.NAND_3in_0.c gd sg13_lv_nmos ad=0.1005p pd=1.34u as=0.1005p ps=1.34u w=0.15u l=0.13u
X70 VCO2_selection_0.NAND_4in_0.c 100 a_31407_32240# gd sg13_lv_nmos ad=0.1005p pd=1.34u as=0.1005p ps=1.34u w=0.15u l=0.13u
X71 a_32090_24854# c0 3bit_to_8_outs_0.NAND_3in_0.y gd sg13_lv_nmos ad=0.1005p pd=1.34u as=0.1005p ps=1.34u w=0.15u l=0.13u
X72 a_30790_50186# f5 gd gd sg13_lv_nmos ad=0.1005p pd=1.34u as=0.1005p ps=1.34u w=0.15u l=0.13u
X73 after_000011_n after_000011 vp vp sg13_lv_pmos ad=0.1005p pd=1.34u as=0.1005p ps=1.34u w=0.15u l=0.13u
X74 VCO2_selection_0.XNOR_0._a f0 gd gd sg13_lv_nmos ad=0.1005p pd=1.34u as=0.1005p ps=1.34u w=0.15u l=0.13u
X75 VCO3_selection_0.NOR_2in_4.b VCO3_selection_0.NAND_2in_3.y vp vp sg13_lv_pmos ad=0.1005p pd=1.34u as=0.1005p ps=1.34u w=0.15u l=0.13u
X76 VCO4_selection_0.NAND_3in_1.y 000 vp vp sg13_lv_pmos ad=0.1005p pd=1.34u as=0.1005p ps=1.34u w=0.15u l=0.13u
X77 VCO2_5_sel VCO2_selection_0.NAND_4in_0.d vp vp sg13_lv_pmos ad=0.1005p pd=1.34u as=0.1005p ps=1.34u w=0.15u l=0.13u
X78 VCO2_11_sel VCO2_selection_0.NAND_3in_5.c vp vp sg13_lv_pmos ad=0.1005p pd=1.34u as=0.1005p ps=1.34u w=0.15u l=0.13u
X79 VCO_sel VCO_selection_0.NAND_2in_2.y vp vp sg13_lv_pmos ad=0.1005p pd=1.34u as=0.1005p ps=1.34u w=0.15u l=0.13u
X80 VCO4_selection_0.inverter_3.out VCO4_selection_0.inverter_3.in gd gd sg13_lv_nmos ad=0.1005p pd=1.34u as=0.1005p ps=1.34u w=0.15u l=0.13u
X81 vp after_000011 VCO2_selection_0.NAND_4in_0.d vp sg13_lv_pmos ad=0.1005p pd=1.34u as=0.1005p ps=1.34u w=0.15u l=0.13u
X82 after_001111 after_001111_n vp vp sg13_lv_pmos ad=0.1005p pd=1.34u as=0.1005p ps=1.34u w=0.15u l=0.13u
X83 vp 3bit_to_8_outs_0.c0_n 3bit_to_8_outs_0.inverter_8.in vp sg13_lv_pmos ad=0.1005p pd=1.34u as=0.1005p ps=1.34u w=0.15u l=0.13u
X84 VCO3_selection_0.NAND_3in_4.y 100 vp vp sg13_lv_pmos ad=0.1005p pd=1.34u as=0.1005p ps=1.34u w=0.15u l=0.13u
X85 VCO3_selection_0.inverter_4.in after_001111 vp vp sg13_lv_pmos ad=0.1005p pd=1.34u as=0.1005p ps=1.34u w=0.15u l=0.13u
X86 VCO4_selection_0.NOR_2in_0.b VCO4_selection_0.inverter_1.in vp vp sg13_lv_pmos ad=0.1005p pd=1.34u as=0.1005p ps=1.34u w=0.15u l=0.13u
X87 a_31060_44464# after_001111_n gd gd sg13_lv_nmos ad=0.1005p pd=1.34u as=0.1005p ps=1.34u w=0.15u l=0.13u
X88 vp after_000111 VCO_selection_0.NAND_2in_1.y vp sg13_lv_pmos ad=0.1005p pd=1.34u as=0.1005p ps=1.34u w=0.15u l=0.13u
X89 VCO2_selection_0.NAND_3in_7.y after_000111_n vp vp sg13_lv_pmos ad=0.1005p pd=1.34u as=0.1005p ps=1.34u w=0.15u l=0.13u
X90 VCO2_selection_0.inverter_4.out VCO2_selection_0.NOR_2in_0.y vp vp sg13_lv_pmos ad=0.1005p pd=1.34u as=0.1005p ps=1.34u w=0.15u l=0.13u
X91 VCO4_selection_0.inverter_2.out VCO4_selection_0.inverter_2.in gd gd sg13_lv_nmos ad=0.1005p pd=1.34u as=0.1005p ps=1.34u w=0.15u l=0.13u
X92 vp 100 VCO3_selection_0.NAND_2in_1.y vp sg13_lv_pmos ad=0.1005p pd=1.34u as=0.1005p ps=1.34u w=0.15u l=0.13u
X93 VCO3_selection_0.XNOR_0._a f0 gd gd sg13_lv_nmos ad=0.1005p pd=1.34u as=0.1005p ps=1.34u w=0.15u l=0.13u
X94 vp after_000111 VCO3_selection_0.NAND_3in_5.y vp sg13_lv_pmos ad=0.1005p pd=1.34u as=0.1005p ps=1.34u w=0.15u l=0.13u
X95 vp VCO4_selection_0.inverter_5.out VCO4_selection_0.NAND_3in_2.y vp sg13_lv_pmos ad=0.1005p pd=1.34u as=0.1005p ps=1.34u w=0.15u l=0.13u
X96 VCO2_selection_0.NAND_2in_0.y after_001111 vp vp sg13_lv_pmos ad=0.1005p pd=1.34u as=0.1005p ps=1.34u w=0.15u l=0.13u
X97 VCO3_selection_0.inverter_1.out VCO3_selection_0.NAND_2in_1.y gd gd sg13_lv_nmos ad=0.1005p pd=1.34u as=0.1005p ps=1.34u w=0.15u l=0.13u
X98 VCO4_selection_0.inverter_3.in 001 a_31276_45946# gd sg13_lv_nmos ad=0.1005p pd=1.34u as=0.1005p ps=1.34u w=0.15u l=0.13u
X99 a_32052_47400# VCO4_selection_0.XNOR_1._a vp vp sg13_lv_pmos ad=0.204p pd=1.88u as=0.204p ps=1.88u w=0.6u l=0.13u
X100 VCO2_selection_0.NAND_3in_7.y 110 a_31623_30284# gd sg13_lv_nmos ad=0.1005p pd=1.34u as=0.1005p ps=1.34u w=0.15u l=0.13u
X101 VCO2_selection_0.NAND_3in_3.c VCO2_selection_0.XNOR_0._b a_32399_31170# vp sg13_lv_pmos ad=0.204p pd=1.88u as=0.204p ps=1.88u w=0.6u l=0.13u
X102 VCO3_selection_0.inverter_12.out VCO3_selection_0.XNOR_1.y gd gd sg13_lv_nmos ad=0.1005p pd=1.34u as=0.1005p ps=1.34u w=0.15u l=0.13u
X103 a_33068_41518# VCO3_selection_0.NOR_2in_4.a vp vp sg13_lv_pmos ad=0.1005p pd=1.34u as=0.1005p ps=1.34u w=0.15u l=0.13u
X104 gd c2 3bit_to_8_outs_0.c2_n gd sg13_lv_nmos ad=0.1005p pd=1.34u as=0.1005p ps=1.34u w=0.15u l=0.13u
X105 gd c0 3bit_to_8_outs_0.c0_n gd sg13_lv_nmos ad=0.1005p pd=1.34u as=0.1005p ps=1.34u w=0.15u l=0.13u
X106 a_32152_32714# f5_n gd gd sg13_lv_nmos ad=0.1005p pd=1.34u as=0.1005p ps=1.34u w=0.15u l=0.13u
X107 a_31315_29201# f0 vp vp sg13_lv_pmos ad=0.204p pd=1.88u as=0.204p ps=1.88u w=0.6u l=0.13u
X108 VCO2_selection_0.NAND_4in_0.c f5 vp vp sg13_lv_pmos ad=0.1005p pd=1.34u as=0.1005p ps=1.34u w=0.15u l=0.13u
X109 a_33486_41044# VCO3_selection_0.inverter_7.out vp vp sg13_lv_pmos ad=0.1005p pd=1.34u as=0.1005p ps=1.34u w=0.15u l=0.13u
X110 VCO3_selection_0.NAND_3in_3.y after_000111_n vp vp sg13_lv_pmos ad=0.1005p pd=1.34u as=0.1005p ps=1.34u w=0.15u l=0.13u
X111 VCO3_selection_0.XNOR_0._b f1 vp vp sg13_lv_pmos ad=0.1005p pd=1.34u as=0.1005p ps=1.34u w=0.15u l=0.13u
X112 VCO4_selection_0.inverter_5.out VCO4_selection_0.inverter_5.in vp vp sg13_lv_pmos ad=0.1005p pd=1.34u as=0.1005p ps=1.34u w=0.15u l=0.13u
X113 row_section_decoding_0.NAND_2in_0.b f5 a_31510_22377# vp sg13_lv_pmos ad=0.1005p pd=1.34u as=0.1005p ps=1.34u w=0.15u l=0.13u
X114 VCO2_selection_0.NAND_3in_3.y 110 vp vp sg13_lv_pmos ad=0.1005p pd=1.34u as=0.1005p ps=1.34u w=0.15u l=0.13u
X115 VCO2_selection_0.inverter_1.out VCO2_selection_0.inverter_1.in vp vp sg13_lv_pmos ad=0.1005p pd=1.34u as=0.1005p ps=1.34u w=0.15u l=0.13u
X116 a_32468_40540# after_000011_n a_32252_40540# gd sg13_lv_nmos ad=0.1005p pd=1.34u as=0.1005p ps=1.34u w=0.15u l=0.13u
X117 VCO4_selection_0.NOR_2in_1.a VCO4_selection_0.inverter_4.in gd gd sg13_lv_nmos ad=0.1005p pd=1.34u as=0.1005p ps=1.34u w=0.15u l=0.13u
X118 VCO4_selection_0.inverter_1.in VCO4_selection_0.inverter_3.out a_32494_44968# vp sg13_lv_pmos ad=0.1005p pd=1.34u as=0.1005p ps=1.34u w=0.15u l=0.13u
X119 a_31410_25172# c0 3bit_to_8_outs_0.NAND_3in_3.y gd sg13_lv_nmos ad=0.1005p pd=1.34u as=0.1005p ps=1.34u w=0.15u l=0.13u
X120 gd 3bit_to_8_outs_0.inverter_1.in 110 gd sg13_lv_nmos ad=0.1005p pd=1.34u as=0.1005p ps=1.34u w=0.15u l=0.13u
X121 a_31788_42496# after_000111 a_31572_42496# gd sg13_lv_nmos ad=0.1005p pd=1.34u as=0.1005p ps=1.34u w=0.15u l=0.13u
X122 a_31410_26816# c0 3bit_to_8_outs_0.NAND_3in_2.y gd sg13_lv_nmos ad=0.1005p pd=1.34u as=0.1005p ps=1.34u w=0.15u l=0.13u
X123 vp row_section_decoding_0.NAND_2in_0.a after_000011 vp sg13_lv_pmos ad=0.1005p pd=1.34u as=0.1005p ps=1.34u w=0.15u l=0.13u
X124 vp after_000011 VCO3_selection_0.NAND_3in_1.y vp sg13_lv_pmos ad=0.1005p pd=1.34u as=0.1005p ps=1.34u w=0.15u l=0.13u
X125 a_32258_36164# after_000011_n gd gd sg13_lv_nmos ad=0.1005p pd=1.34u as=0.1005p ps=1.34u w=0.15u l=0.13u
X126 VCO_sel VCO_selection_0.NAND_2in_1.y a_31476_49868# gd sg13_lv_nmos ad=0.1005p pd=1.34u as=0.1005p ps=1.34u w=0.15u l=0.13u
X127 after_001111_n f5 a_31986_22377# vp sg13_lv_pmos ad=0.1005p pd=1.34u as=0.1005p ps=1.34u w=0.15u l=0.13u
X128 a_32828_32714# VCO2_selection_0.NAND_4in_0.d gd gd sg13_lv_nmos ad=0.1005p pd=1.34u as=0.1005p ps=1.34u w=0.15u l=0.13u
X129 VCO2_selection_0.inverter_1.in f5_n vp vp sg13_lv_pmos ad=0.1005p pd=1.34u as=0.1005p ps=1.34u w=0.15u l=0.13u
X130 gd VCO3_selection_0.inverter_4.out VCO3_selection_0.NOR_2in_0.y gd sg13_lv_nmos ad=0.1005p pd=1.34u as=0.1005p ps=1.34u w=0.15u l=0.13u
X131 VCO3_selection_0.inverter_5.out VCO3_selection_0.NAND_3in_3.y gd gd sg13_lv_nmos ad=0.1005p pd=1.34u as=0.1005p ps=1.34u w=0.15u l=0.13u
X132 VCO3_selection_0.NAND_3in_7.c f0 a_32110_38594# gd sg13_lv_nmos ad=0.1005p pd=1.34u as=0.1005p ps=1.34u w=0.15u l=0.13u
X133 a_33373_34670# VCO2_selection_0.NAND_3in_5.c gd gd sg13_lv_nmos ad=0.1005p pd=1.34u as=0.1005p ps=1.34u w=0.15u l=0.13u
X134 a_31266_50186# 111 gd gd sg13_lv_nmos ad=0.1005p pd=1.34u as=0.1005p ps=1.34u w=0.15u l=0.13u
X135 VCO4_selection_0.NOR_2in_0.b VCO4_selection_0.inverter_1.in gd gd sg13_lv_nmos ad=0.1005p pd=1.34u as=0.1005p ps=1.34u w=0.15u l=0.13u
X136 VCO3_selection_0.NAND_2in_0.y 001 a_31572_42022# gd sg13_lv_nmos ad=0.1005p pd=1.34u as=0.1005p ps=1.34u w=0.15u l=0.13u
X137 VCO5_selection_0.inverter_2.in VCO5_selection_0.XNOR_0._b a_31775_29201# vp sg13_lv_pmos ad=0.204p pd=1.88u as=0.204p ps=1.88u w=0.6u l=0.13u
X138 VCO3_11_sel VCO3_selection_0.NOR_2in_0.y a_33692_38120# gd sg13_lv_nmos ad=0.1005p pd=1.34u as=0.1005p ps=1.34u w=0.15u l=0.13u
X139 a_32058_47902# f1 gd gd sg13_lv_nmos ad=0.1005p pd=1.34u as=0.1005p ps=1.34u w=0.15u l=0.13u
X140 vp c2 3bit_to_8_outs_0.inverter_1.in vp sg13_lv_pmos ad=0.1005p pd=1.34u as=0.1005p ps=1.34u w=0.15u l=0.13u
X141 vp 3bit_to_8_outs_0.NAND_3in_2.y 001 vp sg13_lv_pmos ad=0.1005p pd=1.34u as=0.1005p ps=1.34u w=0.15u l=0.13u
X142 VCO3_selection_0.NAND_3in_7.y 011 vp vp sg13_lv_pmos ad=0.1005p pd=1.34u as=0.1005p ps=1.34u w=0.15u l=0.13u
X143 a_31956_45946# after_000011 a_31740_45946# gd sg13_lv_nmos ad=0.1005p pd=1.34u as=0.1005p ps=1.34u w=0.15u l=0.13u
X144 a_31626_24854# c1 a_31410_24854# gd sg13_lv_nmos ad=0.1005p pd=1.34u as=0.1005p ps=1.34u w=0.15u l=0.13u
X145 VCO5_selection_0.inverter_0.out VCO5_selection_0.inverter_0.in vp vp sg13_lv_pmos ad=0.1005p pd=1.34u as=0.1005p ps=1.34u w=0.15u l=0.13u
X146 VCO3_selection_0.NAND_3in_4.y 100 a_31788_40540# gd sg13_lv_nmos ad=0.1005p pd=1.34u as=0.1005p ps=1.34u w=0.15u l=0.13u
X147 VCO3_selection_0.NOR_2in_4.b VCO3_selection_0.NAND_2in_3.y gd gd sg13_lv_nmos ad=0.1005p pd=1.34u as=0.1005p ps=1.34u w=0.15u l=0.13u
X148 gd c2 a_32306_25172# gd sg13_lv_nmos ad=0.1005p pd=1.34u as=0.1005p ps=1.34u w=0.15u l=0.13u
X149 VCO4_selection_0.inverter_4.in 001 a_31276_46420# gd sg13_lv_nmos ad=0.1005p pd=1.34u as=0.1005p ps=1.34u w=0.15u l=0.13u
X150 VCO_selection_0.NAND_2in_2.y f5 vp vp sg13_lv_pmos ad=0.1005p pd=1.34u as=0.1005p ps=1.34u w=0.15u l=0.13u
X151 gd 3bit_to_8_outs_0.c2_n a_32306_26816# gd sg13_lv_nmos ad=0.1005p pd=1.34u as=0.1005p ps=1.34u w=0.15u l=0.13u
X152 gd f3 row_section_decoding_0.NAND_2in_0.a gd sg13_lv_nmos ad=0.1005p pd=1.34u as=0.1005p ps=1.34u w=0.15u l=0.13u
X153 vp 3bit_to_8_outs_0.inverter_10.in 011 vp sg13_lv_pmos ad=0.1005p pd=1.34u as=0.1005p ps=1.34u w=0.15u l=0.13u
X154 a_32087_30284# VCO2_selection_0.NAND_3in_3.c gd gd sg13_lv_nmos ad=0.1005p pd=1.34u as=0.1005p ps=1.34u w=0.15u l=0.13u
X155 VCO2_selection_0.XNOR_0._b f1 gd gd sg13_lv_nmos ad=0.1005p pd=1.34u as=0.1005p ps=1.34u w=0.15u l=0.13u
X156 a_32058_48376# f1 gd gd sg13_lv_nmos ad=0.1005p pd=1.34u as=0.1005p ps=1.34u w=0.15u l=0.13u
X157 a_31572_36638# f5_n gd gd sg13_lv_nmos ad=0.1005p pd=1.34u as=0.1005p ps=1.34u w=0.15u l=0.13u
X158 a_32093_32240# after_000011 a_31877_32240# gd sg13_lv_nmos ad=0.1005p pd=1.34u as=0.1005p ps=1.34u w=0.15u l=0.13u
X159 3bit_to_8_outs_0.NAND_3in_2.y 3bit_to_8_outs_0.c1_n vp vp sg13_lv_pmos ad=0.1005p pd=1.34u as=0.1005p ps=1.34u w=0.15u l=0.13u
X160 VCO2_selection_0.NOR_2in_0.a VCO2_selection_0.NAND_3in_3.y gd gd sg13_lv_nmos ad=0.1005p pd=1.34u as=0.1005p ps=1.34u w=0.15u l=0.13u
X161 after_000011_n after_000011 gd gd sg13_lv_nmos ad=0.1005p pd=1.34u as=0.1005p ps=1.34u w=0.15u l=0.13u
X162 VCO4_selection_0.NAND_3in_0.y f1 vp vp sg13_lv_pmos ad=0.1005p pd=1.34u as=0.1005p ps=1.34u w=0.15u l=0.13u
X163 VCO_selection_0.NAND_2in_0.y after_001111 a_30790_49868# gd sg13_lv_nmos ad=0.1005p pd=1.34u as=0.1005p ps=1.34u w=0.15u l=0.13u
X164 VCO4_selection_0.inverter_0.out VCO4_selection_0.NAND_3in_0.y vp vp sg13_lv_pmos ad=0.1005p pd=1.34u as=0.1005p ps=1.34u w=0.15u l=0.13u
X165 gd f5 row_section_decoding_0.NAND_2in_0.b gd sg13_lv_nmos ad=0.1005p pd=1.34u as=0.1005p ps=1.34u w=0.15u l=0.13u
X166 after_001111 after_001111_n gd gd sg13_lv_nmos ad=0.1005p pd=1.34u as=0.1005p ps=1.34u w=0.15u l=0.13u
X167 VCO3_selection_0.NAND_3in_6.c VCO3_selection_0.inverter_7.out gd gd sg13_lv_nmos ad=0.1005p pd=1.34u as=0.1005p ps=1.34u w=0.15u l=0.13u
X168 VCO4_selection_0.inverter_5.in f1 a_31592_47400# vp sg13_lv_pmos ad=0.204p pd=1.88u as=0.204p ps=1.88u w=0.6u l=0.13u
X169 VCO2_selection_0.inverter_6.out VCO2_selection_0.NAND_3in_4.y vp vp sg13_lv_pmos ad=0.1005p pd=1.34u as=0.1005p ps=1.34u w=0.15u l=0.13u
X170 VCO4_selection_0.inverter_2.in 000 vp vp sg13_lv_pmos ad=0.1005p pd=1.34u as=0.1005p ps=1.34u w=0.15u l=0.13u
X171 VCO3_selection_0.XNOR_0._b f1 gd gd sg13_lv_nmos ad=0.1005p pd=1.34u as=0.1005p ps=1.34u w=0.15u l=0.13u
X172 a_31623_30284# after_000011 a_31407_30284# gd sg13_lv_nmos ad=0.1005p pd=1.34u as=0.1005p ps=1.34u w=0.15u l=0.13u
X173 a_32772_28789# VCO5_selection_0.inverter_2.out a_32556_28789# gd sg13_lv_nmos ad=0.1005p pd=1.34u as=0.1005p ps=1.34u w=0.15u l=0.13u
X174 a_31519_28315# after_000011_n a_31303_28315# gd sg13_lv_nmos ad=0.1005p pd=1.34u as=0.1005p ps=1.34u w=0.15u l=0.13u
X175 VCO2_selection_0.XNOR_0._a f0 vp vp sg13_lv_pmos ad=0.1005p pd=1.34u as=0.1005p ps=1.34u w=0.15u l=0.13u
X176 a_32018_44968# VCO4_selection_0.inverter_2.out vp vp sg13_lv_pmos ad=0.1005p pd=1.34u as=0.1005p ps=1.34u w=0.15u l=0.13u
X177 gd f5 after_001111_n gd sg13_lv_nmos ad=0.1005p pd=1.34u as=0.1005p ps=1.34u w=0.15u l=0.13u
X178 VCO3_selection_0.NAND_3in_6.b VCO3_selection_0.NOR_2in_4.a gd gd sg13_lv_nmos ad=0.1005p pd=1.34u as=0.1005p ps=1.34u w=0.15u l=0.13u
X179 3bit_to_8_outs_0.inverter_6.in 3bit_to_8_outs_0.c1_n vp vp sg13_lv_pmos ad=0.1005p pd=1.34u as=0.1005p ps=1.34u w=0.15u l=0.13u
X180 VCO2_5_sel VCO2_selection_0.NAND_4in_0.b vp vp sg13_lv_pmos ad=0.1005p pd=1.34u as=0.1005p ps=1.34u w=0.15u l=0.13u
X181 vp VCO4_selection_0.XNOR_0.y VCO4_selection_0.inverter_4.in vp sg13_lv_pmos ad=0.1005p pd=1.34u as=0.1005p ps=1.34u w=0.15u l=0.13u
X182 gd 3bit_to_8_outs_0.c2_n a_31626_26498# gd sg13_lv_nmos ad=0.1005p pd=1.34u as=0.1005p ps=1.34u w=0.15u l=0.13u
X183 VCO4_selection_0.NAND_2in_0.a VCO4_selection_0.inverter_0.out a_32018_44968# vp sg13_lv_pmos ad=0.1005p pd=1.34u as=0.1005p ps=1.34u w=0.15u l=0.13u
X184 a_32104_39564# f0 vp vp sg13_lv_pmos ad=0.204p pd=1.88u as=0.204p ps=1.88u w=0.6u l=0.13u
X185 a_31956_46420# VCO4_selection_0.inverter_5.out a_31740_46420# gd sg13_lv_nmos ad=0.1005p pd=1.34u as=0.1005p ps=1.34u w=0.15u l=0.13u
X186 a_31407_32240# f5 gd gd sg13_lv_nmos ad=0.1005p pd=1.34u as=0.1005p ps=1.34u w=0.15u l=0.13u
X187 vp c0 3bit_to_8_outs_0.NAND_3in_0.y vp sg13_lv_pmos ad=0.1005p pd=1.34u as=0.1005p ps=1.34u w=0.15u l=0.13u
X188 a_31572_38120# after_000111_n gd gd sg13_lv_nmos ad=0.1005p pd=1.34u as=0.1005p ps=1.34u w=0.15u l=0.13u
X189 VCO2_selection_0.NOR_2in_0.y VCO2_selection_0.NOR_2in_0.a gd gd sg13_lv_nmos ad=0.1005p pd=1.34u as=0.1005p ps=1.34u w=0.15u l=0.13u
X190 a_31510_22377# f4 vp vp sg13_lv_pmos ad=0.1005p pd=1.34u as=0.1005p ps=1.34u w=0.15u l=0.13u
X191 a_31939_31170# f0 vp vp sg13_lv_pmos ad=0.204p pd=1.88u as=0.204p ps=1.88u w=0.6u l=0.13u
X192 VCO3_selection_0.inverter_1.out VCO3_selection_0.NAND_2in_1.y vp vp sg13_lv_pmos ad=0.1005p pd=1.34u as=0.1005p ps=1.34u w=0.15u l=0.13u
X193 VCO4_selection_0.inverter_3.out VCO4_selection_0.inverter_3.in vp vp sg13_lv_pmos ad=0.1005p pd=1.34u as=0.1005p ps=1.34u w=0.15u l=0.13u
X194 VCO5_selection_0.inverter_1.out VCO5_selection_0.inverter_1.in gd gd sg13_lv_nmos ad=0.1005p pd=1.34u as=0.1005p ps=1.34u w=0.15u l=0.13u
X195 a_32110_38594# VCO3_selection_0.XNOR_0._b gd gd sg13_lv_nmos ad=0.1005p pd=1.34u as=0.1005p ps=1.34u w=0.15u l=0.13u
X196 a_31060_43990# f1 gd gd sg13_lv_nmos ad=0.1005p pd=1.34u as=0.1005p ps=1.34u w=0.15u l=0.13u
X197 VCO5_selection_0.inverter_1.in 000 a_30783_28315# gd sg13_lv_nmos ad=0.1005p pd=1.34u as=0.1005p ps=1.34u w=0.15u l=0.13u
X198 vp after_000011 VCO3_selection_0.NAND_3in_4.y vp sg13_lv_pmos ad=0.1005p pd=1.34u as=0.1005p ps=1.34u w=0.15u l=0.13u
X199 gd VCO4_selection_0.inverter_3.out VCO4_selection_0.inverter_1.in gd sg13_lv_nmos ad=0.1005p pd=1.34u as=0.1005p ps=1.34u w=0.15u l=0.13u
X200 gd VCO2_selection_0.inverter_0.out VCO2_selection_0.NOR_2in_1.y gd sg13_lv_nmos ad=0.1005p pd=1.34u as=0.1005p ps=1.34u w=0.15u l=0.13u
X201 VCO3_selection_0.NAND_3in_6.a VCO3_selection_0.inverter_10.out a_33484_43000# vp sg13_lv_pmos ad=0.1005p pd=1.34u as=0.1005p ps=1.34u w=0.15u l=0.13u
X202 VCO3_selection_0.XNOR_1.y VCO3_selection_0.XNOR_1._b a_32564_39564# vp sg13_lv_pmos ad=0.204p pd=1.88u as=0.204p ps=1.88u w=0.6u l=0.13u
X203 VCO3_selection_0.NAND_3in_9.y f5_n vp vp sg13_lv_pmos ad=0.1005p pd=1.34u as=0.1005p ps=1.34u w=0.15u l=0.13u
X204 VCO4_selection_0.inverter_0.out VCO4_selection_0.NAND_3in_0.y gd gd sg13_lv_nmos ad=0.1005p pd=1.34u as=0.1005p ps=1.34u w=0.15u l=0.13u
X205 VCO3_selection_0.NAND_3in_7.y 011 a_32468_38120# gd sg13_lv_nmos ad=0.1005p pd=1.34u as=0.1005p ps=1.34u w=0.15u l=0.13u
X206 VCO_selection_0.NAND_2in_1.y 111 vp vp sg13_lv_pmos ad=0.1005p pd=1.34u as=0.1005p ps=1.34u w=0.15u l=0.13u
X207 vp c0 3bit_to_8_outs_0.c0_n vp sg13_lv_pmos ad=0.1005p pd=1.34u as=0.1005p ps=1.34u w=0.15u l=0.13u
X208 after_000011 row_section_decoding_0.NAND_2in_0.a a_31250_23355# gd sg13_lv_nmos ad=0.1005p pd=1.34u as=0.1005p ps=1.34u w=0.15u l=0.13u
X209 VCO3_selection_0.inverter_10.out VCO3_selection_0.NAND_3in_9.y vp vp sg13_lv_pmos ad=0.1005p pd=1.34u as=0.1005p ps=1.34u w=0.15u l=0.13u
X210 a_31410_24854# 3bit_to_8_outs_0.c0_n 3bit_to_8_outs_0.inverter_1.in gd sg13_lv_nmos ad=0.1005p pd=1.34u as=0.1005p ps=1.34u w=0.15u l=0.13u
X211 VCO2_selection_0.NOR_2in_2.y VCO2_selection_0.NOR_2in_2.b a_32903_35174# vp sg13_lv_pmos ad=0.1005p pd=1.34u as=0.1005p ps=1.34u w=0.15u l=0.13u
X212 VCO3_selection_0.NAND_2in_1.y after_000011_n vp vp sg13_lv_pmos ad=0.1005p pd=1.34u as=0.1005p ps=1.34u w=0.15u l=0.13u
X213 VCO2_selection_0.NAND_4in_0.b 101 vp vp sg13_lv_pmos ad=0.1005p pd=1.34u as=0.1005p ps=1.34u w=0.15u l=0.13u
X214 a_32104_39006# f0 vp vp sg13_lv_pmos ad=0.204p pd=1.88u as=0.204p ps=1.88u w=0.6u l=0.13u
X215 VCO4_selection_0.inverter_3.in 001 vp vp sg13_lv_pmos ad=0.1005p pd=1.34u as=0.1005p ps=1.34u w=0.15u l=0.13u
X216 a_30990_22377# f5 a_30774_22377# vp sg13_lv_pmos ad=0.1005p pd=1.34u as=0.1005p ps=1.34u w=0.15u l=0.13u
X217 a_31781_28789# f1 gd gd sg13_lv_nmos ad=0.1005p pd=1.34u as=0.1005p ps=1.34u w=0.15u l=0.13u
X218 VCO3_selection_0.inverter_4.out VCO3_selection_0.inverter_4.in gd gd sg13_lv_nmos ad=0.1005p pd=1.34u as=0.1005p ps=1.34u w=0.15u l=0.13u
X219 a_31276_45946# after_000011 a_31060_45946# gd sg13_lv_nmos ad=0.1005p pd=1.34u as=0.1005p ps=1.34u w=0.15u l=0.13u
X220 VCO3_selection_0.XNOR_1._a f0 vp vp sg13_lv_pmos ad=0.1005p pd=1.34u as=0.1005p ps=1.34u w=0.15u l=0.13u
X221 a_32399_31170# VCO2_selection_0.XNOR_0._a vp vp sg13_lv_pmos ad=0.204p pd=1.88u as=0.204p ps=1.88u w=0.6u l=0.13u
X222 VCO2_selection_0.NOR_2in_2.a VCO2_selection_0.inverter_2.in vp vp sg13_lv_pmos ad=0.1005p pd=1.34u as=0.1005p ps=1.34u w=0.15u l=0.13u
X223 gd VCO2_selection_0.inverter_4.out VCO2_selection_0.NAND_3in_5.c gd sg13_lv_nmos ad=0.1005p pd=1.34u as=0.1005p ps=1.34u w=0.15u l=0.13u
X224 vp c0 3bit_to_8_outs_0.NAND_3in_2.y vp sg13_lv_pmos ad=0.1005p pd=1.34u as=0.1005p ps=1.34u w=0.15u l=0.13u
X225 VCO2_selection_0.NAND_3in_4.y after_000111_n vp vp sg13_lv_pmos ad=0.1005p pd=1.34u as=0.1005p ps=1.34u w=0.15u l=0.13u
X226 a_32090_26498# c0 3bit_to_8_outs_0.inverter_10.in gd sg13_lv_nmos ad=0.1005p pd=1.34u as=0.1005p ps=1.34u w=0.15u l=0.13u
X227 a_33561_40066# VCO3_selection_0.NAND_3in_6.b a_33345_40066# gd sg13_lv_nmos ad=0.1005p pd=1.34u as=0.1005p ps=1.34u w=0.15u l=0.13u
X228 VCO3_selection_0.NAND_3in_7.c VCO3_selection_0.XNOR_0._a a_32570_38594# gd sg13_lv_nmos ad=0.1005p pd=1.34u as=0.1005p ps=1.34u w=0.15u l=0.13u
X229 gd VCO3_selection_0.inverter_10.out VCO3_selection_0.NAND_3in_6.a gd sg13_lv_nmos ad=0.1005p pd=1.34u as=0.1005p ps=1.34u w=0.15u l=0.13u
X230 VCO3_selection_0.NOR_2in_0.y VCO3_selection_0.inverter_4.out a_33278_37142# vp sg13_lv_pmos ad=0.1005p pd=1.34u as=0.1005p ps=1.34u w=0.15u l=0.13u
X231 a_32252_42496# f5_n gd gd sg13_lv_nmos ad=0.1005p pd=1.34u as=0.1005p ps=1.34u w=0.15u l=0.13u
X232 row_section_decoding_0.NAND_2in_0.b f4 gd gd sg13_lv_nmos ad=0.1005p pd=1.34u as=0.1005p ps=1.34u w=0.15u l=0.13u
X233 gd c2 a_32306_24854# gd sg13_lv_nmos ad=0.1005p pd=1.34u as=0.1005p ps=1.34u w=0.15u l=0.13u
X234 vp 3bit_to_8_outs_0.inverter_1.in 110 vp sg13_lv_pmos ad=0.1005p pd=1.34u as=0.1005p ps=1.34u w=0.15u l=0.13u
X235 a_33260_32714# VCO2_selection_0.NAND_4in_0.b a_33044_32714# gd sg13_lv_nmos ad=0.1005p pd=1.34u as=0.1005p ps=1.34u w=0.15u l=0.13u
X236 VCO3_selection_0.inverter_10.out VCO3_selection_0.NAND_3in_9.y gd gd sg13_lv_nmos ad=0.1005p pd=1.34u as=0.1005p ps=1.34u w=0.15u l=0.13u
X237 VCO5_selection_0.NAND_2in_0.b 010 a_31519_28315# gd sg13_lv_nmos ad=0.1005p pd=1.34u as=0.1005p ps=1.34u w=0.15u l=0.13u
X238 VCO3_selection_0.NAND_3in_7.c VCO3_selection_0.XNOR_0._b a_32564_39006# vp sg13_lv_pmos ad=0.204p pd=1.88u as=0.204p ps=1.88u w=0.6u l=0.13u
X239 VCO2_11_sel VCO2_selection_0.NOR_2in_1.y vp vp sg13_lv_pmos ad=0.1005p pd=1.34u as=0.1005p ps=1.34u w=0.15u l=0.13u
X240 VCO_sel VCO_selection_0.NAND_2in_1.y vp vp sg13_lv_pmos ad=0.1005p pd=1.34u as=0.1005p ps=1.34u w=0.15u l=0.13u
X241 VCO2_selection_0.inverter_6.out VCO2_selection_0.NAND_3in_4.y gd gd sg13_lv_nmos ad=0.1005p pd=1.34u as=0.1005p ps=1.34u w=0.15u l=0.13u
X242 VCO2_selection_0.inverter_0.out VCO2_selection_0.NAND_2in_0.y gd gd sg13_lv_nmos ad=0.1005p pd=1.34u as=0.1005p ps=1.34u w=0.15u l=0.13u
X243 VCO2_selection_0.NAND_3in_3.c f0 a_31945_30758# gd sg13_lv_nmos ad=0.1005p pd=1.34u as=0.1005p ps=1.34u w=0.15u l=0.13u
X244 a_31476_49868# VCO_selection_0.NAND_2in_0.y a_31260_49868# gd sg13_lv_nmos ad=0.1005p pd=1.34u as=0.1005p ps=1.34u w=0.15u l=0.13u
X245 VCO3_selection_0.NOR_2in_0.y VCO3_selection_0.inverter_3.out gd gd sg13_lv_nmos ad=0.1005p pd=1.34u as=0.1005p ps=1.34u w=0.15u l=0.13u
X246 vp 3bit_to_8_outs_0.c2_n 3bit_to_8_outs_0.inverter_8.in vp sg13_lv_pmos ad=0.1005p pd=1.34u as=0.1005p ps=1.34u w=0.15u l=0.13u
X247 gd VCO2_selection_0.NOR_2in_0.b VCO2_selection_0.NOR_2in_0.y gd sg13_lv_nmos ad=0.1005p pd=1.34u as=0.1005p ps=1.34u w=0.15u l=0.13u
X248 vp after_000011 VCO4_selection_0.NAND_3in_1.y vp sg13_lv_pmos ad=0.1005p pd=1.34u as=0.1005p ps=1.34u w=0.15u l=0.13u
X249 VCO2_selection_0.XNOR_0._b f1 vp vp sg13_lv_pmos ad=0.1005p pd=1.34u as=0.1005p ps=1.34u w=0.15u l=0.13u
X250 VCO3_selection_0.NAND_3in_2.y f5_n vp vp sg13_lv_pmos ad=0.1005p pd=1.34u as=0.1005p ps=1.34u w=0.15u l=0.13u
X251 VCO4_selection_0.inverter_2.in 000 a_31276_44464# gd sg13_lv_nmos ad=0.1005p pd=1.34u as=0.1005p ps=1.34u w=0.15u l=0.13u
X252 3bit_to_8_outs_0.inverter_1.in c1 vp vp sg13_lv_pmos ad=0.1005p pd=1.34u as=0.1005p ps=1.34u w=0.15u l=0.13u
X253 vp after_000011_n VCO3_selection_0.NAND_3in_7.y vp sg13_lv_pmos ad=0.1005p pd=1.34u as=0.1005p ps=1.34u w=0.15u l=0.13u
X254 VCO2_selection_0.NAND_4in_0.d after_000111_n vp vp sg13_lv_pmos ad=0.1005p pd=1.34u as=0.1005p ps=1.34u w=0.15u l=0.13u
X255 a_33085_39098# VCO3_selection_0.inverter_0.out vp vp sg13_lv_pmos ad=0.1005p pd=1.34u as=0.1005p ps=1.34u w=0.15u l=0.13u
X256 vp 101 VCO3_selection_0.NAND_2in_3.y vp sg13_lv_pmos ad=0.1005p pd=1.34u as=0.1005p ps=1.34u w=0.15u l=0.13u
X257 VCO4_selection_0.NAND_2in_0.a VCO4_selection_0.inverter_2.out gd gd sg13_lv_nmos ad=0.1005p pd=1.34u as=0.1005p ps=1.34u w=0.15u l=0.13u
X258 gd f5 after_000111_n gd sg13_lv_nmos ad=0.1005p pd=1.34u as=0.1005p ps=1.34u w=0.15u l=0.13u
X259 vp after_000011_n VCO5_selection_0.NAND_2in_0.b vp sg13_lv_pmos ad=0.1005p pd=1.34u as=0.1005p ps=1.34u w=0.15u l=0.13u
X260 VCO2_selection_0.inverter_3.in after_000011_n vp vp sg13_lv_pmos ad=0.1005p pd=1.34u as=0.1005p ps=1.34u w=0.15u l=0.13u
X261 a_31788_40540# after_000011 a_31572_40540# gd sg13_lv_nmos ad=0.1005p pd=1.34u as=0.1005p ps=1.34u w=0.15u l=0.13u
X262 a_32306_25172# 3bit_to_8_outs_0.c1_n a_32090_25172# gd sg13_lv_nmos ad=0.1005p pd=1.34u as=0.1005p ps=1.34u w=0.15u l=0.13u
X263 a_32052_48788# VCO4_selection_0.XNOR_0._a vp vp sg13_lv_pmos ad=0.204p pd=1.88u as=0.204p ps=1.88u w=0.6u l=0.13u
X264 a_31276_46420# VCO4_selection_0.XNOR_0.y a_31060_46420# gd sg13_lv_nmos ad=0.1005p pd=1.34u as=0.1005p ps=1.34u w=0.15u l=0.13u
X265 gd VCO4_selection_0.inverter_0.out VCO4_selection_0.NAND_2in_0.a gd sg13_lv_nmos ad=0.1005p pd=1.34u as=0.1005p ps=1.34u w=0.15u l=0.13u
X266 a_32306_26816# 3bit_to_8_outs_0.c1_n a_32090_26816# gd sg13_lv_nmos ad=0.1005p pd=1.34u as=0.1005p ps=1.34u w=0.15u l=0.13u
X267 vp 3bit_to_8_outs_0.inverter_6.in 100 vp sg13_lv_pmos ad=0.1005p pd=1.34u as=0.1005p ps=1.34u w=0.15u l=0.13u
X268 vp 3bit_to_8_outs_0.c2_n 3bit_to_8_outs_0.NAND_3in_6.y vp sg13_lv_pmos ad=0.1005p pd=1.34u as=0.1005p ps=1.34u w=0.15u l=0.13u
X269 gd VCO2_selection_0.NOR_2in_2.b VCO2_selection_0.NOR_2in_2.y gd sg13_lv_nmos ad=0.1005p pd=1.34u as=0.1005p ps=1.34u w=0.15u l=0.13u
X270 a_32570_40066# f1 gd gd sg13_lv_nmos ad=0.1005p pd=1.34u as=0.1005p ps=1.34u w=0.15u l=0.13u
X271 VCO2_selection_0.NAND_4in_0.b 101 a_32368_32714# gd sg13_lv_nmos ad=0.1005p pd=1.34u as=0.1005p ps=1.34u w=0.15u l=0.13u
X272 gd VCO3_selection_0.inverter_2.out VCO3_selection_0.NOR_2in_1.y gd sg13_lv_nmos ad=0.1005p pd=1.34u as=0.1005p ps=1.34u w=0.15u l=0.13u
X273 vp after_001111 VCO_selection_0.NAND_2in_0.y vp sg13_lv_pmos ad=0.1005p pd=1.34u as=0.1005p ps=1.34u w=0.15u l=0.13u
X274 vp VCO4_selection_0.NAND_2in_0.a VCO4_5_sel vp sg13_lv_pmos ad=0.1005p pd=1.34u as=0.1005p ps=1.34u w=0.15u l=0.13u
X275 VCO2_selection_0.NOR_2in_1.y VCO2_selection_0.inverter_1.out gd gd sg13_lv_nmos ad=0.1005p pd=1.34u as=0.1005p ps=1.34u w=0.15u l=0.13u
X276 vp VCO5_selection_0.inverter_2.out VCO5_selection_0.inverter_0.in vp sg13_lv_pmos ad=0.1005p pd=1.34u as=0.1005p ps=1.34u w=0.15u l=0.13u
X277 VCO3_selection_0.NAND_3in_3.y 011 vp vp sg13_lv_pmos ad=0.1005p pd=1.34u as=0.1005p ps=1.34u w=0.15u l=0.13u
X278 VCO5_selection_0.inverter_1.out VCO5_selection_0.inverter_1.in vp vp sg13_lv_pmos ad=0.1005p pd=1.34u as=0.1005p ps=1.34u w=0.15u l=0.13u
X279 gd 3bit_to_8_outs_0.NAND_3in_6.y 010 gd sg13_lv_nmos ad=0.1005p pd=1.34u as=0.1005p ps=1.34u w=0.15u l=0.13u
X280 VCO2_selection_0.NOR_2in_2.a VCO2_selection_0.inverter_2.in gd gd sg13_lv_nmos ad=0.1005p pd=1.34u as=0.1005p ps=1.34u w=0.15u l=0.13u
X281 VCO3_5_sel VCO3_selection_0.NAND_3in_6.c vp vp sg13_lv_pmos ad=0.1005p pd=1.34u as=0.1005p ps=1.34u w=0.15u l=0.13u
X282 gd VCO5_selection_0.inverter_1.out VCO5_selection_0.NOR_2in_0.y gd sg13_lv_nmos ad=0.1005p pd=1.34u as=0.1005p ps=1.34u w=0.15u l=0.13u
X283 VCO4_selection_0.XNOR_1._a f0 gd gd sg13_lv_nmos ad=0.1005p pd=1.34u as=0.1005p ps=1.34u w=0.15u l=0.13u
X284 vp after_000111 VCO4_selection_0.inverter_2.in vp sg13_lv_pmos ad=0.1005p pd=1.34u as=0.1005p ps=1.34u w=0.15u l=0.13u
X285 vp 000 VCO5_selection_0.inverter_1.in vp sg13_lv_pmos ad=0.1005p pd=1.34u as=0.1005p ps=1.34u w=0.15u l=0.13u
X286 a_31407_30284# after_000111_n gd gd sg13_lv_nmos ad=0.1005p pd=1.34u as=0.1005p ps=1.34u w=0.15u l=0.13u
X287 a_32556_28789# after_000011_n gd gd sg13_lv_nmos ad=0.1005p pd=1.34u as=0.1005p ps=1.34u w=0.15u l=0.13u
X288 VCO2_selection_0.NOR_2in_1.y VCO2_selection_0.inverter_0.out a_33113_33692# vp sg13_lv_pmos ad=0.1005p pd=1.34u as=0.1005p ps=1.34u w=0.15u l=0.13u
X289 a_31572_36164# after_000111_n gd gd sg13_lv_nmos ad=0.1005p pd=1.34u as=0.1005p ps=1.34u w=0.15u l=0.13u
X290 VCO3_selection_0.inverter_11.out VCO3_selection_0.NAND_3in_5.y vp vp sg13_lv_pmos ad=0.1005p pd=1.34u as=0.1005p ps=1.34u w=0.15u l=0.13u
X291 VCO4_selection_0.NOR_2in_0.a VCO4_selection_0.NAND_3in_2.y vp vp sg13_lv_pmos ad=0.1005p pd=1.34u as=0.1005p ps=1.34u w=0.15u l=0.13u
X292 VCO2_selection_0.NAND_2in_0.y 011 a_32093_34196# gd sg13_lv_nmos ad=0.1005p pd=1.34u as=0.1005p ps=1.34u w=0.15u l=0.13u
X293 VCO3_selection_0.XNOR_1._b f1 vp vp sg13_lv_pmos ad=0.1005p pd=1.34u as=0.1005p ps=1.34u w=0.15u l=0.13u
X294 a_31626_26498# c1 a_31410_26498# gd sg13_lv_nmos ad=0.1005p pd=1.34u as=0.1005p ps=1.34u w=0.15u l=0.13u
X295 a_32563_32240# after_000111_n gd gd sg13_lv_nmos ad=0.1005p pd=1.34u as=0.1005p ps=1.34u w=0.15u l=0.13u
X296 VCO2_11_sel VCO2_selection_0.NOR_2in_1.y a_33589_34670# gd sg13_lv_nmos ad=0.1005p pd=1.34u as=0.1005p ps=1.34u w=0.15u l=0.13u
X297 VCO4_selection_0.XNOR_0._a f0 gd gd sg13_lv_nmos ad=0.1005p pd=1.34u as=0.1005p ps=1.34u w=0.15u l=0.13u
X298 VCO5_selection_0.XNOR_0._a f0 gd gd sg13_lv_nmos ad=0.1005p pd=1.34u as=0.1005p ps=1.34u w=0.15u l=0.13u
X299 a_31986_22377# f4 vp vp sg13_lv_pmos ad=0.1005p pd=1.34u as=0.1005p ps=1.34u w=0.15u l=0.13u
X300 VCO3_5_sel VCO3_selection_0.NAND_3in_6.a vp vp sg13_lv_pmos ad=0.1005p pd=1.34u as=0.1005p ps=1.34u w=0.15u l=0.13u
X301 vp c0 3bit_to_8_outs_0.inverter_10.in vp sg13_lv_pmos ad=0.1005p pd=1.34u as=0.1005p ps=1.34u w=0.15u l=0.13u
X302 vp VCO3_selection_0.NOR_2in_1.y VCO3_11_sel vp sg13_lv_pmos ad=0.1005p pd=1.34u as=0.1005p ps=1.34u w=0.15u l=0.13u
X303 VCO2_selection_0.NAND_3in_3.y 110 a_32303_30284# gd sg13_lv_nmos ad=0.1005p pd=1.34u as=0.1005p ps=1.34u w=0.15u l=0.13u
X304 VCO3_selection_0.NAND_3in_8.y VCO3_selection_0.inverter_12.out vp vp sg13_lv_pmos ad=0.1005p pd=1.34u as=0.1005p ps=1.34u w=0.15u l=0.13u
X305 VCO3_selection_0.NAND_2in_0.y f5 vp vp sg13_lv_pmos ad=0.1005p pd=1.34u as=0.1005p ps=1.34u w=0.15u l=0.13u
X306 a_30774_23859# f2 vp vp sg13_lv_pmos ad=0.1005p pd=1.34u as=0.1005p ps=1.34u w=0.15u l=0.13u
X307 VCO3_selection_0.NAND_3in_2.y 001 a_31788_36638# gd sg13_lv_nmos ad=0.1005p pd=1.34u as=0.1005p ps=1.34u w=0.15u l=0.13u
X308 VCO3_selection_0.NAND_3in_0.c VCO3_selection_0.inverter_0.out gd gd sg13_lv_nmos ad=0.1005p pd=1.34u as=0.1005p ps=1.34u w=0.15u l=0.13u
X309 a_31883_34670# after_000011_n gd gd sg13_lv_nmos ad=0.1005p pd=1.34u as=0.1005p ps=1.34u w=0.15u l=0.13u
X310 VCO3_selection_0.inverter_4.out VCO3_selection_0.inverter_4.in vp vp sg13_lv_pmos ad=0.1005p pd=1.34u as=0.1005p ps=1.34u w=0.15u l=0.13u
X311 VCO3_selection_0.inverter_8.out VCO3_selection_0.NAND_3in_8.y vp vp sg13_lv_pmos ad=0.1005p pd=1.34u as=0.1005p ps=1.34u w=0.15u l=0.13u
X312 VCO4_5_sel VCO4_selection_0.NAND_2in_0.a a_32494_43990# gd sg13_lv_nmos ad=0.1005p pd=1.34u as=0.1005p ps=1.34u w=0.15u l=0.13u
X313 VCO3_selection_0.inverter_11.out VCO3_selection_0.NAND_3in_5.y gd gd sg13_lv_nmos ad=0.1005p pd=1.34u as=0.1005p ps=1.34u w=0.15u l=0.13u
X314 VCO4_selection_0.NAND_3in_0.y 010 vp vp sg13_lv_pmos ad=0.1005p pd=1.34u as=0.1005p ps=1.34u w=0.15u l=0.13u
X315 vp 3bit_to_8_outs_0.c0_n 3bit_to_8_outs_0.inverter_1.in vp sg13_lv_pmos ad=0.1005p pd=1.34u as=0.1005p ps=1.34u w=0.15u l=0.13u
X316 VCO5_selection_0.NAND_2in_0.b 010 vp vp sg13_lv_pmos ad=0.1005p pd=1.34u as=0.1005p ps=1.34u w=0.15u l=0.13u
X317 VCO2_selection_0.NAND_3in_5.c VCO2_selection_0.inverter_4.out a_32920_31262# vp sg13_lv_pmos ad=0.1005p pd=1.34u as=0.1005p ps=1.34u w=0.15u l=0.13u
X318 a_32468_38120# after_000011_n a_32252_38120# gd sg13_lv_nmos ad=0.1005p pd=1.34u as=0.1005p ps=1.34u w=0.15u l=0.13u
X319 a_31877_32240# after_000111_n gd gd sg13_lv_nmos ad=0.1005p pd=1.34u as=0.1005p ps=1.34u w=0.15u l=0.13u
X320 VCO4_selection_0.XNOR_0.y f1 a_31592_48788# vp sg13_lv_pmos ad=0.204p pd=1.88u as=0.204p ps=1.88u w=0.6u l=0.13u
X321 a_32018_43486# VCO4_selection_0.NOR_2in_0.a vp vp sg13_lv_pmos ad=0.1005p pd=1.34u as=0.1005p ps=1.34u w=0.15u l=0.13u
X322 VCO2_selection_0.NAND_4in_0.a 110 vp vp sg13_lv_pmos ad=0.1005p pd=1.34u as=0.1005p ps=1.34u w=0.15u l=0.13u
X323 VCO2_selection_0.inverter_0.out VCO2_selection_0.NAND_2in_0.y vp vp sg13_lv_pmos ad=0.1005p pd=1.34u as=0.1005p ps=1.34u w=0.15u l=0.13u
X324 VCO3_selection_0.NAND_2in_3.y 101 a_32048_42022# gd sg13_lv_nmos ad=0.1005p pd=1.34u as=0.1005p ps=1.34u w=0.15u l=0.13u
X325 vp after_000011 VCO4_selection_0.inverter_3.in vp sg13_lv_pmos ad=0.1005p pd=1.34u as=0.1005p ps=1.34u w=0.15u l=0.13u
X326 vp after_000111 VCO2_selection_0.NAND_4in_0.b vp sg13_lv_pmos ad=0.1005p pd=1.34u as=0.1005p ps=1.34u w=0.15u l=0.13u
X327 VCO4_selection_0.NAND_2in_0.b VCO4_selection_0.NOR_2in_0.b a_32018_43486# vp sg13_lv_pmos ad=0.1005p pd=1.34u as=0.1005p ps=1.34u w=0.15u l=0.13u
X328 VCO4_11_sel VCO4_selection_0.NAND_3in_1.y gd gd sg13_lv_nmos ad=0.1005p pd=1.34u as=0.1005p ps=1.34u w=0.15u l=0.13u
X329 VCO4_selection_0.inverter_5.in f0 a_31598_47902# gd sg13_lv_nmos ad=0.1005p pd=1.34u as=0.1005p ps=1.34u w=0.15u l=0.13u
X330 VCO2_selection_0.NAND_3in_3.c VCO2_selection_0.XNOR_0._a a_32405_30758# gd sg13_lv_nmos ad=0.1005p pd=1.34u as=0.1005p ps=1.34u w=0.15u l=0.13u
X331 VCO3_selection_0.NAND_3in_5.y after_001111_n vp vp sg13_lv_pmos ad=0.1005p pd=1.34u as=0.1005p ps=1.34u w=0.15u l=0.13u
X332 VCO5_11_sel VCO5_selection_0.NOR_2in_0.y a_33013_28315# gd sg13_lv_nmos ad=0.1005p pd=1.34u as=0.1005p ps=1.34u w=0.15u l=0.13u
X333 gd 3bit_to_8_outs_0.inverter_6.in 100 gd sg13_lv_nmos ad=0.1005p pd=1.34u as=0.1005p ps=1.34u w=0.15u l=0.13u
X334 vp c2 3bit_to_8_outs_0.NAND_3in_0.y vp sg13_lv_pmos ad=0.1005p pd=1.34u as=0.1005p ps=1.34u w=0.15u l=0.13u
X335 VCO3_selection_0.NAND_3in_3.y 011 a_31788_38120# gd sg13_lv_nmos ad=0.1005p pd=1.34u as=0.1005p ps=1.34u w=0.15u l=0.13u
X336 a_33278_37142# VCO3_selection_0.inverter_3.out vp vp sg13_lv_pmos ad=0.1005p pd=1.34u as=0.1005p ps=1.34u w=0.15u l=0.13u
X337 VCO3_selection_0.NOR_2in_4.a VCO3_selection_0.NAND_2in_0.y vp vp sg13_lv_pmos ad=0.1005p pd=1.34u as=0.1005p ps=1.34u w=0.15u l=0.13u
X338 VCO4_selection_0.XNOR_0.y f0 a_31598_48376# gd sg13_lv_nmos ad=0.1005p pd=1.34u as=0.1005p ps=1.34u w=0.15u l=0.13u
X339 VCO4_selection_0.NAND_3in_2.y after_000011_n vp vp sg13_lv_pmos ad=0.1005p pd=1.34u as=0.1005p ps=1.34u w=0.15u l=0.13u
X340 gd 3bit_to_8_outs_0.inverter_8.in 000 gd sg13_lv_nmos ad=0.1005p pd=1.34u as=0.1005p ps=1.34u w=0.15u l=0.13u
X341 f1_n f1 vp vp sg13_lv_pmos ad=0.1005p pd=1.34u as=0.1005p ps=1.34u w=0.15u l=0.13u
X342 gd c1 3bit_to_8_outs_0.c1_n gd sg13_lv_nmos ad=0.1005p pd=1.34u as=0.1005p ps=1.34u w=0.15u l=0.13u
X343 a_32306_24854# c1 a_32090_24854# gd sg13_lv_nmos ad=0.1005p pd=1.34u as=0.1005p ps=1.34u w=0.15u l=0.13u
X344 VCO2_selection_0.NOR_2in_0.b VCO2_selection_0.NAND_3in_7.y vp vp sg13_lv_pmos ad=0.1005p pd=1.34u as=0.1005p ps=1.34u w=0.15u l=0.13u
X345 VCO2_selection_0.NAND_3in_5.c VCO2_selection_0.inverter_6.out gd gd sg13_lv_nmos ad=0.1005p pd=1.34u as=0.1005p ps=1.34u w=0.15u l=0.13u
X346 VCO_selection_0.NAND_2in_2.y 101 a_30790_50186# gd sg13_lv_nmos ad=0.1005p pd=1.34u as=0.1005p ps=1.34u w=0.15u l=0.13u
X347 after_001111_n f4 gd gd sg13_lv_nmos ad=0.1005p pd=1.34u as=0.1005p ps=1.34u w=0.15u l=0.13u
X348 vp VCO2_selection_0.NOR_2in_2.y VCO2_11_sel vp sg13_lv_pmos ad=0.1005p pd=1.34u as=0.1005p ps=1.34u w=0.15u l=0.13u
X349 VCO3_selection_0.NOR_2in_1.y VCO3_selection_0.inverter_2.out a_33278_35660# vp sg13_lv_pmos ad=0.1005p pd=1.34u as=0.1005p ps=1.34u w=0.15u l=0.13u
X350 VCO3_selection_0.inverter_2.out VCO3_selection_0.NAND_3in_1.y gd gd sg13_lv_nmos ad=0.1005p pd=1.34u as=0.1005p ps=1.34u w=0.15u l=0.13u
X351 vp VCO_selection_0.NAND_2in_0.y VCO_sel vp sg13_lv_pmos ad=0.1005p pd=1.34u as=0.1005p ps=1.34u w=0.15u l=0.13u
X352 VCO2_selection_0.NAND_4in_0.d 111 vp vp sg13_lv_pmos ad=0.1005p pd=1.34u as=0.1005p ps=1.34u w=0.15u l=0.13u
X353 VCO4_selection_0.XNOR_1._b f1 gd gd sg13_lv_nmos ad=0.1005p pd=1.34u as=0.1005p ps=1.34u w=0.15u l=0.13u
X354 a_33113_33692# VCO2_selection_0.inverter_1.out vp vp sg13_lv_pmos ad=0.1005p pd=1.34u as=0.1005p ps=1.34u w=0.15u l=0.13u
X355 vp 3bit_to_8_outs_0.NAND_3in_6.y 010 vp sg13_lv_pmos ad=0.1005p pd=1.34u as=0.1005p ps=1.34u w=0.15u l=0.13u
X356 3bit_to_8_outs_0.inverter_8.in 3bit_to_8_outs_0.c1_n vp vp sg13_lv_pmos ad=0.1005p pd=1.34u as=0.1005p ps=1.34u w=0.15u l=0.13u
X357 a_31410_26498# 3bit_to_8_outs_0.c0_n 3bit_to_8_outs_0.NAND_3in_6.y gd sg13_lv_nmos ad=0.1005p pd=1.34u as=0.1005p ps=1.34u w=0.15u l=0.13u
X358 vp after_000011_n VCO2_selection_0.NAND_3in_3.y vp sg13_lv_pmos ad=0.1005p pd=1.34u as=0.1005p ps=1.34u w=0.15u l=0.13u
X359 VCO4_selection_0.NAND_3in_0.y 010 a_31276_43990# gd sg13_lv_nmos ad=0.1005p pd=1.34u as=0.1005p ps=1.34u w=0.15u l=0.13u
X360 VCO4_selection_0.XNOR_1._a f0 vp vp sg13_lv_pmos ad=0.1005p pd=1.34u as=0.1005p ps=1.34u w=0.15u l=0.13u
X361 a_31276_44464# after_000111 a_31060_44464# gd sg13_lv_nmos ad=0.1005p pd=1.34u as=0.1005p ps=1.34u w=0.15u l=0.13u
X362 VCO3_selection_0.NAND_3in_9.y 010 vp vp sg13_lv_pmos ad=0.1005p pd=1.34u as=0.1005p ps=1.34u w=0.15u l=0.13u
X363 a_32252_40540# VCO3_selection_0.inverter_12.out gd gd sg13_lv_nmos ad=0.1005p pd=1.34u as=0.1005p ps=1.34u w=0.15u l=0.13u
X364 a_32494_44968# VCO4_selection_0.NOR_2in_1.a vp vp sg13_lv_pmos ad=0.1005p pd=1.34u as=0.1005p ps=1.34u w=0.15u l=0.13u
X365 VCO5_selection_0.NOR_2in_0.y VCO5_selection_0.inverter_1.out a_32537_27811# vp sg13_lv_pmos ad=0.1005p pd=1.34u as=0.1005p ps=1.34u w=0.15u l=0.13u
X366 a_31572_42496# after_001111_n gd gd sg13_lv_nmos ad=0.1005p pd=1.34u as=0.1005p ps=1.34u w=0.15u l=0.13u
X367 VCO4_selection_0.NAND_2in_0.b VCO4_selection_0.NOR_2in_0.a gd gd sg13_lv_nmos ad=0.1005p pd=1.34u as=0.1005p ps=1.34u w=0.15u l=0.13u
X368 VCO4_selection_0.XNOR_0._a f0 vp vp sg13_lv_pmos ad=0.1005p pd=1.34u as=0.1005p ps=1.34u w=0.15u l=0.13u
X369 after_000011 row_section_decoding_0.NAND_2in_0.b vp vp sg13_lv_pmos ad=0.1005p pd=1.34u as=0.1005p ps=1.34u w=0.15u l=0.13u
X370 VCO3_selection_0.inverter_8.out VCO3_selection_0.NAND_3in_8.y gd gd sg13_lv_nmos ad=0.1005p pd=1.34u as=0.1005p ps=1.34u w=0.15u l=0.13u
X371 VCO3_selection_0.NAND_2in_3.y after_000011_n vp vp sg13_lv_pmos ad=0.1005p pd=1.34u as=0.1005p ps=1.34u w=0.15u l=0.13u
X372 VCO4_selection_0.XNOR_0._b f1 gd gd sg13_lv_nmos ad=0.1005p pd=1.34u as=0.1005p ps=1.34u w=0.15u l=0.13u
X373 VCO4_selection_0.NOR_2in_0.a VCO4_selection_0.NAND_3in_2.y gd gd sg13_lv_nmos ad=0.1005p pd=1.34u as=0.1005p ps=1.34u w=0.15u l=0.13u
X374 gd VCO4_selection_0.NOR_2in_0.b VCO4_selection_0.NAND_2in_0.b gd sg13_lv_nmos ad=0.1005p pd=1.34u as=0.1005p ps=1.34u w=0.15u l=0.13u
X375 VCO3_selection_0.NAND_3in_1.y after_000111_n vp vp sg13_lv_pmos ad=0.1005p pd=1.34u as=0.1005p ps=1.34u w=0.15u l=0.13u
X376 vp 011 VCO2_selection_0.NAND_2in_0.y vp sg13_lv_pmos ad=0.1005p pd=1.34u as=0.1005p ps=1.34u w=0.15u l=0.13u
X377 vp c2 3bit_to_8_outs_0.NAND_3in_3.y vp sg13_lv_pmos ad=0.1005p pd=1.34u as=0.1005p ps=1.34u w=0.15u l=0.13u
X378 3bit_to_8_outs_0.NAND_3in_6.y c1 vp vp sg13_lv_pmos ad=0.1005p pd=1.34u as=0.1005p ps=1.34u w=0.15u l=0.13u
X379 VCO4_selection_0.inverter_5.in VCO4_selection_0.XNOR_1._b a_32052_47400# vp sg13_lv_pmos ad=0.204p pd=1.88u as=0.204p ps=1.88u w=0.6u l=0.13u
X380 a_31572_42022# f5 gd gd sg13_lv_nmos ad=0.1005p pd=1.34u as=0.1005p ps=1.34u w=0.15u l=0.13u
X381 a_31775_29201# VCO5_selection_0.XNOR_0._a vp vp sg13_lv_pmos ad=0.204p pd=1.88u as=0.204p ps=1.88u w=0.6u l=0.13u
X382 a_33692_38120# VCO3_selection_0.NOR_2in_1.y a_33476_38120# gd sg13_lv_nmos ad=0.1005p pd=1.34u as=0.1005p ps=1.34u w=0.15u l=0.13u
X383 VCO2_selection_0.NAND_4in_0.a 110 a_31623_32714# gd sg13_lv_nmos ad=0.1005p pd=1.34u as=0.1005p ps=1.34u w=0.15u l=0.13u
X384 a_32368_32714# after_000111 a_32152_32714# gd sg13_lv_nmos ad=0.1005p pd=1.34u as=0.1005p ps=1.34u w=0.15u l=0.13u
X385 VCO2_selection_0.inverter_1.in 100 a_31623_34196# gd sg13_lv_nmos ad=0.1005p pd=1.34u as=0.1005p ps=1.34u w=0.15u l=0.13u
X386 VCO3_selection_0.NOR_2in_1.y VCO3_selection_0.inverter_1.out gd gd sg13_lv_nmos ad=0.1005p pd=1.34u as=0.1005p ps=1.34u w=0.15u l=0.13u
X387 a_31740_45946# after_000111_n gd gd sg13_lv_nmos ad=0.1005p pd=1.34u as=0.1005p ps=1.34u w=0.15u l=0.13u
X388 VCO2_selection_0.NAND_3in_4.y 101 vp vp sg13_lv_pmos ad=0.1005p pd=1.34u as=0.1005p ps=1.34u w=0.15u l=0.13u
X389 gd 3bit_to_8_outs_0.c2_n a_32306_26498# gd sg13_lv_nmos ad=0.1005p pd=1.34u as=0.1005p ps=1.34u w=0.15u l=0.13u
X390 after_000111 after_000111_n vp vp sg13_lv_pmos ad=0.1005p pd=1.34u as=0.1005p ps=1.34u w=0.15u l=0.13u
X391 VCO5_selection_0.inverter_0.in after_000011_n vp vp sg13_lv_pmos ad=0.1005p pd=1.34u as=0.1005p ps=1.34u w=0.15u l=0.13u
X392 vp after_000011 VCO3_selection_0.NAND_3in_3.y vp sg13_lv_pmos ad=0.1005p pd=1.34u as=0.1005p ps=1.34u w=0.15u l=0.13u
X393 VCO3_selection_0.NAND_3in_9.y 010 a_32468_42496# gd sg13_lv_nmos ad=0.1005p pd=1.34u as=0.1005p ps=1.34u w=0.15u l=0.13u
X394 row_section_decoding_0.NAND_2in_0.a f2 gd gd sg13_lv_nmos ad=0.1005p pd=1.34u as=0.1005p ps=1.34u w=0.15u l=0.13u
X395 vp after_001111_n VCO2_selection_0.NAND_4in_0.a vp sg13_lv_pmos ad=0.1005p pd=1.34u as=0.1005p ps=1.34u w=0.15u l=0.13u
X396 VCO3_selection_0.inverter_4.in 000 a_32258_36638# gd sg13_lv_nmos ad=0.1005p pd=1.34u as=0.1005p ps=1.34u w=0.15u l=0.13u
X397 VCO3_selection_0.inverter_7.out VCO3_selection_0.NAND_3in_4.y vp vp sg13_lv_pmos ad=0.1005p pd=1.34u as=0.1005p ps=1.34u w=0.15u l=0.13u
X398 VCO5_selection_0.inverter_2.in f0 a_31321_28789# gd sg13_lv_nmos ad=0.1005p pd=1.34u as=0.1005p ps=1.34u w=0.15u l=0.13u
X399 VCO5_selection_0.NOR_2in_0.y VCO5_selection_0.inverter_0.out gd gd sg13_lv_nmos ad=0.1005p pd=1.34u as=0.1005p ps=1.34u w=0.15u l=0.13u
X400 VCO5_selection_0.XNOR_0._a f0 vp vp sg13_lv_pmos ad=0.1005p pd=1.34u as=0.1005p ps=1.34u w=0.15u l=0.13u
X401 a_30790_49868# 110 gd gd sg13_lv_nmos ad=0.1005p pd=1.34u as=0.1005p ps=1.34u w=0.15u l=0.13u
X402 a_33589_34670# VCO2_selection_0.NOR_2in_2.y a_33373_34670# gd sg13_lv_nmos ad=0.1005p pd=1.34u as=0.1005p ps=1.34u w=0.15u l=0.13u
X403 VCO3_selection_0.NAND_3in_2.y 001 vp vp sg13_lv_pmos ad=0.1005p pd=1.34u as=0.1005p ps=1.34u w=0.15u l=0.13u
X404 VCO3_selection_0.XNOR_1._a f0 gd gd sg13_lv_nmos ad=0.1005p pd=1.34u as=0.1005p ps=1.34u w=0.15u l=0.13u
X405 a_31592_47400# f0 vp vp sg13_lv_pmos ad=0.204p pd=1.88u as=0.204p ps=1.88u w=0.6u l=0.13u
X406 vp 010 VCO2_selection_0.inverter_2.in vp sg13_lv_pmos ad=0.1005p pd=1.34u as=0.1005p ps=1.34u w=0.15u l=0.13u
X407 VCO3_selection_0.NOR_2in_4.a VCO3_selection_0.NAND_2in_0.y gd gd sg13_lv_nmos ad=0.1005p pd=1.34u as=0.1005p ps=1.34u w=0.15u l=0.13u
X408 a_31303_28315# f1_n gd gd sg13_lv_nmos ad=0.1005p pd=1.34u as=0.1005p ps=1.34u w=0.15u l=0.13u
X409 vp 101 VCO_selection_0.NAND_2in_2.y vp sg13_lv_pmos ad=0.1005p pd=1.34u as=0.1005p ps=1.34u w=0.15u l=0.13u
X410 vp 3bit_to_8_outs_0.c0_n 3bit_to_8_outs_0.inverter_6.in vp sg13_lv_pmos ad=0.1005p pd=1.34u as=0.1005p ps=1.34u w=0.15u l=0.13u
X411 vp VCO2_selection_0.NAND_4in_0.c VCO2_5_sel vp sg13_lv_pmos ad=0.1005p pd=1.34u as=0.1005p ps=1.34u w=0.15u l=0.13u
X412 VCO4_selection_0.inverter_4.in after_000011_n vp vp sg13_lv_pmos ad=0.1005p pd=1.34u as=0.1005p ps=1.34u w=0.15u l=0.13u
X413 VCO2_selection_0.NOR_2in_2.b VCO2_selection_0.inverter_3.in vp vp sg13_lv_pmos ad=0.1005p pd=1.34u as=0.1005p ps=1.34u w=0.15u l=0.13u
X414 VCO3_11_sel VCO3_selection_0.NAND_3in_0.c vp vp sg13_lv_pmos ad=0.1005p pd=1.34u as=0.1005p ps=1.34u w=0.15u l=0.13u
X415 VCO2_selection_0.NAND_4in_0.d 111 a_32093_32240# gd sg13_lv_nmos ad=0.1005p pd=1.34u as=0.1005p ps=1.34u w=0.15u l=0.13u
X416 a_31788_36638# after_000111 a_31572_36638# gd sg13_lv_nmos ad=0.1005p pd=1.34u as=0.1005p ps=1.34u w=0.15u l=0.13u
X417 a_31740_46420# after_000011_n gd gd sg13_lv_nmos ad=0.1005p pd=1.34u as=0.1005p ps=1.34u w=0.15u l=0.13u
X418 f1_n f1 gd gd sg13_lv_nmos ad=0.1005p pd=1.34u as=0.1005p ps=1.34u w=0.15u l=0.13u
X419 vp VCO5_selection_0.NOR_2in_0.y VCO5_11_sel vp sg13_lv_pmos ad=0.1005p pd=1.34u as=0.1005p ps=1.34u w=0.15u l=0.13u
X420 VCO2_selection_0.NAND_3in_7.y 110 vp vp sg13_lv_pmos ad=0.1005p pd=1.34u as=0.1005p ps=1.34u w=0.15u l=0.13u
X421 vp c1 3bit_to_8_outs_0.c1_n vp sg13_lv_pmos ad=0.1005p pd=1.34u as=0.1005p ps=1.34u w=0.15u l=0.13u
X422 gd 3bit_to_8_outs_0.NAND_3in_0.y 111 gd sg13_lv_nmos ad=0.1005p pd=1.34u as=0.1005p ps=1.34u w=0.15u l=0.13u
X423 after_000111_n f4 a_30990_22377# vp sg13_lv_pmos ad=0.1005p pd=1.34u as=0.1005p ps=1.34u w=0.15u l=0.13u
X424 VCO3_selection_0.inverter_12.out VCO3_selection_0.XNOR_1.y vp vp sg13_lv_pmos ad=0.1005p pd=1.34u as=0.1005p ps=1.34u w=0.15u l=0.13u
X425 vp after_000011_n VCO4_selection_0.NAND_3in_0.y vp sg13_lv_pmos ad=0.1005p pd=1.34u as=0.1005p ps=1.34u w=0.15u l=0.13u
X426 VCO5_selection_0.XNOR_0._b f1 gd gd sg13_lv_nmos ad=0.1005p pd=1.34u as=0.1005p ps=1.34u w=0.15u l=0.13u
X427 VCO3_selection_0.inverter_2.out VCO3_selection_0.NAND_3in_1.y vp vp sg13_lv_pmos ad=0.1005p pd=1.34u as=0.1005p ps=1.34u w=0.15u l=0.13u
X428 VCO4_selection_0.XNOR_1._b f1 vp vp sg13_lv_pmos ad=0.1005p pd=1.34u as=0.1005p ps=1.34u w=0.15u l=0.13u
X429 VCO4_11_sel VCO4_selection_0.NAND_3in_1.y vp vp sg13_lv_pmos ad=0.1005p pd=1.34u as=0.1005p ps=1.34u w=0.15u l=0.13u
X430 a_32048_42022# after_000011_n gd gd sg13_lv_nmos ad=0.1005p pd=1.34u as=0.1005p ps=1.34u w=0.15u l=0.13u
X431 VCO4_selection_0.XNOR_0._b f1 vp vp sg13_lv_pmos ad=0.1005p pd=1.34u as=0.1005p ps=1.34u w=0.15u l=0.13u
X432 VCO5_selection_0.inverter_2.out VCO5_selection_0.inverter_2.in gd gd sg13_lv_nmos ad=0.1005p pd=1.34u as=0.1005p ps=1.34u w=0.15u l=0.13u
X433 vp 3bit_to_8_outs_0.inverter_8.in 000 vp sg13_lv_pmos ad=0.1005p pd=1.34u as=0.1005p ps=1.34u w=0.15u l=0.13u
X434 a_31598_47902# VCO4_selection_0.XNOR_1._b gd gd sg13_lv_nmos ad=0.1005p pd=1.34u as=0.1005p ps=1.34u w=0.15u l=0.13u
X435 vp 3bit_to_8_outs_0.c0_n 3bit_to_8_outs_0.NAND_3in_6.y vp sg13_lv_pmos ad=0.1005p pd=1.34u as=0.1005p ps=1.34u w=0.15u l=0.13u
X436 VCO4_selection_0.NAND_3in_2.y 011 vp vp sg13_lv_pmos ad=0.1005p pd=1.34u as=0.1005p ps=1.34u w=0.15u l=0.13u
X437 a_30783_28315# after_000011_n gd gd sg13_lv_nmos ad=0.1005p pd=1.34u as=0.1005p ps=1.34u w=0.15u l=0.13u
X438 a_32920_31262# VCO2_selection_0.inverter_6.out vp vp sg13_lv_pmos ad=0.1005p pd=1.34u as=0.1005p ps=1.34u w=0.15u l=0.13u
X439 VCO3_selection_0.XNOR_1.y f0 a_32110_40066# gd sg13_lv_nmos ad=0.1005p pd=1.34u as=0.1005p ps=1.34u w=0.15u l=0.13u
X440 VCO3_selection_0.NAND_3in_4.y after_000111_n vp vp sg13_lv_pmos ad=0.1005p pd=1.34u as=0.1005p ps=1.34u w=0.15u l=0.13u
X441 VCO4_selection_0.inverter_1.in VCO4_selection_0.NOR_2in_1.a gd gd sg13_lv_nmos ad=0.1005p pd=1.34u as=0.1005p ps=1.34u w=0.15u l=0.13u
X442 VCO5_selection_0.inverter_0.in 001 a_32772_28789# gd sg13_lv_nmos ad=0.1005p pd=1.34u as=0.1005p ps=1.34u w=0.15u l=0.13u
X443 a_33484_43000# VCO3_selection_0.inverter_11.out vp vp sg13_lv_pmos ad=0.1005p pd=1.34u as=0.1005p ps=1.34u w=0.15u l=0.13u
X444 VCO3_selection_0.NAND_3in_1.y 010 a_31788_36164# gd sg13_lv_nmos ad=0.1005p pd=1.34u as=0.1005p ps=1.34u w=0.15u l=0.13u
X445 a_32564_39564# VCO3_selection_0.XNOR_1._a vp vp sg13_lv_pmos ad=0.204p pd=1.88u as=0.204p ps=1.88u w=0.6u l=0.13u
X446 a_31623_32714# after_001111_n a_31407_32714# gd sg13_lv_nmos ad=0.1005p pd=1.34u as=0.1005p ps=1.34u w=0.15u l=0.13u
X447 VCO3_selection_0.inverter_7.out VCO3_selection_0.NAND_3in_4.y gd gd sg13_lv_nmos ad=0.1005p pd=1.34u as=0.1005p ps=1.34u w=0.15u l=0.13u
X448 a_31250_23355# row_section_decoding_0.NAND_2in_0.b gd gd sg13_lv_nmos ad=0.1005p pd=1.34u as=0.1005p ps=1.34u w=0.15u l=0.13u
X449 a_31623_34196# after_000111 a_31407_34196# gd sg13_lv_nmos ad=0.1005p pd=1.34u as=0.1005p ps=1.34u w=0.15u l=0.13u
X450 vp VCO2_selection_0.NAND_4in_0.a VCO2_5_sel vp sg13_lv_pmos ad=0.1005p pd=1.34u as=0.1005p ps=1.34u w=0.15u l=0.13u
X451 VCO2_selection_0.NAND_3in_4.y 101 a_32779_32240# gd sg13_lv_nmos ad=0.1005p pd=1.34u as=0.1005p ps=1.34u w=0.15u l=0.13u
X452 VCO3_selection_0.XNOR_1.y f1 a_32104_39564# vp sg13_lv_pmos ad=0.204p pd=1.88u as=0.204p ps=1.88u w=0.6u l=0.13u
X453 3bit_to_8_outs_0.NAND_3in_0.y c1 vp vp sg13_lv_pmos ad=0.1005p pd=1.34u as=0.1005p ps=1.34u w=0.15u l=0.13u
X454 gd c2 a_31626_25172# gd sg13_lv_nmos ad=0.1005p pd=1.34u as=0.1005p ps=1.34u w=0.15u l=0.13u
X455 a_31788_38120# after_000011 a_31572_38120# gd sg13_lv_nmos ad=0.1005p pd=1.34u as=0.1005p ps=1.34u w=0.15u l=0.13u
X456 a_30774_22377# f3 vp vp sg13_lv_pmos ad=0.1005p pd=1.34u as=0.1005p ps=1.34u w=0.15u l=0.13u
X457 a_31598_48376# VCO4_selection_0.XNOR_0._b gd gd sg13_lv_nmos ad=0.1005p pd=1.34u as=0.1005p ps=1.34u w=0.15u l=0.13u
X458 gd 3bit_to_8_outs_0.c2_n a_31626_26816# gd sg13_lv_nmos ad=0.1005p pd=1.34u as=0.1005p ps=1.34u w=0.15u l=0.13u
X459 a_31060_45946# after_000111_n gd gd sg13_lv_nmos ad=0.1005p pd=1.34u as=0.1005p ps=1.34u w=0.15u l=0.13u
X460 a_31321_28789# VCO5_selection_0.XNOR_0._b gd gd sg13_lv_nmos ad=0.1005p pd=1.34u as=0.1005p ps=1.34u w=0.15u l=0.13u
X461 a_33278_35660# VCO3_selection_0.inverter_1.out vp vp sg13_lv_pmos ad=0.1005p pd=1.34u as=0.1005p ps=1.34u w=0.15u l=0.13u
X462 after_000111 after_000111_n gd gd sg13_lv_nmos ad=0.1005p pd=1.34u as=0.1005p ps=1.34u w=0.15u l=0.13u
X463 VCO2_selection_0.inverter_1.in 100 vp vp sg13_lv_pmos ad=0.1005p pd=1.34u as=0.1005p ps=1.34u w=0.15u l=0.13u
X464 VCO2_selection_0.inverter_2.in 010 a_31407_34670# gd sg13_lv_nmos ad=0.1005p pd=1.34u as=0.1005p ps=1.34u w=0.15u l=0.13u
X465 a_33345_40066# VCO3_selection_0.NAND_3in_6.c gd gd sg13_lv_nmos ad=0.1005p pd=1.34u as=0.1005p ps=1.34u w=0.15u l=0.13u
X466 vp 3bit_to_8_outs_0.c2_n 3bit_to_8_outs_0.inverter_10.in vp sg13_lv_pmos ad=0.1005p pd=1.34u as=0.1005p ps=1.34u w=0.15u l=0.13u
X467 a_33013_28315# VCO5_selection_0.NAND_2in_0.b gd gd sg13_lv_nmos ad=0.1005p pd=1.34u as=0.1005p ps=1.34u w=0.15u l=0.13u
X468 a_32570_38594# f1 gd gd sg13_lv_nmos ad=0.1005p pd=1.34u as=0.1005p ps=1.34u w=0.15u l=0.13u
X469 f5_n f5 vp vp sg13_lv_pmos ad=0.1005p pd=1.34u as=0.1005p ps=1.34u w=0.15u l=0.13u
X470 VCO3_selection_0.NAND_3in_8.y 110 vp vp sg13_lv_pmos ad=0.1005p pd=1.34u as=0.1005p ps=1.34u w=0.15u l=0.13u
X471 vp 3bit_to_8_outs_0.NAND_3in_3.y 101 vp sg13_lv_pmos ad=0.1005p pd=1.34u as=0.1005p ps=1.34u w=0.15u l=0.13u
X472 VCO3_selection_0.NAND_3in_6.a VCO3_selection_0.inverter_11.out gd gd sg13_lv_nmos ad=0.1005p pd=1.34u as=0.1005p ps=1.34u w=0.15u l=0.13u
X473 after_000111_n f4 gd gd sg13_lv_nmos ad=0.1005p pd=1.34u as=0.1005p ps=1.34u w=0.15u l=0.13u
X474 vp 111 VCO2_selection_0.inverter_3.in vp sg13_lv_pmos ad=0.1005p pd=1.34u as=0.1005p ps=1.34u w=0.15u l=0.13u
X475 a_31276_43990# after_000011_n a_31060_43990# gd sg13_lv_nmos ad=0.1005p pd=1.34u as=0.1005p ps=1.34u w=0.15u l=0.13u
X476 VCO2_selection_0.NAND_3in_3.y VCO2_selection_0.NAND_3in_3.c vp vp sg13_lv_pmos ad=0.1005p pd=1.34u as=0.1005p ps=1.34u w=0.15u l=0.13u
X477 a_33044_32714# VCO2_selection_0.NAND_4in_0.c a_32828_32714# gd sg13_lv_nmos ad=0.1005p pd=1.34u as=0.1005p ps=1.34u w=0.15u l=0.13u
X478 VCO2_selection_0.NOR_2in_2.b VCO2_selection_0.inverter_3.in gd gd sg13_lv_nmos ad=0.1005p pd=1.34u as=0.1005p ps=1.34u w=0.15u l=0.13u
X479 vp after_000111 VCO3_selection_0.NAND_3in_9.y vp sg13_lv_pmos ad=0.1005p pd=1.34u as=0.1005p ps=1.34u w=0.15u l=0.13u
X480 VCO2_selection_0.NOR_2in_0.a VCO2_selection_0.NAND_3in_3.y vp vp sg13_lv_pmos ad=0.1005p pd=1.34u as=0.1005p ps=1.34u w=0.15u l=0.13u
X481 a_32537_27811# VCO5_selection_0.inverter_0.out vp vp sg13_lv_pmos ad=0.1005p pd=1.34u as=0.1005p ps=1.34u w=0.15u l=0.13u
X482 a_32564_39006# VCO3_selection_0.XNOR_0._a vp vp sg13_lv_pmos ad=0.204p pd=1.88u as=0.204p ps=1.88u w=0.6u l=0.13u
X483 VCO3_selection_0.inverter_3.out VCO3_selection_0.NAND_3in_2.y gd gd sg13_lv_nmos ad=0.1005p pd=1.34u as=0.1005p ps=1.34u w=0.15u l=0.13u
X484 VCO4_selection_0.NAND_3in_1.y 000 a_31956_45946# gd sg13_lv_nmos ad=0.1005p pd=1.34u as=0.1005p ps=1.34u w=0.15u l=0.13u
X485 VCO3_selection_0.XNOR_1._b f1 gd gd sg13_lv_nmos ad=0.1005p pd=1.34u as=0.1005p ps=1.34u w=0.15u l=0.13u
X486 a_31260_49868# VCO_selection_0.NAND_2in_2.y gd gd sg13_lv_nmos ad=0.1005p pd=1.34u as=0.1005p ps=1.34u w=0.15u l=0.13u
X487 VCO3_selection_0.NAND_3in_7.c f1 a_32104_39006# vp sg13_lv_pmos ad=0.204p pd=1.88u as=0.204p ps=1.88u w=0.6u l=0.13u
X488 VCO5_selection_0.inverter_2.in VCO5_selection_0.XNOR_0._a a_31781_28789# gd sg13_lv_nmos ad=0.1005p pd=1.34u as=0.1005p ps=1.34u w=0.15u l=0.13u
X489 3bit_to_8_outs_0.NAND_3in_3.y 3bit_to_8_outs_0.c1_n vp vp sg13_lv_pmos ad=0.1005p pd=1.34u as=0.1005p ps=1.34u w=0.15u l=0.13u
X490 VCO4_selection_0.NAND_3in_1.y after_000111_n vp vp sg13_lv_pmos ad=0.1005p pd=1.34u as=0.1005p ps=1.34u w=0.15u l=0.13u
X491 a_33476_38120# VCO3_selection_0.NAND_3in_0.c gd gd sg13_lv_nmos ad=0.1005p pd=1.34u as=0.1005p ps=1.34u w=0.15u l=0.13u
X492 vp 000 VCO3_selection_0.inverter_4.in vp sg13_lv_pmos ad=0.1005p pd=1.34u as=0.1005p ps=1.34u w=0.15u l=0.13u
X493 VCO3_selection_0.NAND_3in_7.y VCO3_selection_0.NAND_3in_7.c vp vp sg13_lv_pmos ad=0.1005p pd=1.34u as=0.1005p ps=1.34u w=0.15u l=0.13u
X494 vp after_000011 VCO2_selection_0.NAND_3in_7.y vp sg13_lv_pmos ad=0.1005p pd=1.34u as=0.1005p ps=1.34u w=0.15u l=0.13u
X495 vp after_000011 VCO2_selection_0.NAND_3in_4.y vp sg13_lv_pmos ad=0.1005p pd=1.34u as=0.1005p ps=1.34u w=0.15u l=0.13u
X496 VCO3_5_sel VCO3_selection_0.NAND_3in_6.a a_33561_40066# gd sg13_lv_nmos ad=0.1005p pd=1.34u as=0.1005p ps=1.34u w=0.15u l=0.13u
X497 a_32306_26498# c1 a_32090_26498# gd sg13_lv_nmos ad=0.1005p pd=1.34u as=0.1005p ps=1.34u w=0.15u l=0.13u
X498 VCO3_selection_0.inverter_0.out VCO3_selection_0.NAND_3in_7.y vp vp sg13_lv_pmos ad=0.1005p pd=1.34u as=0.1005p ps=1.34u w=0.15u l=0.13u
X499 VCO3_selection_0.NAND_3in_5.y 011 vp vp sg13_lv_pmos ad=0.1005p pd=1.34u as=0.1005p ps=1.34u w=0.15u l=0.13u
X500 after_000111_n f3 gd gd sg13_lv_nmos ad=0.1005p pd=1.34u as=0.1005p ps=1.34u w=0.15u l=0.13u
X501 a_31572_40540# after_000111_n gd gd sg13_lv_nmos ad=0.1005p pd=1.34u as=0.1005p ps=1.34u w=0.15u l=0.13u
X502 VCO5_selection_0.NAND_2in_0.b f1_n vp vp sg13_lv_pmos ad=0.1005p pd=1.34u as=0.1005p ps=1.34u w=0.15u l=0.13u
X503 a_32090_25172# 3bit_to_8_outs_0.c0_n 3bit_to_8_outs_0.inverter_6.in gd sg13_lv_nmos ad=0.1005p pd=1.34u as=0.1005p ps=1.34u w=0.15u l=0.13u
X504 a_31060_46420# after_000011_n gd gd sg13_lv_nmos ad=0.1005p pd=1.34u as=0.1005p ps=1.34u w=0.15u l=0.13u
X505 a_32468_42496# after_000111 a_32252_42496# gd sg13_lv_nmos ad=0.1005p pd=1.34u as=0.1005p ps=1.34u w=0.15u l=0.13u
X506 a_32090_26816# 3bit_to_8_outs_0.c0_n 3bit_to_8_outs_0.inverter_8.in gd sg13_lv_nmos ad=0.1005p pd=1.34u as=0.1005p ps=1.34u w=0.15u l=0.13u
X507 VCO2_5_sel VCO2_selection_0.NAND_4in_0.a a_33260_32714# gd sg13_lv_nmos ad=0.1005p pd=1.34u as=0.1005p ps=1.34u w=0.15u l=0.13u
X508 VCO2_selection_0.NAND_4in_0.a after_000111 vp vp sg13_lv_pmos ad=0.1005p pd=1.34u as=0.1005p ps=1.34u w=0.15u l=0.13u
X509 a_32258_36638# after_001111 gd gd sg13_lv_nmos ad=0.1005p pd=1.34u as=0.1005p ps=1.34u w=0.15u l=0.13u
X510 a_33317_29780# VCO2_selection_0.NOR_2in_0.a vp vp sg13_lv_pmos ad=0.1005p pd=1.34u as=0.1005p ps=1.34u w=0.15u l=0.13u
X511 VCO3_selection_0.NAND_3in_6.b VCO3_selection_0.NOR_2in_4.b a_33068_41518# vp sg13_lv_pmos ad=0.1005p pd=1.34u as=0.1005p ps=1.34u w=0.15u l=0.13u
X512 a_32903_35174# VCO2_selection_0.NOR_2in_2.a vp vp sg13_lv_pmos ad=0.1005p pd=1.34u as=0.1005p ps=1.34u w=0.15u l=0.13u
X513 VCO_selection_0.NAND_2in_0.y 110 vp vp sg13_lv_pmos ad=0.1005p pd=1.34u as=0.1005p ps=1.34u w=0.15u l=0.13u
X514 VCO2_selection_0.inverter_4.out VCO2_selection_0.NOR_2in_0.y gd gd sg13_lv_nmos ad=0.1005p pd=1.34u as=0.1005p ps=1.34u w=0.15u l=0.13u
X515 VCO4_5_sel VCO4_selection_0.NAND_2in_0.b vp vp sg13_lv_pmos ad=0.1005p pd=1.34u as=0.1005p ps=1.34u w=0.15u l=0.13u
X516 f5_n f5 gd gd sg13_lv_nmos ad=0.1005p pd=1.34u as=0.1005p ps=1.34u w=0.15u l=0.13u
X517 a_32110_40066# VCO3_selection_0.XNOR_1._b gd gd sg13_lv_nmos ad=0.1005p pd=1.34u as=0.1005p ps=1.34u w=0.15u l=0.13u
X518 vp 100 VCO2_selection_0.NAND_4in_0.c vp sg13_lv_pmos ad=0.1005p pd=1.34u as=0.1005p ps=1.34u w=0.15u l=0.13u
X519 VCO3_selection_0.NAND_3in_6.c VCO3_selection_0.inverter_8.out a_33486_41044# vp sg13_lv_pmos ad=0.1005p pd=1.34u as=0.1005p ps=1.34u w=0.15u l=0.13u
C0 a_32252_40540# VCO3_selection_0.NAND_3in_4.y 0.01512f
C1 010 a_30783_28315# 0.0109f
C2 VCO2_selection_0.inverter_1.out m2_33034_34103# 0.01348f
C3 VCO4_selection_0.inverter_5.out VCO4_selection_0.NOR_2in_0.a 0.33838f
C4 VCO2_selection_0.NOR_2in_2.b VCO2_selection_0.NAND_2in_0.y 0.02443f
C5 VCO4_selection_0.NAND_2in_0.b VCO4_selection_0.inverter_0.out 0.2503f
C6 VCO3_selection_0.NOR_2in_0.y VCO3_selection_0.inverter_3.out 0.30927f
C7 VCO3_selection_0.NAND_3in_2.y VCO3_selection_0.inverter_4.out 0.53082f
C8 010 f0 0.12344f
C9 VCO3_selection_0.inverter_12.out 110 0.02635f
C10 m2_33407_40705# m2_33407_40623# 0.40984f
C11 VCO4_selection_0.inverter_4.in VCO4_selection_0.NAND_3in_2.y 0.51092f
C12 VCO3_selection_0.XNOR_1.y VCO3_selection_0.NAND_3in_7.c 0.08284f
C13 100 VCO3_selection_0.inverter_12.out 0.13591f
C14 111 after_000011 0.99664f
C15 after_000011_n f4 0.01565f
C16 VCO4_selection_0.inverter_3.in m2_30981_45853# 0.1319f
C17 VCO2_selection_0.NOR_2in_2.y VCO2_selection_0.inverter_1.out 0.01988f
C18 VCO3_selection_0.NAND_2in_1.y VCO3_selection_0.inverter_4.in 0.05f
C19 111 after_000111 2.84561f
C20 VCO2_selection_0.NAND_3in_5.c VCO2_11_sel 0.6368f
C21 VCO4_selection_0.inverter_5.out m2_32494_47727# 0.18043f
C22 VCO4_selection_0.NAND_3in_1.y VCO4_selection_0.XNOR_0.y 0.02581f
C23 VCO3_selection_0.inverter_4.in after_001111 0.43571f
C24 a_32018_44968# VCO4_selection_0.NAND_2in_0.a 0.08009f
C25 f5_n 110 0.1754f
C26 001 VCO5_selection_0.inverter_1.in 0.01531f
C27 after_000111 a_31266_50186# 0.02007f
C28 m2_30711_49693# VCO_selection_0.NAND_2in_0.y 0.26568f
C29 m2_32353_46585# VCO4_selection_0.NOR_2in_0.a 0.22713f
C30 VCO3_selection_0.XNOR_1.y f0 0.38434f
C31 011 110 0.14617f
C32 f1 VCO4_selection_0.XNOR_0._a 0.60888f
C33 100 f5_n 0.47252f
C34 VCO4_selection_0.NOR_2in_0.a VCO4_selection_0.NOR_2in_1.a 3.85863f
C35 m2_31328_30191# after_000111_n 0.68906f
C36 VCO3_selection_0.NAND_3in_9.y VCO3_selection_0.inverter_10.out 0.52748f
C37 VCO4_selection_0.inverter_5.in VCO4_selection_0.XNOR_0.y 0.08384f
C38 VCO5_selection_0.inverter_0.in m2_32934_28222# 0.07668f
C39 010 a_31788_36164# 0.01179f
C40 a_31407_30284# after_000111_n 0.01632f
C41 100 011 36.5375f
C42 vp 3bit_to_8_outs_0.c1_n 0.61238f
C43 VCO2_selection_0.inverter_1.in f5_n 0.57965f
C44 101 VCO2_selection_0.inverter_6.out 0.104f
C45 VCO2_selection_0.inverter_1.in 011 0.42958f
C46 f1 VCO4_selection_0.XNOR_0.y 0.99743f
C47 000 m2_30761_27145# 0.18536f
C48 after_000111_n a_32563_32240# 0.01632f
C49 after_001111_n 111 0.08252f
C50 a_31956_45946# VCO4_selection_0.NAND_3in_1.y 0.07156f
C51 a_32494_43990# VCO4_selection_0.NOR_2in_0.a 0.01026f
C52 VCO4_selection_0.NOR_2in_0.b VCO3_selection_0.inverter_10.out 0.0177f
C53 a_31410_26498# a_31626_26498# 0.02909f
C54 VCO3_selection_0.NOR_2in_4.b VCO3_selection_0.NOR_2in_4.a 1.3042f
C55 m2_31925_23438# f1 0.17808f
C56 VCO4_selection_0.NOR_2in_0.a VCO4_selection_0.inverter_1.in 5.8034f
C57 VCO3_selection_0.NAND_3in_2.y m2_32933_36721# 0.17808f
C58 001 3bit_to_8_outs_0.NAND_3in_2.y 0.49489f
C59 a_31410_26816# a_31626_26816# 0.02909f
C60 a_31060_44464# VCO4_selection_0.inverter_2.in 0.0131f
C61 VCO4_selection_0.NOR_2in_0.b VCO4_selection_0.inverter_1.in 0.51618f
C62 f3 a_30774_22377# 0.04886f
C63 3bit_to_8_outs_0.inverter_10.in 3bit_to_8_outs_0.inverter_6.in 0.08443f
C64 VCO2_selection_0.NAND_4in_0.d after_000011 0.79515f
C65 VCO3_11_sel m2_33397_38027# 0.09224f
C66 after_000011_n VCO5_selection_0.inverter_2.out 0.451f
C67 VCO5_selection_0.inverter_1.in VCO5_selection_0.inverter_1.out 0.40742f
C68 VCO3_selection_0.NOR_2in_4.b m2_32989_41847# 0.0378f
C69 f1_n f1 0.66493f
C70 VCO4_selection_0.inverter_5.in VCO4_selection_0.XNOR_1._a 1.096f
C71 after_000011_n VCO4_selection_0.XNOR_0.y 0.27568f
C72 a_33486_41044# vp 0.12263f
C73 VCO2_selection_0.NAND_3in_5.c m2_32841_30923# 0.31234f
C74 a_31276_43990# VCO4_selection_0.NAND_3in_0.y 0.07156f
C75 f1 VCO4_selection_0.XNOR_1._a 0.60884f
C76 VCO4_selection_0.NAND_2in_0.b vp 0.3138f
C77 VCO5_selection_0.inverter_2.in a_31775_29201# 0.11436f
C78 VCO3_selection_0.NAND_3in_3.y m2_33397_38027# 0.02003f
C79 VCO4_selection_0.NOR_2in_0.b m2_31673_43815# 0.01796f
C80 VCO3_selection_0.NOR_2in_4.a m2_32989_41929# 0.01348f
C81 a_31060_46420# a_31276_46420# 0.02909f
C82 3bit_to_8_outs_0.inverter_8.in 3bit_to_8_outs_0.c2_n 2.12219f
C83 a_32152_32714# VCO2_selection_0.NAND_4in_0.b 0.01119f
C84 VCO2_selection_0.NOR_2in_2.a vp 0.4429f
C85 VCO2_selection_0.inverter_2.in after_001111 0.02217f
C86 VCO3_selection_0.inverter_5.out VCO3_selection_0.inverter_3.out 0.02078f
C87 VCO4_11_sel m2_32353_45771# 0.18043f
C88 VCO3_selection_0.NAND_3in_4.y m2_33407_40623# 0.01848f
C89 a_32052_47400# vp 0.17108f
C90 c2 3bit_to_8_outs_0.c2_n 0.78542f
C91 101 f5_n 1.23779f
C92 VCO5_selection_0.inverter_0.out VCO5_selection_0.NOR_2in_0.y 0.336f
C93 VCO3_selection_0.inverter_2.out m2_32933_36071# 0.17027f
C94 VCO5_selection_0.inverter_0.out 3bit_to_8_outs_0.inverter_8.in 0.01344f
C95 010 3bit_to_8_outs_0.NAND_3in_6.y 0.49491f
C96 101 011 0.08939f
C97 f0 VCO4_selection_0.NAND_3in_2.y 0.01551f
C98 m2_31033_25501# 3bit_to_8_outs_0.NAND_3in_3.y 0.21959f
C99 VCO4_selection_0.XNOR_1._b VCO4_selection_0.XNOR_0._b 0.13128f
C100 VCO3_selection_0.NAND_3in_7.y VCO3_selection_0.inverter_4.out 0.03535f
C101 after_000011_n f1_n 1.64765f
C102 VCO3_selection_0.NAND_3in_4.y a_31788_40540# 0.07204f
C103 after_000011_n VCO2_selection_0.inverter_3.in 0.43823f
C104 VCO3_selection_0.inverter_3.out m2_33199_36721# 0.01348f
C105 010 f3 0.01157f
C106 m2_32989_41929# m2_32989_41847# 0.40984f
C107 VCO3_selection_0.NAND_3in_5.y m2_32865_42661# 0.16871f
C108 001 f4 0.01539f
C109 after_000011_n 3bit_to_8_outs_0.c0_n 0.09002f
C110 111 after_001111 0.12491f
C111 VCO_selection_0.NAND_2in_1.y after_000111 0.61909f
C112 vp VCO3_selection_0.inverter_3.out 0.4449f
C113 VCO4_selection_0.inverter_3.in a_31740_45946# 0.01405f
C114 VCO3_selection_0.NOR_2in_1.y m2_33397_38027# 0.01463f
C115 VCO3_selection_0.NAND_3in_4.y VCO3_selection_0.NAND_3in_8.y 0.39594f
C116 a_31572_38120# VCO3_selection_0.NAND_3in_3.y 0.01332f
C117 VCO4_5_sel VCO3_selection_0.inverter_10.out 0.02671f
C118 VCO5_selection_0.inverter_1.out m2_32458_28222# 0.01079f
C119 3bit_to_8_outs_0.c0_n a_32090_26816# 0.01353f
C120 VCO4_selection_0.XNOR_0.y a_31598_48376# 0.07107f
C121 VCO2_selection_0.inverter_1.in m2_32768_34103# 0.17808f
C122 a_33085_39098# VCO3_selection_0.NAND_3in_0.c 0.08005f
C123 VCO2_selection_0.NOR_2in_2.b m2_32286_34753# 0.09739f
C124 c0 3bit_to_8_outs_0.c1_n 2.75721f
C125 VCO3_selection_0.inverter_1.out vp 0.44815f
C126 f5_n 011 0.22927f
C127 VCO2_selection_0.NOR_2in_2.b vp 0.34824f
C128 a_31939_31170# VCO2_selection_0.NAND_3in_3.c 0.10853f
C129 VCO2_selection_0.XNOR_0._a a_32399_31170# 0.10751f
C130 VCO3_selection_0.NAND_3in_1.y after_000111_n 0.5605f
C131 a_32494_43990# VCO4_5_sel 0.07562f
C132 VCO3_selection_0.NAND_3in_7.y m2_32865_37945# 0.0115f
C133 vp a_31592_48788# 0.17102f
C134 VCO4_5_sel VCO4_selection_0.inverter_1.in 0.05965f
C135 VCO4_selection_0.inverter_4.in a_31276_46420# 0.07053f
C136 VCO2_selection_0.NOR_2in_1.y vp 0.43272f
C137 vp VCO5_selection_0.inverter_0.in 0.60239f
C138 vp VCO2_selection_0.NAND_3in_3.c 0.58633f
C139 vp a_32052_48788# 0.17108f
C140 VCO3_selection_0.XNOR_1.y VCO3_selection_0.NAND_3in_8.y 0.02418f
C141 m2_32824_34835# m2_32824_34753# 0.40984f
C142 m2_32286_34753# m2_32558_34753# 0.01717f
C143 f5 f4 3.0613f
C144 vp a_33317_29780# 0.12263f
C145 VCO2_selection_0.NOR_2in_0.a m2_32700_29945# 0.17997f
C146 VCO2_selection_0.NAND_3in_5.c m2_33238_30191# 0.0125f
C147 a_32252_38120# a_32468_38120# 0.02909f
C148 m2_32353_45771# after_000111_n 0.01756f
C149 111 VCO2_selection_0.inverter_2.in 0.23103f
C150 010 f2 0.015f
C151 VCO2_selection_0.NAND_3in_3.y a_32303_30284# 0.06947f
C152 010 m2_31328_34835# 0.01111f
C153 001 VCO5_selection_0.inverter_2.out 1.1473f
C154 VCO4_selection_0.NAND_3in_1.y after_000011 0.62738f
C155 VCO3_selection_0.NOR_2in_1.y m2_33199_36071# 0.16765f
C156 a_31410_25172# 3bit_to_8_outs_0.inverter_6.in 0.01202f
C157 001 VCO4_selection_0.XNOR_0.y 0.93354f
C158 a_33278_35660# VCO3_selection_0.NOR_2in_1.y 0.08009f
C159 VCO3_selection_0.NAND_3in_9.y a_32468_42496# 0.07156f
C160 after_000111 VCO4_selection_0.inverter_2.in 0.62653f
C161 m2_30761_26159# 011 0.18046f
C162 VCO2_selection_0.NOR_2in_0.b m2_33238_30191# 0.01349f
C163 row_section_decoding_0.NAND_2in_0.a 3bit_to_8_outs_0.inverter_1.in 0.01498f
C164 VCO4_11_sel VCO4_selection_0.XNOR_0.y 0.02501f
C165 a_32405_30758# VCO2_selection_0.NAND_3in_3.c 0.07768f
C166 f1 after_000011 0.73504f
C167 a_31781_28789# VCO5_selection_0.XNOR_0._a 0.07427f
C168 VCO4_selection_0.inverter_5.out VCO4_selection_0.NAND_3in_2.y 0.92738f
C169 after_000011_n a_31572_42022# 0.01233f
C170 VCO3_selection_0.NAND_3in_4.y 110 0.42286f
C171 VCO3_selection_0.inverter_12.out m2_33407_40705# 0.01743f
C172 after_000111 f1 0.14198f
C173 after_000111_n f4 0.78151f
C174 VCO3_selection_0.inverter_0.out VCO3_selection_0.XNOR_0._a 0.0277f
C175 after_000111 VCO3_selection_0.NAND_3in_2.y 0.5868f
C176 c2 f1 0.01392f
C177 VCO3_selection_0.NAND_3in_4.y 100 0.38365f
C178 after_001111_n VCO4_selection_0.inverter_2.in 0.53838f
C179 111 a_31266_50186# 0.0439f
C180 3bit_to_8_outs_0.c2_n 3bit_to_8_outs_0.inverter_6.in 0.11043f
C181 010 110 0.08822f
C182 3bit_to_8_outs_0.c2_n 3bit_to_8_outs_0.inverter_10.in 2.12248f
C183 100 010 9.70035f
C184 001 f1_n 0.02001f
C185 m2_32458_28222# m2_32934_28222# 0.01756f
C186 VCO3_selection_0.XNOR_1._b m2_33006_39973# 0.0481f
C187 a_32052_47400# f0 0.02644f
C188 after_001111_n f1 0.29316f
C189 m2_32353_46585# VCO4_selection_0.NAND_3in_2.y 0.0115f
C190 f5_n VCO3_selection_0.NAND_3in_9.y 0.57435f
C191 VCO_selection_0.NAND_2in_1.y after_001111 0.02009f
C192 VCO5_selection_0.NAND_2in_0.b VCO5_selection_0.inverter_0.in 0.10864f
C193 a_33692_38120# VCO3_selection_0.NOR_2in_0.y 0.01179f
C194 vp a_32564_39564# 0.17108f
C195 a_31407_34196# VCO2_selection_0.inverter_1.in 0.0131f
C196 after_000011_n VCO5_selection_0.NOR_2in_0.y 0.02606f
C197 m2_32353_45771# m2_32625_45771# 0.01717f
C198 VCO2_selection_0.XNOR_0._b VCO2_selection_0.NAND_3in_3.c 0.59738f
C199 after_000011_n after_000011 0.75378f
C200 VCO2_selection_0.NAND_3in_7.y 110 0.52128f
C201 after_000011_n after_000111 51.7419f
C202 VCO3_selection_0.NAND_3in_5.y m2_33405_42579# 0.01875f
C203 a_33278_37142# VCO3_selection_0.inverter_4.out 0.01383f
C204 VCO3_selection_0.NAND_3in_6.b VCO3_selection_0.NAND_3in_5.y 0.01379f
C205 after_000011_n c2 6.42485f
C206 after_000111 VCO2_selection_0.NAND_4in_0.b 0.6103f
C207 vp 3bit_to_8_outs_0.NAND_3in_0.y 0.57561f
C208 3bit_to_8_outs_0.inverter_8.in a_32090_26816# 0.08164f
C209 after_000011_n a_31572_36164# 0.01233f
C210 VCO4_selection_0.inverter_2.in VCO4_selection_0.inverter_2.out 0.66566f
C211 VCO2_selection_0.inverter_0.out VCO2_selection_0.inverter_1.out 1.30149f
C212 VCO3_selection_0.XNOR_1._a a_32564_39564# 0.10751f
C213 VCO4_selection_0.NAND_3in_1.y VCO4_selection_0.inverter_2.out 0.04229f
C214 c1 3bit_to_8_outs_0.inverter_1.in 0.6154f
C215 m2_31673_44793# VCO4_selection_0.inverter_2.out 0.18057f
C216 VCO2_selection_0.NAND_4in_0.d 111 0.60846f
C217 m2_32972_29945# VCO2_selection_0.NAND_3in_7.y 0.17968f
C218 VCO3_selection_0.inverter_8.out VCO3_selection_0.NAND_3in_6.c 0.34188f
C219 c0 VCO5_selection_0.inverter_0.in 0.01682f
C220 3bit_to_8_outs_0.NAND_3in_2.y a_31410_26816# 0.07156f
C221 after_000011_n after_001111_n 0.32713f
C222 VCO2_selection_0.NAND_4in_0.c after_000011 0.44833f
C223 f5 f1_n 0.06755f
C224 a_31250_23355# after_000011 0.07642f
C225 VCO4_selection_0.inverter_3.out a_32494_44968# 0.01417f
C226 VCO4_selection_0.inverter_3.in a_31060_45946# 0.0131f
C227 VCO3_selection_0.XNOR_1.y a_32570_40066# 0.07528f
C228 VCO2_selection_0.NAND_2in_0.y m2_32496_33857# 0.22284f
C229 VCO4_selection_0.inverter_5.in a_32058_47902# 0.07528f
C230 f0 a_31592_48788# 0.15356f
C231 VCO2_selection_0.NAND_3in_7.y a_32087_30284# 0.01699f
C232 a_33068_41518# VCO3_selection_0.NOR_2in_4.a 0.05153f
C233 after_000011_n m2_32477_28872# 0.72068f
C234 000 VCO5_selection_0.inverter_1.in 0.34945f
C235 f0 VCO2_selection_0.NAND_3in_3.c 0.36073f
C236 VCO2_selection_0.NAND_4in_0.d a_33260_32714# 0.01118f
C237 after_000011_n m2_30981_46503# 0.69427f
C238 f0 a_32052_48788# 0.02644f
C239 m2_31328_30191# VCO2_selection_0.XNOR_0._b 0.03546f
C240 010 a_32468_42496# 0.01179f
C241 vp VCO5_selection_0.inverter_1.in 0.51563f
C242 VCO4_selection_0.NAND_3in_0.y VCO4_selection_0.inverter_0.out 0.51426f
C243 VCO2_selection_0.inverter_0.out m2_33034_34103# 0.01079f
C244 VCO3_selection_0.NAND_3in_6.b vp 0.38134f
C245 m2_33238_30191# VCO2_selection_0.NOR_2in_0.y 0.17581f
C246 VCO3_selection_0.NAND_3in_2.y VCO3_selection_0.inverter_4.in 0.72472f
C247 VCO3_selection_0.NOR_2in_0.y VCO3_selection_0.inverter_4.out 0.34525f
C248 VCO2_selection_0.NAND_3in_4.y VCO2_selection_0.inverter_6.out 1.1324f
C249 010 101 0.14658f
C250 3bit_to_8_outs_0.inverter_1.in 110 0.4948f
C251 101 a_30790_50186# 0.01155f
C252 VCO3_selection_0.NAND_3in_4.y VCO3_selection_0.inverter_12.out 1.37034f
C253 m2_31939_44629# VCO4_selection_0.NAND_2in_0.a 0.28746f
C254 m2_32841_30841# m2_33323_30841# 0.0168f
C255 111 VCO_selection_0.NAND_2in_1.y 0.3906f
C256 f1_n after_000111_n 0.07472f
C257 VCO2_selection_0.NOR_2in_2.y VCO2_11_sel 0.64107f
C258 VCO4_selection_0.inverter_5.in m2_32494_47563# 0.22722f
C259 f1 after_001111 0.17589f
C260 VCO4_selection_0.inverter_2.out VCO4_selection_0.NAND_2in_0.a 0.1821f
C261 VCO3_selection_0.NAND_3in_2.y after_001111 0.7632f
C262 a_32018_44968# VCO4_selection_0.inverter_0.out 0.01417f
C263 001 a_31572_42022# 0.01155f
C264 VCO_selection_0.NAND_2in_1.y a_31266_50186# 0.07548f
C265 f1 VCO4_selection_0.XNOR_0._b 2.31954f
C266 3bit_to_8_outs_0.c0_n after_000111_n 0.02045f
C267 VCO3_selection_0.NAND_3in_4.y f5_n 0.09615f
C268 vp 3bit_to_8_outs_0.NAND_3in_2.y 0.62479f
C269 VCO4_selection_0.inverter_4.in a_31956_46420# 0.01202f
C270 vp VCO3_selection_0.NAND_3in_1.y 0.57214f
C271 101 VCO2_selection_0.NAND_3in_4.y 0.68309f
C272 m2_33006_39973# m2_33006_39891# 0.16814f
C273 010 f5_n 0.5266f
C274 001 a_32772_28789# 0.01179f
C275 f0 a_31598_47902# 0.04506f
C276 after_000011_n m2_31493_40623# 0.20011f
C277 010 011 37.3732f
C278 m2_30711_49775# VCO_selection_0.NAND_2in_0.y 0.09896f
C279 row_section_decoding_0.NAND_2in_0.b f4 0.2187f
C280 c1 3bit_to_8_outs_0.c1_n 0.97581f
C281 VCO4_selection_0.NOR_2in_0.b VCO4_selection_0.NOR_2in_0.a 2.26831f
C282 VCO3_selection_0.XNOR_1.y VCO3_selection_0.inverter_12.out 0.48133f
C283 3bit_to_8_outs_0.NAND_3in_6.y a_31626_26498# 0.0131f
C284 VCO5_selection_0.inverter_0.in m2_32192_28222# 0.03999f
C285 VCO_selection_0.NAND_2in_2.y after_000111 0.55846f
C286 a_31407_34196# f5_n 0.01632f
C287 VCO4_selection_0.NAND_2in_0.b a_32494_43990# 0.01066f
C288 after_000011_n VCO3_selection_0.NAND_2in_1.y 0.43474f
C289 after_000111_n a_31877_32240# 0.01591f
C290 m2_32496_34103# after_001111 0.0169f
C291 001 3bit_to_8_outs_0.inverter_8.in 0.68132f
C292 001 after_000011 1.07128f
C293 m2_30711_49775# m2_31181_49775# 0.01839f
C294 VCO3_selection_0.inverter_11.out m2_32989_41929# 0.01203f
C295 m2_32841_30841# VCO2_selection_0.XNOR_0._b 0.04838f
C296 after_000011_n after_001111 0.65745f
C297 m2_31673_44547# VCO4_selection_0.inverter_2.out 0.09799f
C298 001 after_000111 10.5766f
C299 c0 3bit_to_8_outs_0.NAND_3in_0.y 0.39237f
C300 f0 a_32564_39564# 0.02763f
C301 VCO3_selection_0.NAND_3in_2.y m2_33199_36803# 0.01859f
C302 VCO3_selection_0.inverter_0.out m2_33006_38677# 0.02626f
C303 VCO3_selection_0.NAND_3in_6.a m2_33405_42579# 0.16775f
C304 VCO5_selection_0.inverter_1.in VCO5_selection_0.NAND_2in_0.b 0.6449f
C305 VCO3_selection_0.NAND_3in_6.b VCO3_selection_0.NAND_3in_6.a 0.97809f
C306 VCO4_selection_0.inverter_5.in VCO4_selection_0.XNOR_1._b 0.66266f
C307 VCO3_selection_0.inverter_7.out vp 0.44117f
C308 3bit_to_8_outs_0.inverter_10.in a_32090_26498# 0.08164f
C309 100 a_32258_36164# 0.01155f
C310 f1 VCO4_selection_0.XNOR_1._b 2.34913f
C311 VCO4_selection_0.NAND_3in_0.y vp 0.634f
C312 a_30990_22377# a_30774_22377# 0.02909f
C313 VCO2_selection_0.inverter_1.out m2_32824_34753# 0.01172f
C314 after_001111_n 001 0.06878f
C315 VCO3_selection_0.NOR_2in_4.b m2_32989_41929# 0.01079f
C316 000 f4 0.01539f
C317 VCO2_selection_0.NAND_3in_3.y VCO2_selection_0.NOR_2in_0.a 0.51755f
C318 m2_31673_43651# VCO4_selection_0.inverter_0.out 0.17997f
C319 vp f4 0.50499f
C320 VCO3_selection_0.NAND_3in_6.c VCO3_5_sel 0.76573f
C321 3bit_to_8_outs_0.inverter_1.in a_31410_24854# 0.07156f
C322 111 f1 0.11983f
C323 f5 after_000011 1.16676f
C324 VCO5_selection_0.inverter_1.out VCO5_selection_0.NOR_2in_0.y 0.39821f
C325 VCO5_selection_0.NAND_2in_0.b a_33013_28315# 0.01589f
C326 vp a_32018_44968# 0.12274f
C327 VCO5_selection_0.NAND_2in_0.b 3bit_to_8_outs_0.NAND_3in_2.y 0.05016f
C328 VCO5_selection_0.inverter_1.out 3bit_to_8_outs_0.inverter_8.in 0.01741f
C329 vp a_33113_33692# 0.12263f
C330 001 m2_30981_46503# 0.01832f
C331 VCO5_selection_0.XNOR_0._a f1 0.60852f
C332 VCO2_selection_0.NOR_2in_1.y m2_33034_34021# 0.27819f
C333 after_000111 f5 0.89075f
C334 VCO3_selection_0.NAND_3in_7.y VCO3_selection_0.inverter_4.in 0.0494f
C335 f5 c2 0.0147f
C336 after_000011_n VCO2_selection_0.inverter_2.in 0.76587f
C337 VCO3_selection_0.inverter_4.out m2_33199_36721# 0.01079f
C338 a_31788_42496# 011 0.01179f
C339 m2_31925_23438# row_section_decoding_0.NAND_2in_0.b 0.01721f
C340 a_30783_28315# VCO5_selection_0.inverter_1.in 0.07562f
C341 m2_33405_42661# m2_33405_42579# 0.40984f
C342 VCO_sel a_31476_49868# 0.07049f
C343 VCO3_selection_0.NAND_2in_0.y a_31572_42022# 0.07562f
C344 VCO3_selection_0.inverter_10.out m2_32865_42661# 0.18043f
C345 VCO3_selection_0.NAND_2in_0.y VCO3_selection_0.NOR_2in_4.a 0.61207f
C346 vp VCO3_selection_0.inverter_4.out 0.34741f
C347 a_31598_48376# VCO4_selection_0.XNOR_0._b 0.04746f
C348 m2_32494_47809# VCO4_selection_0.XNOR_1._b 0.0481f
C349 010 VCO3_selection_0.NAND_3in_9.y 0.59886f
C350 010 VCO4_selection_0.NOR_2in_0.a 0.03536f
C351 after_001111_n f5 0.80193f
C352 VCO4_5_sel VCO4_selection_0.NOR_2in_0.a 0.1768f
C353 VCO5_selection_0.NAND_2in_0.b m2_32458_28222# 0.41035f
C354 VCO4_5_sel VCO3_selection_0.NAND_3in_9.y 0.05475f
C355 after_001111_n a_31572_42496# 0.01632f
C356 VCO2_selection_0.NOR_2in_2.y m2_32824_34753# 0.16564f
C357 a_33085_39098# VCO3_selection_0.inverter_5.out 0.01419f
C358 VCO3_selection_0.inverter_0.out VCO3_selection_0.NAND_3in_0.c 0.28601f
C359 a_32252_40540# a_32468_40540# 0.02909f
C360 m2_32865_37945# m2_33137_37945# 0.01717f
C361 after_000011_n 111 0.8016f
C362 c0 3bit_to_8_outs_0.NAND_3in_2.y 0.63466f
C363 VCO3_selection_0.inverter_2.out vp 0.33501f
C364 a_32018_43486# vp 0.12279f
C365 3bit_to_8_outs_0.c0_n a_31410_26498# 0.01179f
C366 VCO4_selection_0.NAND_3in_2.y 011 0.63803f
C367 VCO5_selection_0.inverter_2.in a_31321_28789# 0.07105f
C368 after_000111_n after_000011 62.888f
C369 VCO2_selection_0.XNOR_0._a VCO2_selection_0.NAND_3in_3.c 1.05082f
C370 VCO4_selection_0.NOR_2in_0.b VCO4_5_sel 0.72687f
C371 a_31519_28315# VCO5_selection_0.NAND_2in_0.b 0.07156f
C372 VCO3_selection_0.NAND_3in_7.y VCO3_selection_0.inverter_0.out 0.51396f
C373 VCO3_selection_0.NAND_2in_0.y m2_32989_41847# 0.01859f
C374 vp VCO4_selection_0.XNOR_0._a 0.3542f
C375 m2_30711_49693# 110 0.07573f
C376 after_000111 after_000111_n 0.64753f
C377 vp 3bit_to_8_outs_0.NAND_3in_3.y 0.57491f
C378 VCO_selection_0.NAND_2in_2.y after_001111 0.13364f
C379 c2 after_000111_n 0.02295f
C380 VCO2_selection_0.NAND_3in_5.c vp 0.4049f
C381 vp VCO5_selection_0.inverter_2.out 0.33206f
C382 a_31572_36164# after_000111_n 0.01632f
C383 vp VCO4_selection_0.XNOR_0.y 0.50198f
C384 f5_n a_31572_36638# 0.01809f
C385 vp a_33085_39098# 0.12263f
C386 a_32152_32714# a_32368_32714# 0.02909f
C387 VCO5_selection_0.NOR_2in_0.y a_32537_27811# 0.08009f
C388 m2_32933_36721# m2_33199_36721# 0.01796f
C389 VCO2_selection_0.NAND_4in_0.c 111 0.19692f
C390 VCO3_selection_0.XNOR_0._a f1 0.9369f
C391 001 after_001111 0.24085f
C392 vp VCO2_selection_0.NOR_2in_0.b 0.32576f
C393 a_31956_45946# 000 0.01179f
C394 after_001111_n after_000111_n 42.4109f
C395 VCO2_selection_0.NAND_3in_3.y m2_32700_29945# 0.22771f
C396 VCO3_selection_0.inverter_11.out VCO4_selection_0.NAND_2in_0.a 0.01121f
C397 VCO3_selection_0.NAND_3in_3.y a_32468_38120# 0.01154f
C398 VCO5_selection_0.inverter_1.in m2_32192_28222# 0.01803f
C399 VCO3_5_sel VCO3_selection_0.NAND_3in_0.c 0.02815f
C400 VCO5_selection_0.inverter_2.in VCO2_selection_0.NAND_3in_7.y 0.01255f
C401 a_31788_36164# VCO3_selection_0.NAND_3in_1.y 0.07156f
C402 VCO4_selection_0.inverter_4.in VCO4_selection_0.XNOR_0.y 1.33693f
C403 VCO3_selection_0.inverter_1.out VCO3_selection_0.NOR_2in_1.y 0.28822f
C404 000 f1_n 0.08403f
C405 100 VCO2_selection_0.NOR_2in_2.b 0.01255f
C406 010 m2_30981_43897# 0.01002f
C407 100 m2_30761_25501# 0.18285f
C408 VCO2_selection_0.NOR_2in_0.a m2_33238_30191# 0.42211f
C409 VCO2_selection_0.NAND_3in_5.c m2_33323_30841# 0.17136f
C410 VCO5_selection_0.inverter_1.in a_31303_28315# 0.0146f
C411 VCO5_selection_0.NOR_2in_0.y m2_32934_28222# 0.01152f
C412 m2_31328_30191# VCO2_selection_0.XNOR_0._a 0.01647f
C413 VCO2_selection_0.inverter_3.in m2_32286_34753# 0.01039f
C414 001 VCO2_selection_0.NOR_2in_0.a 0.02068f
C415 vp f1_n 0.38219f
C416 VCO5_11_sel m2_32934_28222# 0.09896f
C417 VCO2_selection_0.inverter_3.in vp 0.39279f
C418 VCO2_selection_0.NAND_4in_0.d VCO2_selection_0.NAND_4in_0.b 0.05019f
C419 m2_33176_31901# VCO2_selection_0.inverter_6.out 0.18075f
C420 VCO2_selection_0.NAND_3in_3.c 110 0.16224f
C421 c0 f4 0.29601f
C422 VCO2_selection_0.NOR_2in_1.y VCO3_selection_0.NOR_2in_1.y 0.02846f
C423 vp VCO4_selection_0.XNOR_1._a 0.35929f
C424 vp 3bit_to_8_outs_0.c0_n 1.79282f
C425 after_000011_n VCO3_selection_0.XNOR_0._a 0.02535f
C426 f5 a_31510_22377# 0.01383f
C427 VCO5_selection_0.inverter_2.out m2_32217_28954# 0.18043f
C428 VCO3_selection_0.inverter_0.out VCO3_selection_0.XNOR_0._b 0.09107f
C429 a_33476_38120# VCO3_selection_0.NAND_3in_0.c 0.02239f
C430 a_31060_44464# a_31276_44464# 0.02909f
C431 VCO5_selection_0.XNOR_0._b VCO5_selection_0.XNOR_0._a 0.62619f
C432 m2_30981_44547# m2_30981_43897# 0.0462f
C433 f5 after_001111 0.31134f
C434 a_33044_32714# a_33260_32714# 0.02909f
C435 f0 f4 0.01636f
C436 VCO2_selection_0.inverter_3.in a_31883_34670# 0.07562f
C437 a_31626_24854# a_31410_24854# 0.02909f
C438 VCO2_selection_0.NAND_4in_0.d VCO2_selection_0.NAND_4in_0.c 2.31334f
C439 VCO3_selection_0.NAND_3in_6.b m2_33407_40623# 0.03054f
C440 a_31788_36638# VCO3_selection_0.NAND_3in_2.y 0.07156f
C441 VCO4_selection_0.NOR_2in_0.a VCO4_selection_0.NAND_3in_2.y 0.53242f
C442 VCO_selection_0.NAND_2in_2.y 111 0.34993f
C443 010 VCO4_5_sel 0.01923f
C444 after_000011_n VCO5_selection_0.inverter_0.out 0.0116f
C445 VCO3_selection_0.inverter_11.out m2_33137_42661# 0.18027f
C446 VCO3_selection_0.inverter_12.out m2_33006_39727# 0.17998f
C447 m2_31493_40623# after_000111_n 0.67515f
C448 m2_32192_28222# m2_32458_28222# 0.01796f
C449 VCO3_selection_0.XNOR_1.y VCO3_selection_0.NAND_3in_4.y 0.02827f
C450 a_32087_30284# VCO2_selection_0.NAND_3in_3.c 0.02066f
C451 001 a_31315_29201# 0.01395f
C452 VCO3_selection_0.NOR_2in_4.a VCO3_selection_0.NAND_3in_5.y 0.01344f
C453 VCO2_selection_0.NAND_3in_3.c VCO2_selection_0.inverter_6.out 0.089f
C454 VCO3_selection_0.inverter_10.out m2_33405_42579# 0.01079f
C455 after_000111 VCO2_selection_0.NAND_4in_0.a 0.84259f
C456 001 111 0.04795f
C457 a_31572_40540# after_000111_n 0.01632f
C458 VCO2_selection_0.NAND_4in_0.d a_33044_32714# 0.01181f
C459 001 VCO5_selection_0.XNOR_0._a 0.18013f
C460 after_000111_n after_001111 0.71632f
C461 3bit_to_8_outs_0.NAND_3in_2.y 3bit_to_8_outs_0.NAND_3in_6.y 0.08826f
C462 c1 3bit_to_8_outs_0.NAND_3in_0.y 0.72792f
C463 m2_31673_44793# VCO4_selection_0.inverter_2.in 0.22771f
C464 c0 3bit_to_8_outs_0.NAND_3in_3.y 0.63462f
C465 vp a_33484_43000# 0.12263f
C466 3bit_to_8_outs_0.inverter_8.in a_31410_26816# 0.01202f
C467 row_section_decoding_0.NAND_2in_0.b after_000011 1.19811f
C468 a_31303_28315# a_31519_28315# 0.02909f
C469 a_32110_38594# VCO3_selection_0.XNOR_0._b 0.04746f
C470 a_32468_40540# VCO3_selection_0.NAND_3in_8.y 0.07156f
C471 VCO3_selection_0.NAND_3in_7.c m2_32865_37945# 0.01766f
C472 VCO2_selection_0.inverter_2.in f5 0.3739f
C473 VCO4_selection_0.inverter_3.out VCO4_selection_0.NAND_2in_0.a 0.12276f
C474 after_001111_n VCO2_selection_0.NAND_4in_0.a 0.60375f
C475 vp VCO2_selection_0.NOR_2in_0.y 0.23395f
C476 f1_n VCO5_selection_0.NAND_2in_0.b 0.57818f
C477 VCO3_selection_0.NAND_3in_8.y m2_32865_40869# 0.22771f
C478 m2_32700_30109# VCO2_selection_0.NAND_3in_7.y 0.16871f
C479 f0 VCO4_selection_0.XNOR_0._a 1.65924f
C480 a_31877_32240# a_32093_32240# 0.02909f
C481 a_33068_41518# VCO3_selection_0.NOR_2in_4.b 0.01383f
C482 VCO4_selection_0.inverter_5.in f1 0.99709f
C483 f0 VCO4_selection_0.XNOR_0.y 0.35906f
C484 VCO3_selection_0.NAND_3in_5.y after_000111 0.80426f
C485 a_32556_28789# VCO5_selection_0.inverter_0.in 0.01382f
C486 VCO3_selection_0.NOR_2in_4.a vp 0.447f
C487 VCO2_selection_0.NAND_2in_0.y after_001111 0.43886f
C488 3bit_to_8_outs_0.NAND_3in_0.y 110 0.68256f
C489 vp a_32104_39006# 0.17102f
C490 111 f5 0.16272f
C491 after_001111_n row_section_decoding_0.NAND_2in_0.b 0.16309f
C492 VCO2_selection_0.inverter_2.in a_31407_34670# 0.07562f
C493 m2_32841_30841# VCO2_selection_0.inverter_4.out 0.01201f
C494 a_31788_38120# after_000111_n 0.0118f
C495 a_31945_30758# VCO2_selection_0.XNOR_0._b 0.04746f
C496 m2_31939_44629# VCO4_selection_0.inverter_0.out 0.49866f
C497 c0 f1_n 0.03381f
C498 VCO2_selection_0.inverter_0.out m2_32496_34103# 0.09739f
C499 VCO3_selection_0.NAND_3in_5.y after_001111_n 1.2127f
C500 m2_33323_30841# VCO2_selection_0.NOR_2in_0.y 0.01368f
C501 after_000011_n VCO4_selection_0.inverter_2.in 0.06283f
C502 VCO3_selection_0.inverter_7.out m2_33407_40623# 0.01092f
C503 VCO2_selection_0.NAND_4in_0.d a_32779_32240# 0.01407f
C504 c0 3bit_to_8_outs_0.c0_n 2.85077f
C505 VCO4_selection_0.inverter_2.out VCO4_selection_0.inverter_0.out 0.90162f
C506 VCO2_selection_0.inverter_1.out VCO2_selection_0.NAND_4in_0.a 0.0262f
C507 VCO2_selection_0.inverter_0.out VCO2_selection_0.NAND_4in_0.b 0.01956f
C508 000 after_000011 1.15709f
C509 VCO4_selection_0.NAND_3in_1.y VCO4_selection_0.NAND_2in_0.a 0.04227f
C510 000 3bit_to_8_outs_0.inverter_8.in 0.41628f
C511 vp VCO5_selection_0.NOR_2in_0.y 0.33045f
C512 f5_n m2_32865_42661# 0.01756f
C513 VCO3_selection_0.NAND_3in_6.a a_33561_40066# 0.01188f
C514 f0 f1_n 0.04431f
C515 vp 3bit_to_8_outs_0.inverter_8.in 0.5801f
C516 vp after_000011 1.46517f
C517 000 after_000111 1.07482f
C518 vp VCO5_11_sel 0.23519f
C519 after_000011_n f1 4.58768f
C520 001 3bit_to_8_outs_0.c2_n 0.01474f
C521 f0 VCO4_selection_0.XNOR_1._a 1.65918f
C522 after_000111 vp 1.53463f
C523 VCO4_selection_0.NAND_2in_0.b VCO4_selection_0.NOR_2in_0.a 0.33407f
C524 VCO4_selection_0.NAND_2in_0.b VCO3_selection_0.NAND_3in_9.y 0.0275f
C525 a_33484_43000# VCO3_selection_0.NAND_3in_6.a 0.08009f
C526 vp c2 0.49333f
C527 f3 f4 0.73641f
C528 VCO3_selection_0.NAND_2in_3.y VCO3_selection_0.NOR_2in_4.b 0.47819f
C529 a_32468_38120# 011 0.01179f
C530 111 after_000111_n 0.28426f
C531 a_31986_22377# f4 0.04801f
C532 m2_32841_30923# f1 0.01358f
C533 VCO_selection_0.NAND_2in_2.y VCO_selection_0.NAND_2in_1.y 0.33238f
C534 VCO2_selection_0.NOR_2in_1.y VCO2_5_sel 0.03688f
C535 VCO3_11_sel a_33692_38120# 0.07156f
C536 VCO3_selection_0.XNOR_0._b VCO3_selection_0.XNOR_0._a 0.56598f
C537 a_32090_25172# a_32306_25172# 0.02909f
C538 VCO4_selection_0.NAND_2in_0.b VCO4_selection_0.NOR_2in_0.b 1.03604f
C539 a_32468_40540# 110 0.01179f
C540 000 after_001111_n 0.0833f
C541 m2_30981_45853# VCO4_selection_0.XNOR_0.y 0.02589f
C542 f0 a_31945_30758# 0.04506f
C543 after_001111_n vp 0.73549f
C544 VCO_selection_0.NAND_2in_0.y after_001111 0.33574f
C545 a_32048_42022# 101 0.01155f
C546 m2_31673_44547# VCO4_selection_0.inverter_2.in 0.01049f
C547 VCO_selection_0.NAND_2in_0.y VCO4_selection_0.XNOR_0._b 0.01683f
C548 VCO3_selection_0.NOR_2in_0.y m2_33199_36803# 0.27137f
C549 m2_32841_30841# VCO2_selection_0.inverter_6.out 0.01105f
C550 a_32093_32240# after_000011 0.04356f
C551 VCO3_selection_0.NAND_3in_6.b a_33345_40066# 0.04933f
C552 VCO2_selection_0.NOR_2in_2.a a_32903_35174# 0.05153f
C553 VCO3_selection_0.inverter_8.out vp 0.34832f
C554 100 VCO3_selection_0.NAND_3in_1.y 0.57648f
C555 a_31510_22377# row_section_decoding_0.NAND_2in_0.b 0.08005f
C556 after_000011_n VCO2_selection_0.NAND_3in_3.y 0.98203f
C557 VCO4_selection_0.NAND_3in_0.y m2_31673_43815# 0.0115f
C558 001 a_31788_36638# 0.01179f
C559 3bit_to_8_outs_0.NAND_3in_6.y 3bit_to_8_outs_0.NAND_3in_3.y 0.15363f
C560 VCO4_selection_0.inverter_5.out VCO4_selection_0.XNOR_0.y 1.22833f
C561 VCO4_selection_0.inverter_3.out VCO4_11_sel 0.52597f
C562 3bit_to_8_outs_0.inverter_10.in a_31410_26498# 0.01202f
C563 000 VCO4_selection_0.inverter_2.out 0.03326f
C564 3bit_to_8_outs_0.NAND_3in_0.y a_31410_24854# 0.01202f
C565 f1_n a_31303_28315# 0.01632f
C566 VCO2_selection_0.NAND_4in_0.d after_000111_n 0.67463f
C567 VCO5_selection_0.NAND_2in_0.b VCO5_selection_0.NOR_2in_0.y 1.06592f
C568 VCO3_selection_0.NOR_2in_4.b m2_32451_41929# 0.09739f
C569 VCO5_selection_0.inverter_1.out VCO5_selection_0.inverter_0.out 1.16457f
C570 f2 f4 0.01539f
C571 vp VCO4_selection_0.inverter_2.out 0.45107f
C572 after_000011_n a_31740_46420# 0.01632f
C573 vp VCO2_selection_0.inverter_1.out 0.44578f
C574 VCO4_selection_0.inverter_4.in m2_30981_46503# 0.12874f
C575 VCO5_selection_0.XNOR_0._b f1 2.14734f
C576 VCO5_11_sel VCO5_selection_0.NAND_2in_0.b 0.56042f
C577 a_31407_32714# VCO2_selection_0.NAND_4in_0.a 0.0131f
C578 VCO2_selection_0.NAND_4in_0.c VCO2_selection_0.NAND_4in_0.b 0.44509f
C579 m2_31673_43897# VCO4_selection_0.inverter_0.out 0.09739f
C580 VCO2_selection_0.XNOR_0._b after_000011 0.19245f
C581 a_32104_39006# VCO3_selection_0.NAND_3in_7.c 0.10853f
C582 000 VCO3_selection_0.inverter_4.in 0.54666f
C583 a_33589_34670# VCO2_11_sel 0.07047f
C584 VCO4_selection_0.NOR_2in_1.a VCO4_selection_0.XNOR_0.y 3.15587f
C585 c2 a_32306_25172# 0.01632f
C586 VCO3_selection_0.NAND_2in_0.y VCO3_selection_0.NOR_2in_4.b 0.53082f
C587 VCO3_selection_0.NAND_3in_9.y m2_32865_42661# 0.0115f
C588 vp VCO3_selection_0.inverter_4.in 0.39504f
C589 VCO2_selection_0.NOR_2in_2.b a_32903_35174# 0.01383f
C590 f0 a_32104_39006# 0.15466f
C591 001 m2_31033_27145# 0.17997f
C592 VCO3_selection_0.inverter_4.out m2_32661_36721# 0.09739f
C593 VCO3_selection_0.NAND_3in_0.c m2_33006_38677# 0.16213f
C594 vp a_30774_23859# 0.12461f
C595 VCO3_selection_0.inverter_0.out VCO3_selection_0.inverter_5.out 0.95037f
C596 c0 VCO5_selection_0.NOR_2in_0.y 0.05823f
C597 vp a_31510_22377# 0.12284f
C598 000 after_001111 0.77475f
C599 c0 3bit_to_8_outs_0.inverter_8.in 0.47907f
C600 VCO3_selection_0.NAND_2in_1.y vp 0.39586f
C601 c0 after_000011 0.03616f
C602 VCO3_selection_0.inverter_12.out VCO3_selection_0.NAND_3in_6.b 0.15763f
C603 VCO4_selection_0.NAND_3in_1.y VCO4_11_sel 0.52663f
C604 110 f4 0.01539f
C605 VCO5_11_sel c0 0.02961f
C606 3bit_to_8_outs_0.c0_n 3bit_to_8_outs_0.NAND_3in_6.y 0.63468f
C607 f1_n f3 0.01117f
C608 after_000011_n VCO5_selection_0.XNOR_0._b 0.03376f
C609 vp after_001111 0.77555f
C610 100 f4 0.01539f
C611 VCO4_selection_0.NAND_2in_0.b VCO4_5_sel 0.43786f
C612 after_000111 c0 0.03347f
C613 001 f1 0.32414f
C614 after_000011_n VCO3_selection_0.NAND_3in_7.y 0.72492f
C615 001 VCO3_selection_0.NAND_3in_2.y 0.38034f
C616 c0 c2 0.59815f
C617 vp VCO4_selection_0.XNOR_0._b 0.34793f
C618 3bit_to_8_outs_0.c0_n row_section_decoding_0.NAND_2in_0.a 0.01085f
C619 vp 3bit_to_8_outs_0.inverter_6.in 0.55377f
C620 VCO2_selection_0.NOR_2in_2.y vp 0.32635f
C621 f0 after_000011 0.11992f
C622 vp 3bit_to_8_outs_0.inverter_10.in 0.55378f
C623 111 m2_31181_49775# 0.03582f
C624 vp VCO3_selection_0.inverter_0.out 0.47342f
C625 VCO2_selection_0.NAND_4in_0.c a_33044_32714# 0.01462f
C626 VCO5_selection_0.inverter_0.out a_32537_27811# 0.05153f
C627 VCO3_selection_0.NAND_3in_3.y m2_32865_37945# 0.16871f
C628 VCO3_selection_0.inverter_1.out m2_33199_36071# 0.01348f
C629 vp a_32494_44968# 0.12263f
C630 after_000111 f0 0.10563f
C631 m2_30711_49775# 110 0.01072f
C632 VCO3_selection_0.inverter_1.out a_33278_35660# 0.05153f
C633 f0 c2 0.01628f
C634 after_001111_n c0 0.07404f
C635 011 a_31956_46420# 0.01179f
C636 VCO3_selection_0.XNOR_0._b f1 2.15254f
C637 vp VCO2_selection_0.NOR_2in_0.a 0.42193f
C638 VCO_selection_0.NAND_2in_2.y a_31260_49868# 0.01951f
C639 VCO3_selection_0.XNOR_1.y m2_33006_39727# 0.22722f
C640 m2_32661_36721# m2_32933_36721# 0.01717f
C641 m2_33199_36803# m2_33199_36721# 0.40984f
C642 after_000011_n 001 2.21383f
C643 after_001111_n f0 0.0802f
C644 VCO3_selection_0.inverter_2.out VCO3_selection_0.NOR_2in_1.y 0.63146f
C645 VCO2_selection_0.NAND_3in_5.c VCO2_selection_0.inverter_4.out 1.00912f
C646 VCO2_selection_0.NOR_2in_1.y m2_33294_34753# 0.03387f
C647 a_31740_45946# a_31956_45946# 0.02909f
C648 f5_n VCO3_selection_0.NAND_3in_1.y 0.01773f
C649 f5 f1 35.7351f
C650 VCO2_selection_0.inverter_2.in m2_32286_34753# 0.16872f
C651 001 VCO2_selection_0.NAND_3in_3.y 0.03736f
C652 a_32093_34196# after_001111 0.04478f
C653 a_31572_36164# a_31788_36164# 0.02909f
C654 VCO2_selection_0.inverter_2.in vp 0.35486f
C655 VCO2_selection_0.NAND_4in_0.d VCO2_selection_0.NAND_4in_0.a 0.02701f
C656 m2_33176_31901# VCO2_selection_0.NAND_3in_4.y 0.22771f
C657 VCO3_selection_0.XNOR_0._b m2_33006_38677# 0.04838f
C658 vp VCO3_5_sel 0.38845f
C659 VCO2_selection_0.NAND_3in_3.c a_32399_31170# 0.11751f
C660 VCO3_selection_0.NAND_2in_3.y after_000011_n 0.44828f
C661 vp VCO4_selection_0.XNOR_1._b 0.32994f
C662 f1_n f2 0.01763f
C663 f1_n c1 0.02001f
C664 after_000011_n VCO3_selection_0.XNOR_0._b 0.09431f
C665 a_32306_24854# 3bit_to_8_outs_0.NAND_3in_0.y 0.02306f
C666 VCO3_selection_0.NAND_3in_5.y VCO3_selection_0.inverter_11.out 0.56099f
C667 c1 3bit_to_8_outs_0.c0_n 2.09798f
C668 m2_30981_45853# after_000011 0.01284f
C669 000 111 0.0459f
C670 vp a_32920_31262# 0.12273f
C671 vp a_31315_29201# 0.17102f
C672 VCO4_selection_0.NAND_3in_1.y after_000111_n 0.53611f
C673 VCO3_selection_0.inverter_10.out a_33484_43000# 0.01383f
C674 VCO3_selection_0.inverter_12.out VCO3_selection_0.inverter_7.out 0.35164f
C675 a_31276_45946# 001 0.01315f
C676 101 f4 0.01539f
C677 a_31626_24854# 3bit_to_8_outs_0.inverter_1.in 0.0131f
C678 111 vp 1.88659f
C679 a_32306_25172# 3bit_to_8_outs_0.inverter_6.in 0.02306f
C680 VCO4_selection_0.inverter_4.in VCO4_selection_0.XNOR_1._b 0.01484f
C681 vp VCO5_selection_0.XNOR_0._a 0.32568f
C682 VCO4_selection_0.inverter_3.out m2_32625_45771# 0.19204f
C683 after_000011_n f5 2.13072f
C684 after_000011_n VCO5_selection_0.inverter_1.out 0.6148f
C685 f1 after_000111_n 0.35067f
C686 VCO3_selection_0.XNOR_1._b f1 2.15454f
C687 VCO2_selection_0.NOR_2in_0.b m2_32972_29945# 0.19766f
C688 m2_32700_30109# VCO2_selection_0.NAND_3in_3.c 0.01766f
C689 VCO2_selection_0.NAND_3in_7.y VCO2_selection_0.NAND_3in_3.c 0.77144f
C690 f1_n 110 0.02632f
C691 a_31626_25172# 3bit_to_8_outs_0.NAND_3in_3.y 0.0131f
C692 VCO2_selection_0.NAND_3in_5.c VCO2_selection_0.inverter_6.out 0.30445f
C693 VCO3_selection_0.NOR_2in_4.b VCO3_selection_0.NAND_3in_5.y 0.01658f
C694 100 f1_n 0.02535f
C695 100 VCO2_selection_0.inverter_3.in 0.03598f
C696 VCO2_selection_0.NAND_3in_3.c VCO2_selection_0.NAND_3in_4.y 0.03636f
C697 111 a_31883_34670# 0.01155f
C698 VCO_selection_0.NAND_2in_1.y VCO_selection_0.NAND_2in_0.y 0.88942f
C699 VCO3_selection_0.inverter_12.out m2_33006_39973# 0.09739f
C700 c0 after_001111 0.03296f
C701 VCO2_selection_0.NAND_2in_0.y VCO2_selection_0.inverter_0.out 0.47459f
C702 f5_n f4 0.0156f
C703 001 VCO5_selection_0.XNOR_0._b 0.23032f
C704 011 f4 0.01539f
C705 c0 3bit_to_8_outs_0.inverter_6.in 0.47975f
C706 vp VCO3_selection_0.inverter_11.out 0.41762f
C707 VCO3_selection_0.NAND_3in_5.y a_32252_42496# 0.01221f
C708 VCO3_selection_0.NAND_3in_8.y VCO3_selection_0.NOR_2in_4.a 0.02076f
C709 VCO2_selection_0.NAND_4in_0.c f5 0.30239f
C710 after_000011_n a_31407_34670# 0.01005f
C711 after_000011_n m2_32451_41929# 0.01692f
C712 m2_30761_24515# 3bit_to_8_outs_0.NAND_3in_0.y 0.17968f
C713 m2_30981_46503# m2_30981_45853# 0.02834f
C714 c0 3bit_to_8_outs_0.inverter_10.in 0.43475f
C715 VCO_selection_0.NAND_2in_1.y m2_31181_49775# 0.05606f
C716 row_section_decoding_0.NAND_2in_0.a after_000011 0.65285f
C717 VCO3_selection_0.inverter_0.out VCO3_selection_0.NAND_3in_7.c 0.3152f
C718 VCO3_selection_0.inverter_5.out VCO3_selection_0.XNOR_0._a 0.01362f
C719 VCO4_selection_0.inverter_3.out VCO4_selection_0.inverter_0.out 0.02918f
C720 f3 after_000011 0.07572f
C721 f0 after_001111 0.10738f
C722 111 a_32093_32240# 0.01179f
C723 after_000011_n after_000111_n 1.94078f
C724 VCO3_selection_0.XNOR_1._b after_000011_n 0.09483f
C725 VCO5_selection_0.inverter_1.in VCO5_selection_0.inverter_2.in 0.01657f
C726 f0 VCO4_selection_0.XNOR_0._b 0.53548f
C727 101 3bit_to_8_outs_0.NAND_3in_3.y 0.49479f
C728 VCO3_5_sel VCO3_selection_0.NAND_3in_6.a 0.83147f
C729 after_000111 f3 0.01116f
C730 VCO3_selection_0.NAND_3in_7.y VCO3_selection_0.XNOR_0._b 0.01229f
C731 VCO3_selection_0.NAND_2in_0.y after_000011_n 0.77138f
C732 VCO2_selection_0.NAND_4in_0.d vp 0.57213f
C733 f0 VCO3_selection_0.inverter_0.out 0.01835f
C734 m2_31328_30191# VCO2_selection_0.NAND_3in_7.y 0.11582f
C735 VCO3_selection_0.NOR_2in_4.b vp 0.35683f
C736 a_31407_30284# VCO2_selection_0.NAND_3in_7.y 0.01332f
C737 vp VCO3_selection_0.XNOR_0._a 0.3579f
C738 after_001111_n f3 0.01116f
C739 a_32152_32714# 101 0.01206f
C740 a_32303_30284# 110 0.01179f
C741 VCO2_selection_0.NAND_4in_0.c after_000111_n 0.36481f
C742 after_001111_n a_31986_22377# 0.08009f
C743 VCO2_selection_0.NOR_2in_0.y VCO2_selection_0.inverter_4.out 1.15986f
C744 111 VCO2_selection_0.XNOR_0._b 0.0244f
C745 VCO2_selection_0.NAND_2in_0.y m2_32496_34103# 0.01039f
C746 vp 3bit_to_8_outs_0.c2_n 0.58168f
C747 a_32563_32240# VCO2_selection_0.NAND_3in_4.y 0.0131f
C748 VCO3_selection_0.inverter_8.out m2_33407_40623# 0.01079f
C749 VCO2_selection_0.NAND_2in_0.y VCO2_selection_0.NAND_4in_0.b 0.02117f
C750 VCO2_selection_0.inverter_0.out VCO2_selection_0.NAND_4in_0.a 0.0351f
C751 VCO3_selection_0.XNOR_1.y a_32564_39564# 0.11436f
C752 VCO3_selection_0.XNOR_1._a VCO3_selection_0.XNOR_0._a 0.04548f
C753 m2_31033_26159# 3bit_to_8_outs_0.NAND_3in_6.y 0.21959f
C754 m2_31673_44793# VCO4_selection_0.inverter_0.out 0.02654f
C755 vp VCO5_selection_0.inverter_0.out 0.4327f
C756 101 f1_n 0.02578f
C757 m2_31653_23684# after_000011 0.2263f
C758 VCO3_selection_0.inverter_7.out m2_33407_40705# 0.10644f
C759 VCO_selection_0.NAND_2in_2.y f5 0.29473f
C760 VCO3_selection_0.NAND_3in_3.y after_000011 0.58308f
C761 a_33345_40066# a_33561_40066# 0.02909f
C762 VCO2_selection_0.NAND_4in_0.d a_32093_32240# 0.07152f
C763 a_32110_38594# VCO3_selection_0.NAND_3in_7.c 0.07127f
C764 f0 VCO4_selection_0.XNOR_1._b 0.53543f
C765 f2 after_000011 0.0174f
C766 VCO_selection_0.NAND_2in_1.y vp 0.49315f
C767 VCO4_selection_0.NAND_3in_0.y VCO4_selection_0.NOR_2in_0.a 0.15328f
C768 VCO3_selection_0.inverter_11.out VCO3_selection_0.NAND_3in_6.a 0.26648f
C769 c1 after_000011 0.02011f
C770 111 c0 0.01342f
C771 a_32152_32714# f5_n 0.02309f
C772 VCO4_selection_0.inverter_5.in a_31592_47400# 0.10845f
C773 a_32087_30284# a_32303_30284# 0.02909f
C774 m2_33006_39891# f1 0.01358f
C775 VCO3_selection_0.NAND_3in_8.y VCO3_selection_0.inverter_8.out 0.52744f
C776 after_000111 f2 0.02665f
C777 VCO2_selection_0.NAND_3in_5.c VCO2_5_sel 0.24756f
C778 after_000111 c1 0.0215f
C779 c2 f2 0.01381f
C780 001 f5 1.46551f
C781 c1 c2 13.0948f
C782 f0 a_31315_29201# 0.15347f
C783 3bit_to_8_outs_0.c0_n a_31410_24854# 0.01179f
C784 f0 a_32110_38594# 0.04506f
C785 010 VCO5_selection_0.inverter_1.in 0.49526f
C786 a_32468_40540# VCO3_selection_0.NAND_3in_4.y 0.01154f
C787 111 f0 0.1902f
C788 VCO2_selection_0.inverter_1.out m2_33034_34021# 0.10901f
C789 VCO5_selection_0.inverter_2.out m2_32217_28872# 0.09739f
C790 VCO4_selection_0.inverter_3.out vp 0.3007f
C791 a_30990_22377# f4 0.01429f
C792 VCO4_selection_0.NOR_2in_1.a VCO4_selection_0.inverter_2.out 0.02259f
C793 VCO3_selection_0.NAND_3in_6.c m2_33006_39891# 0.01968f
C794 f5_n f1_n 0.0447f
C795 f0 VCO5_selection_0.XNOR_0._a 1.66232f
C796 row_section_decoding_0.NAND_2in_0.b f1 1.37336f
C797 f1_n 011 0.02549f
C798 after_001111_n f2 0.0159f
C799 after_001111_n c1 0.0226f
C800 VCO2_selection_0.NOR_2in_0.y VCO2_selection_0.inverter_6.out 0.02755f
C801 VCO4_selection_0.inverter_3.in m2_32353_45771# 0.16871f
C802 110 after_000011 1.12722f
C803 011 VCO4_selection_0.XNOR_1._a 0.02476f
C804 a_30774_23859# row_section_decoding_0.NAND_2in_0.a 0.0797f
C805 after_000011_n VCO4_selection_0.inverter_0.out 0.02429f
C806 f3 a_30774_23859# 0.01463f
C807 VCO4_selection_0.inverter_5.out m2_32494_47563# 0.1803f
C808 100 after_000011 2.05724f
C809 VCO4_selection_0.inverter_0.out VCO4_selection_0.NAND_2in_0.a 1.21451f
C810 VCO2_selection_0.NAND_4in_0.a VCO2_selection_0.NAND_4in_0.b 1.61193f
C811 after_000111 110 0.96631f
C812 VCO_selection_0.NAND_2in_0.y a_31260_49868# 0.01004f
C813 VCO3_selection_0.inverter_11.out m2_33405_42661# 0.01574f
C814 c2 110 0.02342f
C815 VCO3_selection_0.XNOR_1._b a_32110_40066# 0.04746f
C816 100 after_000111 1.15432f
C817 010 3bit_to_8_outs_0.NAND_3in_2.y 0.02871f
C818 010 VCO3_selection_0.NAND_3in_1.y 0.38626f
C819 f3 after_001111 0.01111f
C820 a_31572_40540# a_31788_40540# 0.02909f
C821 001 after_000111_n 0.3204f
C822 a_31407_32240# after_000011 0.01587f
C823 after_000111 VCO2_selection_0.inverter_1.in 0.6409f
C824 3bit_to_8_outs_0.inverter_10.in 3bit_to_8_outs_0.NAND_3in_6.y 0.48578f
C825 m2_33034_34103# m2_33034_34021# 0.40984f
C826 c0 a_31410_25172# 0.01179f
C827 3bit_to_8_outs_0.NAND_3in_0.y 3bit_to_8_outs_0.inverter_1.in 0.48578f
C828 VCO3_selection_0.inverter_5.out f1 0.0136f
C829 000 VCO4_selection_0.inverter_2.in 0.68372f
C830 VCO3_selection_0.NAND_3in_0.c VCO3_selection_0.NOR_2in_0.y 0.0346f
C831 000 VCO4_selection_0.NAND_3in_1.y 0.66785f
C832 a_32018_43486# VCO4_selection_0.NOR_2in_0.a 0.04825f
C833 VCO3_selection_0.NAND_2in_0.y 001 0.3369f
C834 VCO4_selection_0.NAND_3in_0.y m2_30981_43897# 0.09699f
C835 VCO3_selection_0.NAND_2in_3.y m2_32451_41929# 0.01039f
C836 VCO5_selection_0.NAND_2in_0.b VCO5_selection_0.inverter_0.out 0.46886f
C837 vp VCO4_selection_0.inverter_2.in 0.6272f
C838 vp VCO2_selection_0.inverter_0.out 0.34169f
C839 after_001111_n 110 1.61994f
C840 after_000011_n row_section_decoding_0.NAND_2in_0.b 0.24331f
C841 VCO4_selection_0.NAND_3in_1.y vp 0.6331f
C842 VCO2_selection_0.NAND_4in_0.c VCO2_selection_0.NAND_4in_0.a 0.04151f
C843 VCO3_selection_0.XNOR_0._a VCO3_selection_0.NAND_3in_7.c 0.98224f
C844 100 after_001111_n 0.0898f
C845 vp VCO2_11_sel 0.40714f
C846 VCO4_selection_0.NOR_2in_0.b a_32018_43486# 0.01419f
C847 VCO3_selection_0.XNOR_1._b VCO3_selection_0.XNOR_0._b 0.04548f
C848 000 f1 0.11697f
C849 VCO4_selection_0.inverter_5.in vp 0.61091f
C850 VCO2_selection_0.NAND_4in_0.d f0 0.01849f
C851 000 VCO3_selection_0.NAND_3in_2.y 0.42896f
C852 a_31276_44464# VCO4_selection_0.inverter_2.in 0.07156f
C853 VCO4_selection_0.NOR_2in_0.a VCO4_selection_0.XNOR_0.y 0.23968f
C854 after_000011_n a_31060_46420# 0.01632f
C855 VCO3_selection_0.NAND_2in_0.y VCO3_selection_0.NAND_2in_3.y 0.69785f
C856 c0 3bit_to_8_outs_0.c2_n 1.20642f
C857 vp f1 4.3402f
C858 VCO2_selection_0.NOR_2in_2.a VCO3_selection_0.inverter_1.out 0.01183f
C859 VCO2_selection_0.inverter_6.out after_000011 0.06988f
C860 VCO4_selection_0.NOR_2in_1.a a_32494_44968# 0.04832f
C861 vp VCO3_selection_0.NAND_3in_2.y 0.57478f
C862 VCO2_selection_0.NOR_2in_2.b VCO2_selection_0.NOR_2in_2.a 1.3042f
C863 m2_31673_44547# VCO4_selection_0.inverter_0.out 0.01807f
C864 f0 VCO3_selection_0.XNOR_0._a 1.82517f
C865 VCO3_selection_0.NAND_3in_4.y VCO3_selection_0.inverter_7.out 0.56286f
C866 a_31407_34670# f5 0.01085f
C867 VCO3_selection_0.inverter_4.in m2_32661_36721# 0.01039f
C868 VCO3_selection_0.inverter_5.out m2_33006_38677# 0.44901f
C869 010 a_31519_28315# 0.01184f
C870 VCO3_selection_0.NOR_2in_4.b m2_32451_41683# 0.22322f
C871 c2 a_31626_25172# 0.01632f
C872 row_section_decoding_0.NAND_2in_0.b a_31250_23355# 0.04134f
C873 c0 VCO5_selection_0.inverter_0.out 0.05727f
C874 f5 after_000111_n 4.05306f
C875 VCO3_selection_0.NAND_3in_6.c vp 0.20646f
C876 VCO2_selection_0.NOR_2in_2.a VCO2_selection_0.NOR_2in_1.y 0.02485f
C877 010 VCO4_selection_0.NAND_3in_0.y 0.62658f
C878 f2 a_30774_23859# 0.04801f
C879 a_32494_44968# VCO4_selection_0.inverter_1.in 0.08009f
C880 VCO5_selection_0.inverter_2.in VCO5_selection_0.inverter_2.out 0.49117f
C881 VCO3_selection_0.XNOR_1._a f1 0.9369f
C882 VCO3_selection_0.inverter_4.out m2_32661_36967# 0.22322f
C883 VCO3_selection_0.NAND_2in_0.y f5 0.30121f
C884 a_32556_28789# a_32772_28789# 0.02909f
C885 VCO4_selection_0.NOR_2in_0.b m2_31673_43651# 0.01796f
C886 VCO4_selection_0.inverter_4.in f1 0.01695f
C887 VCO2_selection_0.NOR_2in_2.a m2_32558_34753# 0.09799f
C888 m2_32661_36721# after_001111 0.0169f
C889 VCO3_selection_0.inverter_1.out VCO3_selection_0.inverter_3.out 0.04586f
C890 f2 after_001111 0.01816f
C891 a_32368_32714# VCO2_selection_0.NAND_4in_0.b 0.06905f
C892 000 after_000011_n 1.73365f
C893 010 f4 0.01539f
C894 c1 after_001111 0.02105f
C895 101 after_000011 1.13573f
C896 after_000011_n m2_32286_34753# 0.0169f
C897 VCO2_selection_0.inverter_1.in VCO2_selection_0.inverter_1.out 0.61207f
C898 after_000011_n vp 5.94711f
C899 after_000011_n a_32252_38120# 0.01013f
C900 VCO5_selection_0.inverter_1.out a_32537_27811# 0.01383f
C901 VCO3_selection_0.NAND_3in_3.y VCO3_selection_0.inverter_0.out 0.19982f
C902 101 after_000111 1.98014f
C903 VCO3_selection_0.inverter_2.out m2_33199_36071# 0.42232f
C904 vp VCO4_selection_0.NAND_2in_0.a 0.3467f
C905 vp VCO2_selection_0.NAND_4in_0.b 0.56102f
C906 VCO_selection_0.NAND_2in_1.y f0 0.03065f
C907 101 c2 0.02342f
C908 VCO3_selection_0.inverter_2.out a_33278_35660# 0.01419f
C909 VCO4_selection_0.inverter_3.in VCO4_selection_0.XNOR_0.y 0.12994f
C910 c1 3bit_to_8_outs_0.inverter_10.in 0.72472f
C911 VCO4_selection_0.NAND_3in_2.y a_31956_46420# 0.07156f
C912 vp VCO2_selection_0.NAND_3in_3.y 0.59878f
C913 111 f3 0.02414f
C914 VCO_selection_0.NAND_2in_2.y VCO_selection_0.NAND_2in_0.y 0.50978f
C915 m2_32217_28954# f1 0.01358f
C916 100 m2_31493_40623# 0.01011f
C917 VCO3_selection_0.NAND_3in_5.y m2_33137_42661# 0.1796f
C918 VCO_sel VCO4_selection_0.XNOR_0._a 0.03365f
C919 VCO3_selection_0.NAND_2in_0.y m2_32451_41929# 0.16872f
C920 VCO3_selection_0.XNOR_1._a after_000011_n 0.02536f
C921 VCO3_selection_0.inverter_5.out m2_33137_37781# 0.17972f
C922 VCO2_selection_0.NOR_2in_1.y VCO3_selection_0.inverter_1.out 0.01348f
C923 a_32058_48376# VCO4_selection_0.XNOR_0._a 0.07427f
C924 101 after_001111_n 0.6559f
C925 after_000011_n a_31883_34670# 0.04481f
C926 after_000011_n VCO4_selection_0.inverter_4.in 1.5818f
C927 VCO2_selection_0.NAND_3in_5.c m2_33294_34753# 0.70073f
C928 VCO4_selection_0.inverter_3.in a_31956_45946# 0.01202f
C929 100 VCO3_selection_0.NAND_2in_1.y 0.3743f
C930 VCO_selection_0.NAND_2in_2.y m2_31181_49775# 0.69509f
C931 110 after_001111 1.71688f
C932 VCO2_selection_0.NAND_4in_0.c vp 0.33269f
C933 f5_n after_000011 0.39212f
C934 a_31788_38120# VCO3_selection_0.NAND_3in_3.y 0.07204f
C935 011 after_000011 1.69978f
C936 a_31407_32714# a_31623_32714# 0.02909f
C937 100 after_001111 0.23617f
C938 VCO4_selection_0.XNOR_0.y a_32058_48376# 0.07532f
C939 VCO3_selection_0.inverter_5.out VCO3_selection_0.NAND_3in_0.c 1.19802f
C940 VCO3_selection_0.NAND_3in_0.c m2_33137_37945# 0.01982f
C941 m2_31673_43897# m2_31673_43815# 0.16814f
C942 after_000111 f5_n 2.92188f
C943 VCO2_selection_0.inverter_1.in after_001111 0.76346f
C944 100 3bit_to_8_outs_0.inverter_6.in 0.41584f
C945 f1 VCO2_selection_0.XNOR_0._b 2.14738f
C946 f5_n c2 0.02638f
C947 after_000111 011 2.83757f
C948 VCO5_selection_0.inverter_0.out m2_32192_28222# 0.09744f
C949 VCO2_selection_0.inverter_2.in m2_31328_34835# 0.28323f
C950 111 VCO2_selection_0.XNOR_0._a 0.02395f
C951 after_000011_n m2_32217_28954# 0.01969f
C952 VCO3_selection_0.NAND_3in_6.c VCO3_selection_0.NAND_3in_6.a 0.24911f
C953 VCO4_selection_0.inverter_4.in a_31740_46420# 0.01405f
C954 a_31775_29201# VCO5_selection_0.XNOR_0._a 0.10751f
C955 VCO3_selection_0.inverter_10.out VCO3_selection_0.inverter_11.out 1.16328f
C956 VCO3_selection_0.inverter_12.out VCO3_selection_0.inverter_8.out 0.49691f
C957 after_001111_n f5_n 42.5437f
C958 VCO3_11_sel a_33476_38120# 0.01021f
C959 vp VCO3_selection_0.NAND_3in_0.c 0.28438f
C960 after_001111_n 011 0.09991f
C961 VCO5_selection_0.inverter_2.in m2_32217_29118# 0.22722f
C962 a_31626_24854# 3bit_to_8_outs_0.NAND_3in_0.y 0.01402f
C963 VCO3_selection_0.NAND_3in_7.c f1 1.07668f
C964 c0 f1 0.01348f
C965 vp VCO5_selection_0.XNOR_0._b 0.49007f
C966 m2_31033_24515# 110 0.17997f
C967 111 f2 0.09309f
C968 after_000011_n VCO5_selection_0.NAND_2in_0.b 1.05183f
C969 vp VCO3_selection_0.NAND_3in_7.y 0.64499f
C970 a_33068_41518# vp 0.12263f
C971 a_32252_38120# VCO3_selection_0.NAND_3in_7.y 0.01038f
C972 VCO3_selection_0.inverter_11.out VCO4_selection_0.inverter_1.in 0.01398f
C973 VCO2_selection_0.NAND_3in_5.c VCO2_selection_0.NAND_3in_7.y 0.0119f
C974 3bit_to_8_outs_0.c2_n 3bit_to_8_outs_0.NAND_3in_6.y 0.53837f
C975 VCO4_selection_0.inverter_5.in f0 0.38556f
C976 3bit_to_8_outs_0.NAND_3in_2.y 3bit_to_8_outs_0.c1_n 0.6154f
C977 a_31626_25172# 3bit_to_8_outs_0.inverter_6.in 0.01402f
C978 a_33278_37142# VCO3_selection_0.NOR_2in_0.y 0.08227f
C979 VCO2_selection_0.NAND_3in_5.c VCO2_selection_0.NAND_3in_4.y 0.03102f
C980 VCO3_selection_0.NAND_2in_3.y VCO3_selection_0.NAND_3in_5.y 0.01232f
C981 f0 f1 8.34163f
C982 VCO2_selection_0.NAND_3in_3.y VCO2_selection_0.XNOR_0._b 0.01226f
C983 a_32920_31262# VCO2_selection_0.inverter_4.out 0.01383f
C984 VCO2_selection_0.inverter_2.in VCO2_selection_0.inverter_1.in 0.01325f
C985 VCO2_selection_0.NOR_2in_0.b VCO2_selection_0.NAND_3in_7.y 0.41511f
C986 c0 a_32090_24854# 0.01179f
C987 VCO_selection_0.NAND_2in_2.y vp 0.49303f
C988 010 f1_n 1.44126f
C989 VCO2_selection_0.NOR_2in_0.a VCO2_selection_0.inverter_6.out 0.01223f
C990 f5 row_section_decoding_0.NAND_2in_0.b 0.43471f
C991 000 001 37.2959f
C992 after_000011_n VCO3_selection_0.NAND_3in_7.c 0.43627f
C993 after_000011_n c0 0.04893f
C994 VCO2_selection_0.NAND_4in_0.c VCO2_selection_0.XNOR_0._b 0.01404f
C995 111 110 44.0679f
C996 m2_32217_28872# m2_32477_28872# 0.01883f
C997 101 after_001111 0.06683f
C998 001 vp 2.14582f
C999 100 111 7.37848f
C1000 c0 a_32090_26498# 0.01183f
C1001 VCO3_selection_0.NAND_3in_5.y a_31572_42496# 0.02306f
C1002 after_001111_n m2_31673_44629# 0.01756f
C1003 VCO3_selection_0.NAND_3in_6.b m2_33006_39727# 0.01883f
C1004 101 3bit_to_8_outs_0.inverter_6.in 0.68056f
C1005 vp VCO4_11_sel 0.26809f
C1006 VCO3_selection_0.inverter_4.in 011 0.01324f
C1007 after_000011_n f0 0.15458f
C1008 a_32252_40540# after_000011_n 0.01142f
C1009 VCO2_5_sel VCO2_selection_0.inverter_1.out 0.03633f
C1010 100 a_31623_34196# 0.01179f
C1011 after_000111 VCO3_selection_0.NAND_3in_9.y 0.6266f
C1012 3bit_to_8_outs_0.inverter_1.in 3bit_to_8_outs_0.NAND_3in_3.y 0.08826f
C1013 VCO3_selection_0.NAND_2in_3.y vp 0.39172f
C1014 a_32258_36638# VCO3_selection_0.inverter_4.in 0.07562f
C1015 c2 a_32306_24854# 0.01632f
C1016 vp VCO3_selection_0.XNOR_0._b 0.32905f
C1017 VCO3_selection_0.NAND_3in_6.a VCO3_selection_0.NAND_3in_0.c 0.02007f
C1018 a_31623_34196# VCO2_selection_0.inverter_1.in 0.07156f
C1019 VCO4_selection_0.inverter_4.in 001 0.45995f
C1020 m2_33176_32065# after_000111_n 0.01756f
C1021 m2_30761_26159# m2_31033_26159# 0.01717f
C1022 VCO3_selection_0.inverter_12.out VCO3_selection_0.inverter_0.out 0.02325f
C1023 f5_n after_001111 3.6172f
C1024 row_section_decoding_0.NAND_2in_0.b after_000111_n 0.48206f
C1025 VCO5_selection_0.NAND_2in_0.b VCO5_selection_0.XNOR_0._b 0.01587f
C1026 011 after_001111 0.69603f
C1027 a_32920_31262# VCO2_selection_0.inverter_6.out 0.05035f
C1028 3bit_to_8_outs_0.inverter_8.in a_32306_26816# 0.02306f
C1029 m2_31673_44629# m2_31939_44629# 0.01796f
C1030 000 f5 0.05642f
C1031 VCO4_selection_0.inverter_3.out VCO4_selection_0.NOR_2in_1.a 2.17131f
C1032 a_32258_36638# after_001111 0.04403f
C1033 after_000011_n a_31788_36164# 0.01123f
C1034 VCO2_selection_0.NAND_2in_0.y VCO2_selection_0.NAND_4in_0.a 0.04758f
C1035 c1 3bit_to_8_outs_0.c2_n 0.69357f
C1036 vp f5 0.97179f
C1037 m2_32700_29945# m2_32972_29945# 0.01717f
C1038 m2_31673_44629# VCO4_selection_0.inverter_2.out 0.18102f
C1039 3bit_to_8_outs_0.inverter_10.in 011 0.41591f
C1040 vp VCO5_selection_0.inverter_1.out 0.33418f
C1041 VCO4_selection_0.NAND_3in_2.y VCO4_selection_0.XNOR_0.y 0.17518f
C1042 VCO3_selection_0.NAND_2in_0.y VCO3_selection_0.NAND_3in_5.y 0.01949f
C1043 VCO3_selection_0.inverter_8.out m2_33407_40705# 0.0378f
C1044 3bit_to_8_outs_0.NAND_3in_2.y a_31626_26816# 0.0131f
C1045 VCO3_selection_0.NAND_3in_0.c VCO3_selection_0.NAND_3in_7.c 0.04232f
C1046 a_32570_38594# VCO3_selection_0.XNOR_0._a 0.07427f
C1047 VCO4_selection_0.inverter_3.out VCO4_selection_0.inverter_1.in 0.82047f
C1048 VCO4_selection_0.inverter_3.in after_000011 0.8679f
C1049 VCO3_selection_0.NOR_2in_4.b 110 0.01794f
C1050 VCO5_selection_0.inverter_1.in VCO5_selection_0.inverter_0.in 0.17025f
C1051 VCO4_selection_0.inverter_5.in VCO4_selection_0.inverter_5.out 0.48502f
C1052 VCO2_selection_0.NAND_3in_7.y a_32303_30284# 0.01227f
C1053 VCO3_selection_0.inverter_7.out a_33486_41044# 0.05001f
C1054 m2_33405_42661# m2_33137_42661# 0.01769f
C1055 VCO3_selection_0.NAND_3in_7.y VCO3_selection_0.NAND_3in_7.c 0.7555f
C1056 VCO3_selection_0.inverter_12.out VCO3_5_sel 0.10668f
C1057 3bit_to_8_outs_0.c0_n 3bit_to_8_outs_0.inverter_1.in 0.63468f
C1058 f0 a_31598_48376# 0.04506f
C1059 101 111 0.25188f
C1060 a_31407_32714# f5_n 0.01007f
C1061 VCO2_selection_0.inverter_0.out m2_33034_34021# 0.0378f
C1062 a_31788_38120# 011 0.01179f
C1063 000 after_000111_n 0.10976f
C1064 f0 VCO5_selection_0.XNOR_0._b 0.47974f
C1065 row_section_decoding_0.NAND_2in_0.a f1 0.39668f
C1066 vp after_000111_n 1.33498f
C1067 VCO3_selection_0.XNOR_1._b vp 0.32903f
C1068 f3 f1 0.95178f
C1069 3bit_to_8_outs_0.c1_n 3bit_to_8_outs_0.NAND_3in_3.y 0.61541f
C1070 VCO3_selection_0.NAND_3in_1.y m2_32661_36071# 0.17808f
C1071 VCO2_selection_0.inverter_1.out m2_32768_34103# 0.09799f
C1072 011 VCO4_selection_0.XNOR_1._b 0.02425f
C1073 VCO3_selection_0.NAND_2in_0.y vp 0.35566f
C1074 3bit_to_8_outs_0.inverter_10.in m2_30761_26159# 0.17968f
C1075 vp a_33278_37142# 0.12469f
C1076 VCO3_selection_0.NAND_3in_6.c m2_33407_40623# 0.16521f
C1077 VCO3_selection_0.NAND_3in_4.y after_000011 0.57992f
C1078 VCO2_selection_0.NAND_4in_0.d VCO2_selection_0.inverter_6.out 0.27497f
C1079 a_31410_25172# a_31626_25172# 0.02909f
C1080 001 c0 0.01443f
C1081 VCO3_selection_0.XNOR_1._b VCO3_selection_0.XNOR_1._a 0.56598f
C1082 VCO4_selection_0.inverter_5.out after_000011_n 0.21052f
C1083 vp a_32537_27811# 0.12274f
C1084 010 after_000011 10.8772f
C1085 111 f5_n 35.6463f
C1086 111 011 0.07151f
C1087 VCO4_selection_0.inverter_5.out m2_32494_47809# 0.09739f
C1088 VCO3_selection_0.inverter_5.out VCO3_selection_0.NOR_2in_0.y 0.08869f
C1089 010 after_000111 0.98628f
C1090 m2_31181_49775# VCO_selection_0.NAND_2in_0.y 0.01316f
C1091 a_32110_40066# f0 0.04506f
C1092 VCO5_selection_0.NAND_2in_0.b VCO5_selection_0.inverter_1.out 0.64011f
C1093 vp VCO2_selection_0.NAND_2in_0.y 0.3922f
C1094 VCO5_selection_0.inverter_0.in m2_32458_28222# 0.08446f
C1095 001 f0 0.59781f
C1096 after_000011_n f3 0.01106f
C1097 f1 VCO2_selection_0.XNOR_0._a 0.60852f
C1098 VCO3_selection_0.XNOR_0._b VCO3_selection_0.NAND_3in_7.c 0.57721f
C1099 m2_32768_34103# m2_33034_34103# 0.01796f
C1100 VCO4_selection_0.NAND_2in_0.b a_32018_43486# 0.08009f
C1101 VCO3_selection_0.NOR_2in_0.y m2_33199_36721# 0.16564f
C1102 VCO2_selection_0.NAND_3in_7.y after_000011 0.6473f
C1103 VCO2_selection_0.NAND_4in_0.d 101 0.50011f
C1104 a_31740_45946# VCO4_selection_0.NAND_3in_1.y 0.0131f
C1105 m2_30711_49775# m2_30711_49693# 0.40984f
C1106 after_000011_n m2_32353_46585# 0.01756f
C1107 a_30790_49868# after_001111 0.01155f
C1108 010 after_001111_n 0.10517f
C1109 VCO2_selection_0.NAND_3in_4.y after_000011 0.61789f
C1110 VCO2_selection_0.NOR_2in_2.a VCO3_selection_0.inverter_2.out 0.01531f
C1111 after_000111 m2_30981_44547# 0.01284f
C1112 VCO4_selection_0.NOR_2in_1.a VCO4_selection_0.NAND_2in_0.a 0.03318f
C1113 vp VCO3_selection_0.NOR_2in_0.y 0.51648f
C1114 VCO3_selection_0.NAND_3in_3.y f1 0.01353f
C1115 3bit_to_8_outs_0.c1_n 3bit_to_8_outs_0.c0_n 6.92534f
C1116 VCO3_selection_0.NAND_3in_3.y VCO3_selection_0.NAND_3in_2.y 0.0464f
C1117 f0 VCO3_selection_0.XNOR_0._b 0.63674f
C1118 VCO3_selection_0.NAND_3in_4.y VCO3_selection_0.inverter_8.out 0.35612f
C1119 m2_31673_43815# f1 0.01756f
C1120 VCO3_selection_0.NAND_3in_2.y m2_32661_36721# 0.16872f
C1121 VCO3_selection_0.NAND_3in_8.y after_000011_n 0.75709f
C1122 f2 f1 35.7175f
C1123 a_32252_42496# a_32468_42496# 0.02909f
C1124 VCO3_selection_0.NAND_2in_3.y m2_32451_41683# 0.2263f
C1125 c0 f5 0.03612f
C1126 a_32494_43990# VCO4_selection_0.NAND_2in_0.a 0.01155f
C1127 row_section_decoding_0.NAND_2in_0.a a_31250_23355# 0.01379f
C1128 c0 VCO5_selection_0.inverter_1.out 0.02994f
C1129 VCO3_selection_0.inverter_4.out VCO3_selection_0.inverter_3.out 1.30418f
C1130 3bit_to_8_outs_0.inverter_10.in a_32306_26498# 0.02306f
C1131 a_32903_35174# VCO2_selection_0.NOR_2in_2.y 0.08009f
C1132 VCO2_5_sel a_33260_32714# 0.08178f
C1133 VCO4_selection_0.NAND_2in_0.a VCO4_selection_0.inverter_1.in 7.63295f
C1134 after_001111_n m2_30981_44547# 0.67477f
C1135 VCO3_selection_0.inverter_4.in m2_32661_36967# 0.2263f
C1136 010 m2_31033_26159# 0.17997f
C1137 VCO2_selection_0.NOR_2in_1.y a_33113_33692# 0.08009f
C1138 f0 f5 0.25778f
C1139 m2_31673_43897# VCO4_selection_0.NOR_2in_0.a 0.01982f
C1140 a_31060_43990# VCO4_selection_0.NAND_3in_0.y 0.0131f
C1141 VCO2_11_sel VCO3_selection_0.NOR_2in_1.y 0.04039f
C1142 a_32093_34196# VCO2_selection_0.NAND_2in_0.y 0.07562f
C1143 VCO2_selection_0.inverter_1.in VCO2_selection_0.inverter_0.out 0.5286f
C1144 after_000011_n m2_31653_23684# 0.22668f
C1145 VCO3_selection_0.NOR_2in_4.a m2_32723_41929# 0.09799f
C1146 after_000011_n VCO3_selection_0.NAND_3in_3.y 0.56697f
C1147 vp VCO4_selection_0.inverter_0.out 0.36525f
C1148 vp VCO2_selection_0.NAND_4in_0.a 0.97118f
C1149 VCO2_selection_0.NOR_2in_2.a m2_32824_34835# 0.10901f
C1150 vp VCO_selection_0.NAND_2in_0.y 0.46769f
C1151 001 m2_30981_45853# 0.01914f
C1152 VCO3_selection_0.inverter_2.out VCO3_selection_0.inverter_1.out 1.4159f
C1153 f1 110 0.13435f
C1154 after_000011_n f2 35.6118f
C1155 after_000011_n c1 0.02495f
C1156 3bit_to_8_outs_0.inverter_1.in after_000011 0.04672f
C1157 after_000011_n m2_31328_34835# 0.41122f
C1158 100 f1 0.13347f
C1159 f5_n a_32252_42496# 0.02335f
C1160 VCO2_selection_0.NAND_4in_0.d VCO2_5_sel 0.17479f
C1161 VCO3_selection_0.NAND_3in_4.y m2_31493_40623# 0.11582f
C1162 c0 after_000111_n 0.06507f
C1163 VCO3_selection_0.NAND_3in_7.c after_000111_n 0.02078f
C1164 a_31592_47400# vp 0.17102f
C1165 a_31276_46420# VCO4_selection_0.XNOR_0.y 0.02488f
C1166 VCO3_selection_0.inverter_2.out m2_32661_36071# 0.09739f
C1167 c2 3bit_to_8_outs_0.inverter_1.in 0.53837f
C1168 VCO2_selection_0.NOR_2in_2.b VCO2_selection_0.NAND_3in_5.c 0.13442f
C1169 VCO2_selection_0.NOR_2in_2.y m2_33294_34753# 0.01308f
C1170 VCO3_selection_0.NAND_3in_4.y a_31572_40540# 0.01332f
C1171 VCO3_selection_0.inverter_3.out m2_32933_36721# 0.09799f
C1172 vp row_section_decoding_0.NAND_2in_0.b 0.30309f
C1173 f0 after_000111_n 0.1404f
C1174 VCO3_selection_0.XNOR_1._b f0 0.63921f
C1175 VCO5_selection_0.NAND_2in_0.b m2_32934_28222# 0.42213f
C1176 a_32052_47400# VCO4_selection_0.XNOR_1._a 0.10751f
C1177 VCO3_selection_0.inverter_5.out m2_33137_37945# 0.1797f
C1178 VCO2_selection_0.NAND_3in_5.c VCO2_selection_0.NOR_2in_1.y 0.3153f
C1179 a_32052_48788# VCO4_selection_0.XNOR_0._a 0.10751f
C1180 VCO4_selection_0.XNOR_0.y a_31592_48788# 0.10845f
C1181 m2_30761_24515# m2_31033_24515# 0.01717f
C1182 VCO2_selection_0.NAND_3in_5.c VCO2_selection_0.NAND_3in_3.c 0.11228f
C1183 m2_32841_30923# VCO2_selection_0.inverter_4.out 0.07485f
C1184 VCO3_selection_0.NAND_3in_5.y vp 0.57874f
C1185 VCO5_selection_0.inverter_2.in a_31781_28789# 0.07528f
C1186 010 after_001111 0.07588f
C1187 VCO5_selection_0.inverter_2.out VCO5_selection_0.inverter_0.in 0.6668f
C1188 a_31315_29201# VCO5_selection_0.inverter_2.in 0.10845f
C1189 after_000011_n 110 9.27044f
C1190 a_31572_38120# a_31788_38120# 0.02909f
C1191 VCO3_11_sel VCO3_selection_0.NAND_3in_0.c 0.74424f
C1192 100 after_000011_n 0.79766f
C1193 VCO4_selection_0.XNOR_0.y a_32052_48788# 0.11436f
C1194 VCO3_selection_0.NAND_3in_3.y m2_33137_37781# 0.17968f
C1195 VCO2_selection_0.inverter_1.in m2_32496_34103# 0.16872f
C1196 VCO2_selection_0.NOR_2in_2.b m2_32824_34835# 0.0378f
C1197 m2_30981_43897# m2_31673_43897# 0.01756f
C1198 after_000011_n VCO2_selection_0.inverter_1.in 0.02068f
C1199 VCO2_selection_0.NAND_3in_3.y 110 0.55495f
C1200 VCO5_selection_0.inverter_2.in VCO5_selection_0.XNOR_0._a 1.096f
C1201 VCO5_selection_0.inverter_0.in VCO2_selection_0.NOR_2in_0.b 0.0217f
C1202 VCO3_selection_0.NAND_3in_6.c a_33345_40066# 0.019f
C1203 010 3bit_to_8_outs_0.inverter_10.in 0.68431f
C1204 001 f3 0.01174f
C1205 vp VCO3_selection_0.inverter_5.out 0.3388f
C1206 VCO3_selection_0.NAND_3in_3.y VCO3_selection_0.NAND_3in_0.c 0.14577f
C1207 VCO2_selection_0.NOR_2in_0.b a_33317_29780# 0.01735f
C1208 VCO2_selection_0.NOR_2in_2.b VCO2_selection_0.inverter_3.in 0.47624f
C1209 VCO4_selection_0.inverter_4.in a_31060_46420# 0.01159f
C1210 vp a_31939_31170# 0.17102f
C1211 VCO3_selection_0.NAND_3in_3.y VCO3_selection_0.NAND_3in_7.y 0.45323f
C1212 VCO2_selection_0.NAND_4in_0.c 100 0.33341f
C1213 VCO4_11_sel VCO4_selection_0.NOR_2in_1.a 0.02555f
C1214 111 m2_30761_24515# 0.1802f
C1215 000 vp 2.50118f
C1216 VCO2_selection_0.NAND_3in_5.c a_33373_34670# 0.01839f
C1217 VCO3_selection_0.XNOR_1.y VCO3_selection_0.inverter_0.out 0.01652f
C1218 3bit_to_8_outs_0.inverter_8.in 3bit_to_8_outs_0.c1_n 0.72478f
C1219 VCO5_11_sel 3bit_to_8_outs_0.c1_n 0.01599f
C1220 101 f1 0.09508f
C1221 VCO2_selection_0.NAND_4in_0.c a_31407_32240# 0.07579f
C1222 VCO2_selection_0.NOR_2in_0.a m2_32700_30109# 0.22367f
C1223 m2_30981_45853# after_000111_n 0.67657f
C1224 VCO5_selection_0.inverter_1.in a_31519_28315# 0.0118f
C1225 VCO2_selection_0.NOR_2in_0.a VCO2_selection_0.NAND_3in_7.y 0.63069f
C1226 VCO2_selection_0.NAND_3in_3.y a_32087_30284# 0.01159f
C1227 a_31276_44464# 000 0.01179f
C1228 c2 3bit_to_8_outs_0.c1_n 1.19498f
C1229 VCO3_selection_0.NOR_2in_1.y m2_33137_37781# 0.01883f
C1230 3bit_to_8_outs_0.inverter_8.in m2_30761_27145# 0.17968f
C1231 001 a_31775_29201# 0.01373f
C1232 010 VCO2_selection_0.inverter_2.in 0.33708f
C1233 VCO3_selection_0.inverter_7.out VCO3_selection_0.NAND_3in_6.b 0.43023f
C1234 VCO3_selection_0.NAND_3in_8.y VCO3_selection_0.NAND_2in_3.y 0.01915f
C1235 m2_32841_30923# VCO2_selection_0.inverter_6.out 0.0142f
C1236 VCO3_selection_0.NAND_3in_9.y a_32252_42496# 0.01267f
C1237 f5 f3 0.22393f
C1238 VCO3_selection_0.XNOR_1._a vp 0.35732f
C1239 f5 a_31986_22377# 0.01383f
C1240 VCO3_selection_0.NOR_2in_1.y VCO3_selection_0.NAND_3in_0.c 0.25675f
C1241 VCO4_selection_0.inverter_4.in vp 0.57364f
C1242 a_31945_30758# VCO2_selection_0.NAND_3in_3.c 0.07125f
C1243 VCO3_selection_0.inverter_12.out VCO3_selection_0.NAND_3in_6.c 0.02702f
C1244 001 f2 0.015f
C1245 f5_n f1 0.13282f
C1246 f5_n VCO3_selection_0.NAND_3in_2.y 0.65236f
C1247 010 111 0.97055f
C1248 a_32564_39006# VCO3_selection_0.XNOR_0._a 0.10751f
C1249 f1 011 0.17896f
C1250 111 a_30790_50186# 0.01037f
C1251 after_000011_n 101 0.72921f
C1252 3bit_to_8_outs_0.c2_n a_32306_26498# 0.01637f
C1253 101 VCO2_selection_0.NAND_4in_0.b 0.69232f
C1254 f0 VCO_selection_0.NAND_2in_0.y 0.0295f
C1255 VCO3_selection_0.NAND_3in_6.b m2_33006_39973# 0.01894f
C1256 3bit_to_8_outs_0.c2_n a_32306_26816# 0.01637f
C1257 after_000011_n a_32556_28789# 0.02125f
C1258 VCO3_selection_0.NAND_3in_3.y VCO3_selection_0.XNOR_0._b 0.03327f
C1259 c0 a_31410_26816# 0.01179f
C1260 c0 row_section_decoding_0.NAND_2in_0.b 0.02743f
C1261 a_31592_47400# f0 0.15347f
C1262 VCO3_selection_0.inverter_12.out after_000011_n 0.28829f
C1263 row_section_decoding_0.NAND_2in_0.a after_000111_n 0.04373f
C1264 f3 after_000111_n 0.36845f
C1265 after_000011_n m2_31493_41847# 0.4108f
C1266 vp a_32104_39564# 0.17102f
C1267 c2 a_31626_24854# 0.01632f
C1268 VCO_selection_0.NAND_2in_1.y a_31476_49868# 0.02008f
C1269 a_31407_34196# a_31623_34196# 0.02909f
C1270 VCO4_selection_0.inverter_3.out VCO4_selection_0.NOR_2in_0.a 0.04432f
C1271 a_31623_30284# 110 0.01179f
C1272 VCO2_selection_0.NAND_3in_5.c m2_32841_30841# 0.16564f
C1273 VCO2_selection_0.NAND_4in_0.c 101 0.16636f
C1274 001 110 0.08102f
C1275 VCO2_selection_0.NOR_2in_0.y VCO2_selection_0.NAND_3in_3.c 0.02395f
C1276 m2_31673_44629# VCO4_selection_0.inverter_2.in 0.0115f
C1277 after_000011_n f5_n 7.73865f
C1278 vp VCO3_selection_0.NAND_3in_6.a 0.36141f
C1279 vp VCO5_selection_0.NAND_2in_0.b 0.60977f
C1280 100 001 9.11056f
C1281 VCO4_selection_0.NOR_2in_0.b VCO4_selection_0.inverter_3.out 0.01036f
C1282 after_000011_n 011 1.09079f
C1283 VCO2_selection_0.NAND_4in_0.b f5_n 0.55413f
C1284 m2_31033_24515# 3bit_to_8_outs_0.inverter_1.in 0.21959f
C1285 f5 f2 0.09682f
C1286 3bit_to_8_outs_0.inverter_8.in a_31626_26816# 0.01402f
C1287 vp VCO2_selection_0.XNOR_0._b 0.3313f
C1288 101 m2_31033_25501# 0.17997f
C1289 f5 m2_31328_34835# 0.07783f
C1290 VCO2_selection_0.NOR_2in_0.b m2_32841_30841# 0.01008f
C1291 VCO3_selection_0.XNOR_1._b VCO3_selection_0.NAND_3in_8.y 0.01232f
C1292 a_33317_29780# VCO2_selection_0.NOR_2in_0.y 0.08012f
C1293 VCO3_selection_0.NAND_2in_3.y 110 0.03358f
C1294 f1_n 3bit_to_8_outs_0.NAND_3in_0.y 0.01732f
C1295 VCO3_selection_0.inverter_8.out a_33486_41044# 0.01383f
C1296 3bit_to_8_outs_0.c0_n 3bit_to_8_outs_0.NAND_3in_0.y 0.48221f
C1297 a_31276_45946# a_31060_45946# 0.02909f
C1298 000 c0 0.01351f
C1299 VCO2_selection_0.NAND_4in_0.c f5_n 0.21039f
C1300 VCO2_5_sel VCO2_selection_0.NAND_4in_0.b 0.95058f
C1301 VCO3_selection_0.NAND_2in_1.y a_32258_36164# 0.07562f
C1302 VCO3_selection_0.inverter_2.out VCO3_selection_0.NAND_3in_1.y 0.50358f
C1303 a_32772_28789# VCO5_selection_0.inverter_0.in 0.07322f
C1304 vp c0 2.02376f
C1305 vp VCO3_selection_0.NAND_3in_7.c 0.56051f
C1306 a_32252_38120# VCO3_selection_0.NAND_3in_7.c 0.02301f
C1307 000 a_30783_28315# 0.0116f
C1308 f0 a_31939_31170# 0.1535f
C1309 VCO_selection_0.NAND_2in_1.y VCO_sel 0.71543f
C1310 VCO4_selection_0.inverter_3.in VCO4_selection_0.inverter_3.out 0.41883f
C1311 VCO3_selection_0.NAND_3in_3.y after_000111_n 0.65361f
C1312 f5 110 0.13681f
C1313 3bit_to_8_outs_0.c1_n 3bit_to_8_outs_0.inverter_6.in 0.72465f
C1314 010 3bit_to_8_outs_0.c2_n 0.01474f
C1315 000 f0 35.6894f
C1316 VCO4_selection_0.inverter_5.in VCO4_selection_0.NOR_2in_0.a 0.01843f
C1317 VCO5_selection_0.NOR_2in_0.y VCO5_selection_0.inverter_0.in 0.18727f
C1318 100 f5 7.76015f
C1319 a_31740_45946# after_000111_n 0.01632f
C1320 f2 after_000111_n 0.01629f
C1321 c1 after_000111_n 0.02082f
C1322 a_32779_32240# VCO2_selection_0.inverter_6.out 0.01409f
C1323 VCO2_selection_0.NAND_3in_3.c after_000011 0.0262f
C1324 3bit_to_8_outs_0.c1_n 3bit_to_8_outs_0.inverter_10.in 0.11309f
C1325 VCO5_11_sel VCO5_selection_0.inverter_0.in 0.01146f
C1326 VCO2_selection_0.inverter_1.in f5 0.01441f
C1327 f0 vp 26.2632f
C1328 VCO2_selection_0.NAND_4in_0.d VCO2_selection_0.NAND_3in_4.y 0.08025f
C1329 VCO2_selection_0.NAND_4in_0.c VCO2_5_sel 0.83369f
C1330 VCO5_selection_0.inverter_1.in f1_n 1.3069f
C1331 VCO_selection_0.NAND_2in_2.y 101 0.33741f
C1332 VCO3_selection_0.NAND_3in_6.c m2_33407_40705# 0.27093f
C1333 VCO4_selection_0.inverter_5.in m2_32494_47727# 0.01094f
C1334 VCO3_selection_0.XNOR_1._a f0 1.82677f
C1335 m2_32494_47727# f1 0.01358f
C1336 101 001 0.76489f
C1337 VCO3_selection_0.NAND_3in_7.y 011 0.56075f
C1338 a_32090_24854# a_32306_24854# 0.02909f
C1339 VCO5_selection_0.inverter_2.in f1 0.99695f
C1340 101 a_32779_32240# 0.01333f
C1341 VCO3_11_sel VCO3_selection_0.NOR_2in_0.y 0.50906f
C1342 after_000111_n 110 0.14684f
C1343 VCO4_selection_0.inverter_3.in VCO4_selection_0.inverter_2.in 0.04595f
C1344 VCO4_selection_0.inverter_3.in VCO4_selection_0.NAND_3in_1.y 0.52651f
C1345 100 after_000111_n 0.35089f
C1346 3bit_to_8_outs_0.NAND_3in_6.y a_31410_26498# 0.07156f
C1347 VCO2_selection_0.inverter_3.in VCO3_selection_0.NAND_3in_1.y 0.02022f
C1348 VCO5_selection_0.inverter_0.in m2_32477_28872# 0.14207f
C1349 VCO2_selection_0.NOR_2in_2.a VCO3_selection_0.NAND_2in_1.y 0.01621f
C1350 VCO3_selection_0.NAND_2in_3.y 101 0.54609f
C1351 VCO4_selection_0.NOR_2in_0.a VCO4_selection_0.NAND_2in_0.a 0.099f
C1352 VCO4_selection_0.NOR_2in_1.a VCO4_selection_0.inverter_0.out 0.14591f
C1353 m2_32496_34103# m2_32768_34103# 0.01717f
C1354 VCO3_selection_0.NAND_3in_3.y VCO3_selection_0.NOR_2in_0.y 0.02897f
C1355 m2_31328_30191# after_000011 0.019f
C1356 001 m2_31493_41847# 0.01129f
C1357 m2_31673_44547# m2_31673_44629# 0.16814f
C1358 VCO5_selection_0.XNOR_0._b m2_32217_28872# 0.0481f
C1359 VCO4_selection_0.NOR_2in_0.b VCO4_selection_0.NAND_2in_0.a 0.33544f
C1360 c0 VCO5_selection_0.NAND_2in_0.b 0.02954f
C1361 row_section_decoding_0.NAND_2in_0.a row_section_decoding_0.NAND_2in_0.b 0.84917f
C1362 VCO3_selection_0.NAND_3in_6.b a_33561_40066# 0.04434f
C1363 f3 row_section_decoding_0.NAND_2in_0.b 0.16466f
C1364 VCO2_selection_0.NOR_2in_2.a VCO2_selection_0.NOR_2in_2.y 0.28841f
C1365 001 f5_n 0.11734f
C1366 m2_30711_49693# after_001111 0.0111f
C1367 VCO2_11_sel m2_33294_34753# 0.09318f
C1368 001 011 0.64988f
C1369 VCO4_selection_0.inverter_0.out VCO4_selection_0.inverter_1.in 0.16991f
C1370 f0 a_32104_39564# 0.15466f
C1371 m2_30981_43897# f1 0.67483f
C1372 a_31260_49868# a_31476_49868# 0.02909f
C1373 after_000011_n VCO5_selection_0.inverter_2.in 0.17907f
C1374 m2_32494_47809# m2_32494_47727# 0.16814f
C1375 VCO4_selection_0.NAND_3in_0.y m2_31673_43651# 0.22679f
C1376 a_32090_26498# a_32306_26498# 0.02909f
C1377 VCO3_selection_0.NAND_3in_6.a m2_33405_42661# 0.27348f
C1378 VCO2_selection_0.NOR_2in_1.y VCO2_selection_0.inverter_1.out 0.28826f
C1379 101 f5 1.7122f
C1380 VCO3_selection_0.inverter_2.out VCO3_selection_0.inverter_4.out 0.04586f
C1381 3bit_to_8_outs_0.inverter_10.in a_31626_26498# 0.01402f
C1382 after_000111_n VCO2_selection_0.inverter_6.out 0.69621f
C1383 VCO2_selection_0.inverter_1.in VCO2_selection_0.NAND_2in_0.y 0.72136f
C1384 VCO3_selection_0.NAND_2in_3.y f5_n 0.0319f
C1385 f0 VCO2_selection_0.XNOR_0._b 0.47719f
C1386 f5_n VCO3_selection_0.XNOR_0._b 0.17174f
C1387 VCO3_selection_0.NAND_3in_5.y VCO3_selection_0.inverter_10.out 0.4094f
C1388 a_32090_26816# a_32306_26816# 0.02909f
C1389 VCO3_selection_0.NAND_2in_1.y VCO3_selection_0.inverter_1.out 0.59972f
C1390 a_31623_32714# VCO2_selection_0.NAND_4in_0.a 0.07156f
C1391 VCO2_selection_0.NOR_2in_2.b VCO3_selection_0.NAND_2in_1.y 0.02902f
C1392 VCO4_selection_0.inverter_3.in after_000011_n 0.02267f
C1393 m2_31673_43815# VCO4_selection_0.inverter_0.out 0.18043f
C1394 VCO3_selection_0.NAND_3in_4.y f1 0.01353f
C1395 VCO3_selection_0.NOR_2in_1.y VCO3_selection_0.NOR_2in_0.y 1.18187f
C1396 VCO3_selection_0.inverter_0.out VCO3_selection_0.inverter_3.out 0.02058f
C1397 f5 m2_31493_41847# 0.08645f
C1398 VCO4_selection_0.inverter_5.out vp 0.39355f
C1399 VCO3_selection_0.NOR_2in_4.a VCO3_selection_0.NAND_3in_6.b 0.28843f
C1400 c2 3bit_to_8_outs_0.NAND_3in_0.y 2.12385f
C1401 010 f1 0.22209f
C1402 after_000011_n m2_30981_43897# 0.01792f
C1403 f1_n f4 0.01586f
C1404 vp 3bit_to_8_outs_0.NAND_3in_6.y 0.57491f
C1405 m2_30761_25501# 3bit_to_8_outs_0.inverter_6.in 0.17968f
C1406 VCO2_selection_0.NOR_2in_2.y VCO3_selection_0.inverter_1.out 0.03152f
C1407 VCO2_selection_0.NOR_2in_2.a VCO2_selection_0.inverter_2.in 0.61207f
C1408 f5 f5_n 2.10243f
C1409 VCO2_selection_0.NOR_2in_1.y m2_33034_34103# 0.17799f
C1410 VCO2_selection_0.NOR_2in_2.b VCO2_selection_0.NOR_2in_2.y 0.36673f
C1411 m2_30981_44547# VCO4_selection_0.inverter_2.in 0.09699f
C1412 000 f3 0.01196f
C1413 f5 011 0.08698f
C1414 f0 c0 0.021f
C1415 f0 VCO3_selection_0.NAND_3in_7.c 0.35668f
C1416 VCO3_selection_0.NAND_3in_0.c m2_33397_38027# 0.71956f
C1417 vp row_section_decoding_0.NAND_2in_0.a 0.37327f
C1418 101 after_000111_n 0.13258f
C1419 vp f3 1.09683f
C1420 VCO_sel a_31260_49868# 0.01119f
C1421 VCO3_selection_0.inverter_10.out m2_32865_42825# 0.22322f
C1422 vp a_31986_22377# 0.12279f
C1423 VCO3_selection_0.inverter_0.out m2_32865_37781# 0.17997f
C1424 VCO2_selection_0.NOR_2in_2.y VCO2_selection_0.NOR_2in_1.y 1.07078f
C1425 VCO4_selection_0.XNOR_0.y VCO4_selection_0.XNOR_0._a 1.03953f
C1426 f2 row_section_decoding_0.NAND_2in_0.b 0.011f
C1427 VCO4_selection_0.inverter_5.out VCO4_selection_0.inverter_4.in 0.35319f
C1428 VCO3_selection_0.NAND_2in_0.y 101 0.23204f
C1429 a_31276_45946# VCO4_selection_0.inverter_3.in 0.07156f
C1430 VCO3_selection_0.XNOR_1.y f1 1.07697f
C1431 VCO3_selection_0.inverter_3.out m2_33199_36803# 0.10901f
C1432 vp VCO4_selection_0.NOR_2in_1.a 0.34887f
C1433 vp VCO3_selection_0.inverter_10.out 0.33573f
C1434 m2_32723_41929# m2_32989_41929# 0.01796f
C1435 VCO3_11_sel VCO3_selection_0.inverter_5.out 0.07319f
C1436 VCO3_selection_0.inverter_12.out after_000111_n 0.02013f
C1437 VCO5_selection_0.NAND_2in_0.b m2_32192_28222# 0.16814f
C1438 VCO3_selection_0.NAND_3in_6.b m2_32989_41847# 0.27137f
C1439 VCO2_selection_0.NAND_4in_0.a 110 0.37845f
C1440 VCO3_selection_0.NAND_3in_4.y after_000011_n 0.5698f
C1441 110 VCO_selection_0.NAND_2in_0.y 0.31751f
C1442 VCO2_selection_0.NAND_3in_5.c VCO2_selection_0.NOR_2in_0.b 0.02371f
C1443 VCO3_selection_0.NAND_3in_8.y vp 0.64331f
C1444 VCO5_selection_0.inverter_2.in VCO5_selection_0.XNOR_0._b 0.66266f
C1445 VCO2_selection_0.inverter_1.in VCO2_selection_0.NAND_4in_0.a 0.05342f
C1446 after_000111_n a_31060_45946# 0.01632f
C1447 010 after_000011_n 2.85025f
C1448 VCO3_selection_0.XNOR_1.y VCO3_selection_0.NAND_3in_6.c 0.13199f
C1449 010 VCO4_selection_0.NAND_2in_0.a 0.0125f
C1450 a_31303_28315# VCO5_selection_0.NAND_2in_0.b 0.01271f
C1451 VCO3_selection_0.NAND_3in_3.y VCO3_selection_0.inverter_5.out 0.40942f
C1452 vp VCO4_selection_0.inverter_1.in 0.28161f
C1453 VCO3_selection_0.NAND_2in_0.y m2_31493_41847# 0.28323f
C1454 VCO3_selection_0.NAND_3in_3.y m2_33137_37945# 0.1796f
C1455 VCO2_selection_0.NAND_3in_5.c m2_32824_34835# 0.01912f
C1456 3bit_to_8_outs_0.c1_n 3bit_to_8_outs_0.c2_n 5.27335f
C1457 f5_n after_000111_n 0.72665f
C1458 VCO3_selection_0.XNOR_1._b f5_n 0.1716f
C1459 VCO2_selection_0.NOR_2in_2.b m2_32286_34999# 0.22322f
C1460 VCO4_selection_0.inverter_4.in m2_32353_46585# 0.16871f
C1461 VCO4_5_sel VCO4_selection_0.NAND_2in_0.a 0.48656f
C1462 011 after_000111_n 9.36692f
C1463 VCO2_selection_0.NOR_2in_2.b VCO2_selection_0.inverter_2.in 0.53082f
C1464 VCO2_selection_0.NOR_2in_0.a a_33317_29780# 0.04837f
C1465 VCO4_selection_0.inverter_4.in VCO4_selection_0.NOR_2in_1.a 0.41291f
C1466 vp a_31775_29201# 0.17108f
C1467 vp VCO2_selection_0.XNOR_0._a 0.36612f
C1468 vp VCO3_11_sel 0.39161f
C1469 VCO3_selection_0.NAND_2in_0.y f5_n 0.13408f
C1470 m2_32933_36071# m2_33199_36071# 0.01796f
C1471 VCO5_selection_0.NOR_2in_0.y a_33013_28315# 0.01379f
C1472 VCO4_11_sel VCO4_selection_0.NOR_2in_0.a 0.02049f
C1473 3bit_to_8_outs_0.inverter_8.in 3bit_to_8_outs_0.NAND_3in_2.y 0.48578f
C1474 000 VCO3_selection_0.NAND_3in_3.y 0.04812f
C1475 VCO5_11_sel a_33013_28315# 0.07562f
C1476 VCO3_selection_0.NAND_3in_1.y after_000011 0.58046f
C1477 after_000011_n VCO2_selection_0.NAND_3in_7.y 0.37563f
C1478 VCO4_selection_0.XNOR_1._a VCO4_selection_0.XNOR_0._a 0.04586f
C1479 a_31572_36638# a_31788_36638# 0.02909f
C1480 000 f2 0.01507f
C1481 vp VCO3_selection_0.NAND_3in_3.y 0.63939f
C1482 VCO2_selection_0.NAND_3in_3.y m2_32700_30109# 0.0115f
C1483 VCO3_selection_0.NAND_3in_3.y a_32252_38120# 0.01512f
C1484 VCO2_selection_0.NAND_3in_3.y VCO2_selection_0.NAND_3in_7.y 0.48587f
C1485 VCO4_selection_0.XNOR_0.y VCO4_selection_0.XNOR_1._a 0.01133f
C1486 VCO2_selection_0.inverter_2.in m2_32558_34753# 0.17808f
C1487 vp f2 0.26037f
C1488 VCO2_selection_0.NAND_4in_0.b VCO2_selection_0.NAND_3in_4.y 0.01098f
C1489 vp c1 0.52005f
C1490 f1_n m2_31925_23438# 0.09739f
C1491 001 VCO5_selection_0.inverter_2.in 0.44976f
C1492 m2_33294_34753# m2_32824_34753# 0.01839f
C1493 VCO3_selection_0.inverter_8.out VCO3_selection_0.NAND_3in_6.b 0.0269f
C1494 a_31572_36164# VCO3_selection_0.NAND_3in_1.y 0.0131f
C1495 VCO2_selection_0.NAND_2in_0.y 011 0.54931f
C1496 VCO4_selection_0.NAND_3in_1.y VCO4_selection_0.NAND_3in_2.y 0.04095f
C1497 VCO5_selection_0.NOR_2in_0.y m2_32458_28222# 0.16564f
C1498 a_32405_30758# VCO2_selection_0.XNOR_0._a 0.07427f
C1499 111 VCO2_selection_0.NAND_3in_3.c 0.01724f
C1500 VCO3_selection_0.inverter_8.out m2_32865_40869# 0.22322f
C1501 a_31321_28789# VCO5_selection_0.XNOR_0._b 0.04746f
C1502 VCO4_selection_0.inverter_5.in VCO4_selection_0.NAND_3in_2.y 0.05947f
C1503 m2_33176_32065# VCO2_selection_0.inverter_6.out 0.35153f
C1504 vp VCO2_selection_0.inverter_4.out 0.26064f
C1505 VCO3_selection_0.inverter_10.out VCO3_selection_0.NAND_3in_6.a 0.3462f
C1506 VCO4_selection_0.inverter_3.in 001 0.48778f
C1507 VCO2_selection_0.NAND_4in_0.c VCO2_selection_0.NAND_3in_4.y 0.02211f
C1508 VCO_selection_0.NAND_2in_2.y VCO_sel 0.54029f
C1509 3bit_to_8_outs_0.NAND_3in_0.y after_001111 0.01405f
C1510 VCO5_selection_0.inverter_2.out m2_32217_29118# 0.19881f
C1511 000 110 0.05699f
C1512 100 000 0.06978f
C1513 VCO4_selection_0.inverter_3.in VCO4_11_sel 0.4073f
C1514 010 VCO5_selection_0.XNOR_0._b 0.02912f
C1515 101 VCO2_selection_0.NAND_4in_0.a 0.34844f
C1516 m2_30981_44547# m2_31673_44547# 0.01756f
C1517 3bit_to_8_outs_0.NAND_3in_0.y 3bit_to_8_outs_0.inverter_6.in 0.2557f
C1518 vp 110 1.90067f
C1519 f1_n 3bit_to_8_outs_0.c0_n 0.02279f
C1520 vp VCO3_selection_0.NOR_2in_1.y 0.35404f
C1521 100 vp 1.75857f
C1522 after_000011_n 3bit_to_8_outs_0.inverter_1.in 0.02121f
C1523 VCO4_selection_0.XNOR_1._b a_31598_47902# 0.04746f
C1524 c0 f3 0.07086f
C1525 vp VCO2_selection_0.inverter_1.in 0.57626f
C1526 VCO4_selection_0.NAND_3in_0.y after_000111 0.01438f
C1527 3bit_to_8_outs_0.c2_n a_31626_26498# 0.01634f
C1528 a_31276_43990# 010 0.01179f
C1529 VCO5_selection_0.inverter_1.out VCO5_selection_0.inverter_2.in 0.01875f
C1530 VCO3_11_sel VCO3_selection_0.NAND_3in_6.a 0.01059f
C1531 a_31572_36638# VCO3_selection_0.NAND_3in_2.y 0.0131f
C1532 f4 after_000011 0.06393f
C1533 3bit_to_8_outs_0.c2_n a_31626_26816# 0.01634f
C1534 VCO3_selection_0.inverter_12.out m2_33006_39891# 0.18043f
C1535 VCO2_selection_0.XNOR_0._b VCO2_selection_0.XNOR_0._a 0.62619f
C1536 VCO_selection_0.NAND_2in_2.y a_30790_50186# 0.07571f
C1537 m2_33323_30841# VCO2_selection_0.inverter_4.out 0.09861f
C1538 VCO2_selection_0.NAND_3in_5.c VCO2_selection_0.NOR_2in_0.y 0.60096f
C1539 after_000111 f4 0.01555f
C1540 f0 f3 0.01423f
C1541 VCO3_selection_0.NAND_3in_5.y a_32468_42496# 0.01082f
C1542 after_000011_n VCO4_selection_0.NAND_3in_2.y 0.53606f
C1543 VCO2_selection_0.NAND_4in_0.a f5_n 0.24126f
C1544 a_30990_22377# after_000111_n 0.07095f
C1545 VCO3_selection_0.inverter_10.out m2_33405_42661# 0.07363f
C1546 VCO2_selection_0.NAND_4in_0.a 011 0.0932f
C1547 m2_30761_27145# m2_31033_27145# 0.01717f
C1548 VCO2_selection_0.NAND_4in_0.d VCO2_selection_0.NAND_3in_3.c 0.01084f
C1549 VCO2_selection_0.NOR_2in_0.b VCO2_selection_0.NOR_2in_0.y 0.49818f
C1550 010 001 35.8377f
C1551 VCO2_selection_0.NAND_4in_0.d a_32828_32714# 0.056f
C1552 after_001111_n f4 0.13736f
C1553 VCO4_selection_0.NAND_3in_1.y m2_32353_45607# 0.22679f
C1554 vp VCO2_selection_0.inverter_6.out 0.56763f
C1555 VCO3_selection_0.inverter_8.out VCO3_selection_0.inverter_7.out 1.24132f
C1556 a_32252_40540# VCO3_selection_0.NAND_3in_8.y 0.01307f
C1557 a_32110_40066# VCO3_selection_0.XNOR_1.y 0.07105f
C1558 VCO3_selection_0.XNOR_1._a a_32570_40066# 0.07427f
C1559 VCO2_5_sel VCO2_selection_0.NAND_4in_0.a 0.51009f
C1560 m2_33238_30191# VCO2_selection_0.NAND_3in_7.y 0.01904f
C1561 VCO3_selection_0.NAND_2in_1.y VCO3_selection_0.NAND_3in_1.y 0.91123f
C1562 a_31740_46420# VCO4_selection_0.NAND_3in_2.y 0.0131f
C1563 a_31623_30284# VCO2_selection_0.NAND_3in_7.y 0.07204f
C1564 VCO3_selection_0.NAND_3in_3.y VCO3_selection_0.NAND_3in_7.c 0.73808f
C1565 f0 a_31775_29201# 0.02644f
C1566 f0 VCO2_selection_0.XNOR_0._a 1.659f
C1567 a_32368_32714# 101 0.0601f
C1568 3bit_to_8_outs_0.c0_n a_32090_25172# 0.01191f
C1569 VCO3_selection_0.NAND_3in_5.y f5_n 1.27101f
C1570 c0 f2 0.01342f
C1571 111 3bit_to_8_outs_0.NAND_3in_0.y 0.41578f
C1572 c0 c1 15.4285f
C1573 VCO3_selection_0.NAND_3in_5.y 011 0.3931f
C1574 000 101 0.06018f
C1575 a_30774_22377# after_000111_n 0.01227f
C1576 VCO5_selection_0.inverter_0.out VCO5_selection_0.inverter_0.in 0.96432f
C1577 VCO4_selection_0.inverter_3.in after_000111_n 1.58551f
C1578 a_32779_32240# VCO2_selection_0.NAND_3in_4.y 0.07155f
C1579 101 vp 1.53435f
C1580 after_000011_n a_32258_36164# 0.04417f
C1581 c2 3bit_to_8_outs_0.NAND_3in_3.y 0.53843f
C1582 010 f5 1.0352f
C1583 a_31572_38120# after_000111_n 0.02628f
C1584 VCO2_selection_0.NOR_2in_2.a VCO2_selection_0.inverter_0.out 0.02274f
C1585 f0 f2 0.03367f
C1586 f0 c1 0.01628f
C1587 VCO3_selection_0.NAND_3in_6.b VCO3_5_sel 0.67773f
C1588 VCO3_selection_0.NOR_2in_0.y m2_33397_38027# 0.01083f
C1589 VCO3_selection_0.inverter_12.out vp 0.36966f
C1590 VCO4_selection_0.inverter_2.out a_32018_44968# 0.0537f
C1591 VCO2_selection_0.NAND_4in_0.d a_32563_32240# 0.01205f
C1592 VCO2_selection_0.inverter_1.out a_33113_33692# 0.05153f
C1593 a_32570_38594# VCO3_selection_0.NAND_3in_7.c 0.07537f
C1594 VCO4_selection_0.inverter_5.in a_32052_47400# 0.11436f
C1595 a_33486_41044# VCO3_selection_0.NAND_3in_6.c 0.08013f
C1596 000 f5_n 0.06105f
C1597 c0 110 0.01342f
C1598 f5 VCO2_selection_0.NAND_3in_7.y 0.0268f
C1599 000 011 0.33675f
C1600 100 c0 0.01349f
C1601 vp f5_n 0.86736f
C1602 010 a_31407_34670# 0.01155f
C1603 000 a_32258_36638# 0.01155f
C1604 VCO3_selection_0.NAND_3in_4.y after_000111_n 0.53807f
C1605 VCO3_selection_0.XNOR_1._b VCO3_selection_0.NAND_3in_4.y 0.0329f
C1606 vp 011 8.83089f
C1607 VCO5_selection_0.inverter_1.in VCO5_selection_0.XNOR_0._a 0.03053f
C1608 f1_n after_000011 0.05376f
C1609 after_001111_n m2_31925_23438# 0.03798f
C1610 VCO2_selection_0.inverter_2.in VCO3_selection_0.NAND_3in_1.y 0.01233f
C1611 VCO5_selection_0.inverter_2.out m2_32477_28872# 0.01415f
C1612 a_31510_22377# f4 0.04801f
C1613 VCO4_selection_0.NOR_2in_0.a VCO4_selection_0.inverter_0.out 0.10179f
C1614 VCO5_selection_0.NOR_2in_0.y 3bit_to_8_outs_0.c0_n 0.01837f
C1615 VCO3_selection_0.NAND_3in_4.y VCO3_selection_0.NAND_2in_0.y 0.02372f
C1616 VCO2_selection_0.XNOR_0._b VCO2_selection_0.inverter_6.out 0.08052f
C1617 f0 110 0.0941f
C1618 010 after_000111_n 0.16369f
C1619 3bit_to_8_outs_0.inverter_8.in 3bit_to_8_outs_0.c0_n 0.54097f
C1620 after_000111 f1_n 43.4389f
C1621 3bit_to_8_outs_0.c0_n after_000011 0.01335f
C1622 f1_n c2 0.02062f
C1623 f4 after_001111 0.0155f
C1624 100 f0 0.09682f
C1625 m2_30981_46503# VCO4_selection_0.XNOR_0.y 0.11258f
C1626 VCO4_selection_0.inverter_3.in m2_32625_45771# 0.1796f
C1627 VCO4_selection_0.NOR_2in_0.b VCO4_selection_0.inverter_0.out 0.0266f
C1628 VCO4_selection_0.NAND_2in_0.b VCO4_selection_0.NAND_2in_0.a 0.70451f
C1629 VCO4_selection_0.inverter_5.out VCO4_selection_0.NOR_2in_1.a 0.57872f
C1630 after_000111 3bit_to_8_outs_0.c0_n 0.02315f
C1631 VCO3_selection_0.NAND_3in_2.y VCO3_selection_0.inverter_3.out 0.61207f
C1632 VCO3_selection_0.inverter_4.in VCO3_selection_0.inverter_4.out 0.47819f
C1633 c2 3bit_to_8_outs_0.c0_n 5.03952f
C1634 f3 row_section_decoding_0.NAND_2in_0.a 0.62991f
C1635 VCO_selection_0.NAND_2in_0.y a_30790_49868# 0.07562f
C1636 vp VCO2_5_sel 0.47072f
C1637 VCO4_selection_0.inverter_4.in 011 0.56397f
C1638 after_001111_n f1_n 0.48156f
C1639 VCO3_selection_0.inverter_11.out m2_33405_42579# 0.01301f
C1640 VCO3_selection_0.NAND_3in_6.b VCO3_selection_0.inverter_11.out 0.02028f
C1641 VCO2_selection_0.NOR_2in_1.y VCO2_selection_0.inverter_0.out 0.34524f
C1642 VCO3_selection_0.XNOR_1._b VCO3_selection_0.XNOR_1.y 0.66266f
C1643 a_31060_44464# after_001111_n 0.01632f
C1644 VCO2_selection_0.NAND_3in_7.y after_000111_n 0.53981f
C1645 3bit_to_8_outs_0.c2_n 3bit_to_8_outs_0.NAND_3in_0.y 0.04478f
C1646 a_31877_32240# after_000011 0.04539f
C1647 VCO2_selection_0.NOR_2in_1.y VCO2_11_sel 0.54173f
C1648 after_000111_n VCO2_selection_0.NAND_3in_4.y 0.53404f
C1649 VCO3_selection_0.NAND_3in_5.y VCO3_selection_0.NAND_3in_9.y 0.47412f
C1650 a_31572_42496# a_31788_42496# 0.02909f
C1651 VCO4_selection_0.NAND_3in_0.y m2_31673_43897# 0.01049f
C1652 VCO3_selection_0.NAND_2in_1.y VCO3_selection_0.inverter_2.out 0.58574f
C1653 f1 VCO2_selection_0.NAND_3in_3.c 1.01671f
C1654 f0 VCO2_selection_0.inverter_6.out 0.02157f
C1655 a_32093_34196# 011 0.01155f
C1656 VCO3_selection_0.NOR_2in_4.b VCO3_selection_0.NAND_3in_6.b 0.34269f
C1657 VCO4_selection_0.NOR_2in_1.a VCO4_selection_0.inverter_1.in 0.24075f
C1658 a_33476_38120# a_33692_38120# 0.02909f
C1659 101 c0 0.01436f
C1660 VCO4_selection_0.XNOR_0._b VCO4_selection_0.XNOR_0._a 0.62619f
C1661 c1 3bit_to_8_outs_0.NAND_3in_6.y 0.61544f
C1662 3bit_to_8_outs_0.inverter_6.in 3bit_to_8_outs_0.NAND_3in_3.y 0.48578f
C1663 VCO_sel VCO_selection_0.NAND_2in_0.y 0.65566f
C1664 a_33373_34670# VCO2_11_sel 0.01154f
C1665 a_31060_43990# f1 0.01632f
C1666 VCO3_selection_0.NAND_3in_9.y m2_32865_42825# 0.22771f
C1667 VCO2_selection_0.NOR_2in_2.y VCO2_selection_0.NAND_3in_5.c 0.2957f
C1668 VCO4_selection_0.XNOR_0.y VCO4_selection_0.XNOR_0._b 0.5806f
C1669 f2 row_section_decoding_0.NAND_2in_0.a 0.16853f
C1670 m2_32217_28872# m2_32217_28954# 0.16814f
C1671 f2 f3 2.84651f
C1672 after_000011_n m2_32661_36071# 0.0169f
C1673 VCO3_selection_0.inverter_4.out m2_33199_36803# 0.0378f
C1674 101 f0 0.09312f
C1675 vp VCO4_selection_0.NOR_2in_0.a 0.42664f
C1676 vp VCO3_selection_0.NAND_3in_9.y 0.6344f
C1677 after_000011_n VCO5_selection_0.inverter_0.in 1.22981f
C1678 after_000011_n VCO2_selection_0.NAND_3in_3.c 0.29572f
C1679 VCO3_selection_0.NOR_2in_4.a m2_32989_41847# 0.10901f
C1680 111 f4 0.01539f
C1681 VCO4_selection_0.inverter_5.in a_31598_47902# 0.07105f
C1682 m2_31181_49775# VCO_sel 0.09306f
C1683 a_32058_47902# VCO4_selection_0.XNOR_1._a 0.07427f
C1684 VCO2_selection_0.NOR_2in_2.a m2_32824_34753# 0.01348f
C1685 VCO3_selection_0.inverter_0.out a_33085_39098# 0.04823f
C1686 VCO3_selection_0.inverter_0.out m2_32865_37945# 0.18043f
C1687 vp a_30990_22377# 0.09506f
C1688 VCO5_selection_0.inverter_0.in VCO2_selection_0.NAND_3in_3.y 0.03071f
C1689 VCO2_selection_0.NAND_3in_3.y VCO2_selection_0.NAND_3in_3.c 0.7678f
C1690 VCO4_selection_0.NOR_2in_0.b vp 0.25495f
C1691 VCO4_11_sel m2_32353_45607# 0.22668f
C1692 f5_n VCO3_selection_0.NAND_3in_7.c 0.02185f
C1693 c0 f5_n 0.06121f
C1694 m2_32451_41929# m2_32723_41929# 0.01717f
C1695 010 VCO4_selection_0.inverter_0.out 0.02727f
C1696 VCO3_selection_0.NAND_3in_6.b m2_32989_41929# 0.16564f
C1697 a_32252_40540# VCO3_selection_0.inverter_12.out 0.01636f
C1698 VCO3_selection_0.NAND_3in_7.c 011 0.16051f
C1699 c0 011 0.01342f
C1700 3bit_to_8_outs_0.NAND_3in_2.y 3bit_to_8_outs_0.c2_n 0.53837f
C1701 VCO2_selection_0.NOR_2in_2.y m2_32824_34835# 0.27137f
C1702 VCO2_selection_0.NOR_2in_0.a VCO2_selection_0.NOR_2in_0.b 1.33059f
C1703 VCO4_selection_0.inverter_4.in VCO4_selection_0.NOR_2in_0.a 0.48774f
C1704 f1_n after_001111 43.8416f
C1705 a_32903_35174# vp 0.12274f
C1706 vp VCO5_selection_0.inverter_2.in 0.54786f
C1707 m2_30761_25501# m2_31033_25501# 0.01717f
C1708 VCO2_selection_0.inverter_3.in after_001111 0.01937f
C1709 111 m2_30711_49775# 0.03453f
C1710 row_section_decoding_0.NAND_2in_0.a 110 0.03772f
C1711 vp a_32564_39006# 0.17108f
C1712 VCO2_selection_0.NAND_4in_0.c a_32828_32714# 0.01523f
C1713 f3 110 0.01146f
C1714 f0 f5_n 0.16058f
C1715 3bit_to_8_outs_0.c0_n after_001111 0.02276f
C1716 VCO3_selection_0.inverter_1.out m2_32933_36071# 0.09799f
C1717 VCO3_selection_0.NAND_2in_0.y m2_32723_41929# 0.17808f
C1718 f0 011 0.19928f
C1719 100 f3 0.01132f
C1720 VCO5_11_sel VCO5_selection_0.NOR_2in_0.y 0.46553f
C1721 m2_32865_37781# m2_33137_37781# 0.01717f
C1722 3bit_to_8_outs_0.c0_n 3bit_to_8_outs_0.inverter_6.in 0.43482f
C1723 VCO4_selection_0.inverter_3.in 000 0.54337f
C1724 100 a_31788_40540# 0.01179f
C1725 VCO_selection_0.NAND_2in_2.y m2_30711_49693# 0.01938f
C1726 VCO3_selection_0.XNOR_1.y m2_33006_39891# 0.01094f
C1727 after_000111 after_000011 0.25997f
C1728 vp a_30774_22377# 0.12528f
C1729 c2 after_000011 0.01964f
C1730 m2_32661_36071# m2_32933_36071# 0.01717f
C1731 3bit_to_8_outs_0.c0_n 3bit_to_8_outs_0.inverter_10.in 0.47983f
C1732 VCO4_selection_0.inverter_3.in vp 0.57087f
C1733 VCO2_selection_0.inverter_1.in m2_33034_34021# 0.01859f
C1734 VCO2_selection_0.NOR_2in_2.b m2_32824_34753# 0.01079f
C1735 VCO3_selection_0.inverter_8.out VCO3_selection_0.NOR_2in_4.a 0.01793f
C1736 010 VCO3_selection_0.NAND_3in_5.y 0.42227f
C1737 VCO3_selection_0.NAND_3in_8.y 110 0.59878f
C1738 after_000111 c2 0.03876f
C1739 VCO2_selection_0.NAND_3in_5.c a_32920_31262# 0.08009f
C1740 m2_33199_36071# m2_33199_36721# 0.01956f
C1741 VCO2_selection_0.XNOR_0._a VCO2_selection_0.inverter_4.out 0.01362f
C1742 a_32828_32714# a_33044_32714# 0.02909f
C1743 VCO5_selection_0.inverter_0.out m2_32458_28222# 0.01348f
C1744 VCO3_selection_0.NAND_3in_7.y m2_32865_37781# 0.22771f
C1745 VCO2_selection_0.inverter_2.in m2_32824_34835# 0.01859f
C1746 after_001111_n after_000011 0.31498f
C1747 m2_32865_42661# m2_33137_42661# 0.01717f
C1748 vp VCO_sel 0.43524f
C1749 a_33278_35660# vp 0.12263f
C1750 m2_33176_32065# VCO2_selection_0.NAND_3in_4.y 0.0115f
C1751 VCO4_selection_0.inverter_3.in VCO4_selection_0.inverter_4.in 0.05419f
C1752 a_32048_42022# after_000011_n 0.04416f
C1753 after_001111_n after_000111 2.66958f
C1754 VCO3_11_sel VCO3_selection_0.NOR_2in_1.y 0.75789f
C1755 m2_32558_34753# m2_32824_34753# 0.01796f
C1756 after_001111_n c2 0.01965f
C1757 VCO5_selection_0.inverter_2.in m2_32217_28954# 0.01094f
C1758 a_32090_24854# 3bit_to_8_outs_0.NAND_3in_0.y 0.08164f
C1759 VCO2_selection_0.inverter_3.in m2_32286_34999# 0.22451f
C1760 VCO2_selection_0.inverter_2.in VCO2_selection_0.inverter_3.in 0.69606f
C1761 001 a_31276_46420# 0.01219f
C1762 vp a_32399_31170# 0.17108f
C1763 a_31623_32714# 110 0.01179f
C1764 VCO3_selection_0.NAND_3in_4.y vp 0.57875f
C1765 a_32468_38120# VCO3_selection_0.NAND_3in_7.y 0.07156f
C1766 010 000 0.33288f
C1767 VCO4_selection_0.XNOR_1._b VCO4_selection_0.XNOR_1._a 0.62619f
C1768 f2 110 0.01918f
C1769 VCO2_selection_0.NOR_2in_1.y a_33589_34670# 0.0123f
C1770 100 f2 0.01479f
C1771 010 vp 2.12552f
C1772 a_32090_25172# 3bit_to_8_outs_0.inverter_6.in 0.08164f
C1773 vp VCO4_5_sel 0.39133f
C1774 111 f1_n 0.02632f
C1775 111 VCO2_selection_0.inverter_3.in 0.54768f
C1776 3bit_to_8_outs_0.NAND_3in_2.y m2_31033_27145# 0.21959f
C1777 001 VCO5_selection_0.inverter_0.in 0.5054f
C1778 101 f3 0.01126f
C1779 a_31060_43990# a_31276_43990# 0.02909f
C1780 VCO3_selection_0.NAND_3in_6.c VCO3_selection_0.NAND_3in_6.b 1.57365f
C1781 a_31410_25172# 3bit_to_8_outs_0.NAND_3in_3.y 0.07156f
C1782 000 m2_30981_44547# 0.0106f
C1783 VCO2_selection_0.XNOR_0._a VCO2_selection_0.inverter_6.out 0.02709f
C1784 VCO2_selection_0.NAND_4in_0.d VCO2_selection_0.NAND_3in_5.c 0.03204f
C1785 VCO3_selection_0.XNOR_1.y vp 0.61936f
C1786 m2_32841_30841# m2_32841_30923# 0.40984f
C1787 vp VCO2_selection_0.NAND_3in_7.y 0.58859f
C1788 VCO2_selection_0.NOR_2in_0.a VCO2_selection_0.NOR_2in_0.y 0.40942f
C1789 VCO3_selection_0.NAND_3in_5.y a_31788_42496# 0.08152f
C1790 VCO3_selection_0.NAND_3in_1.y VCO3_selection_0.NAND_3in_2.y 0.05926f
C1791 VCO4_selection_0.inverter_5.out 011 0.86775f
C1792 vp VCO2_selection_0.NAND_3in_4.y 0.62924f
C1793 m2_31493_40623# after_000011 0.01291f
C1794 after_000011_n VCO5_selection_0.inverter_1.in 0.87189f
C1795 100 110 1.73645f
C1796 a_33373_34670# a_33589_34670# 0.02909f
C1797 VCO3_5_sel a_33561_40066# 0.07132f
C1798 a_32564_39006# VCO3_selection_0.NAND_3in_7.c 0.11436f
C1799 VCO3_selection_0.XNOR_1._a VCO3_selection_0.XNOR_1.y 1.03871f
C1800 100 VCO2_selection_0.inverter_1.in 0.38145f
C1801 VCO4_selection_0.NAND_3in_1.y m2_32353_45771# 0.0115f
C1802 f5_n f3 0.01116f
C1803 f3 011 0.01143f
C1804 VCO3_selection_0.inverter_12.out VCO3_selection_0.NAND_3in_8.y 0.66967f
C1805 after_000011 after_001111 41.994f
C1806 100 a_31407_32240# 0.01155f
C1807 f0 VCO5_selection_0.inverter_2.in 0.38555f
C1808 f0 a_32564_39006# 0.02763f
C1809 after_000111 after_001111 0.60084f
C1810 VCO4_selection_0.NAND_3in_0.y VCO4_selection_0.inverter_2.in 0.06349f
C1811 VCO5_selection_0.inverter_0.out VCO5_selection_0.inverter_2.out 0.01675f
C1812 VCO5_selection_0.inverter_1.out VCO5_selection_0.inverter_0.in 0.61556f
C1813 c2 after_001111 0.01981f
C1814 a_31407_30284# a_31623_30284# 0.02909f
C1815 VCO2_selection_0.inverter_4.out VCO2_selection_0.inverter_6.out 0.6129f
C1816 3bit_to_8_outs_0.inverter_8.in 3bit_to_8_outs_0.inverter_10.in 0.2557f
C1817 after_000011_n VCO3_selection_0.NAND_3in_1.y 0.8288f
C1818 c2 3bit_to_8_outs_0.inverter_6.in 2.12239f
C1819 a_31740_46420# a_31956_46420# 0.02909f
C1820 010 VCO5_selection_0.NAND_2in_0.b 0.38186f
C1821 101 f2 0.01493f
C1822 m2_31939_44629# VCO4_selection_0.inverter_2.out 0.01342f
C1823 a_33278_37142# VCO3_selection_0.inverter_3.out 0.05115f
C1824 a_32563_32240# a_32779_32240# 0.02909f
C1825 VCO4_selection_0.NAND_3in_0.y f1 0.54621f
C1826 after_001111_n after_001111 0.73977f
C1827 vp 3bit_to_8_outs_0.inverter_1.in 0.62143f
C1828 VCO3_selection_0.XNOR_1.y a_32104_39564# 0.10845f
C1829 VCO2_selection_0.inverter_0.out a_33113_33692# 0.01383f
C1830 VCO3_selection_0.inverter_7.out VCO3_selection_0.NAND_3in_6.c 0.17956f
C1831 f1 f4 0.01993f
C1832 VCO3_selection_0.XNOR_1.y VCO3_selection_0.NAND_3in_6.a 0.02112f
C1833 f0 VCO_sel 0.01959f
C1834 3bit_to_8_outs_0.c2_n 3bit_to_8_outs_0.c0_n 2.00018f
C1835 VCO4_selection_0.inverter_3.out VCO4_selection_0.XNOR_0.y 0.04684f
C1836 VCO2_selection_0.NAND_4in_0.d a_31877_32240# 0.01287f
C1837 after_000111_n VCO2_selection_0.NAND_3in_3.c 0.02048f
C1838 VCO3_selection_0.inverter_11.out a_33484_43000# 0.05409f
C1839 VCO2_selection_0.NAND_3in_7.y VCO2_selection_0.XNOR_0._b 0.06611f
C1840 f5_n VCO3_selection_0.NAND_3in_3.y 0.09609f
C1841 vp VCO4_selection_0.NAND_3in_2.y 0.64555f
C1842 VCO5_selection_0.inverter_1.in VCO5_selection_0.XNOR_0._b 0.04875f
C1843 a_31407_32714# after_000111 0.01632f
C1844 a_32048_42022# VCO3_selection_0.NAND_2in_3.y 0.07562f
C1845 VCO2_selection_0.inverter_0.out m2_32496_33857# 0.22576f
C1846 VCO3_selection_0.NAND_3in_3.y 011 0.51438f
C1847 010 c0 0.03038f
C1848 f5_n f2 0.01528f
C1849 f5_n c1 0.02647f
C1850 a_33068_41518# VCO3_selection_0.NAND_3in_6.b 0.08051f
C1851 101 110 36.2694f
C1852 f2 011 0.01486f
C1853 f0 a_31321_28789# 0.04506f
C1854 f0 a_32399_31170# 0.02644f
C1855 100 101 37.0426f
C1856 after_000011_n VCO4_selection_0.NAND_3in_0.y 0.68359f
C1857 VCO5_11_sel gd 2.09427f
C1858 VCO2_5_sel gd 1.793f
C1859 VCO2_11_sel gd 3.605f
C1860 VCO3_11_sel gd 2.56264f
C1861 VCO3_5_sel gd 2.81074f
C1862 VCO4_5_sel gd 2.86087f
C1863 VCO4_11_sel gd 1.12158f
C1864 VCO_sel gd 1.06407f
C1865 vp gd 80.421f
C1866 m2_31925_23438# gd 0.0129f ; **FLOATING
C1867 m2_30761_24515# gd 0.01149f ; **FLOATING
C1868 m2_30761_26159# gd 0.01131f ; **FLOATING
C1869 m2_32934_28222# gd 0.03395f ; **FLOATING
C1870 m2_32458_28222# gd 0.01872f ; **FLOATING
C1871 m2_32477_28872# gd 0.06257f ; **FLOATING
C1872 m2_32217_28872# gd 0.01132f ; **FLOATING
C1873 m2_33238_30191# gd 0.04515f ; **FLOATING
C1874 m2_31328_30191# gd 0.06419f ; **FLOATING
C1875 m2_33323_30841# gd 0.01873f ; **FLOATING
C1876 m2_32841_30841# gd 0.0355f ; **FLOATING
C1877 m2_32841_30923# gd 0.01458f ; **FLOATING
C1878 m2_33176_31901# gd 0.01176f ; **FLOATING
C1879 m2_33176_32065# gd 0.01274f ; **FLOATING
C1880 m2_33034_34021# gd 0.02064f ; **FLOATING
C1881 m2_33034_34103# gd 0.04276f ; **FLOATING
C1882 m2_32768_34103# gd 0.01445f ; **FLOATING
C1883 m2_32496_34103# gd 0.01423f ; **FLOATING
C1884 m2_33294_34753# gd 0.09782f ; **FLOATING
C1885 m2_32824_34753# gd 0.03544f ; **FLOATING
C1886 m2_32558_34753# gd 0.01315f ; **FLOATING
C1887 m2_32286_34753# gd 0.01323f ; **FLOATING
C1888 m2_32824_34835# gd 0.01411f ; **FLOATING
C1889 m2_31328_34835# gd 0.01987f ; **FLOATING
C1890 m2_33199_36071# gd 0.04255f ; **FLOATING
C1891 m2_32933_36071# gd 0.01361f ; **FLOATING
C1892 m2_32661_36071# gd 0.01366f ; **FLOATING
C1893 m2_33199_36721# gd 0.04257f ; **FLOATING
C1894 m2_32933_36721# gd 0.01359f ; **FLOATING
C1895 m2_32661_36721# gd 0.01368f ; **FLOATING
C1896 m2_33199_36803# gd 0.02046f ; **FLOATING
C1897 m2_33397_38027# gd 0.08591f ; **FLOATING
C1898 m2_33006_38677# gd 0.04198f ; **FLOATING
C1899 m2_33006_39973# gd 0.01249f ; **FLOATING
C1900 m2_33407_40623# gd 0.0427f ; **FLOATING
C1901 m2_31493_40623# gd 0.02944f ; **FLOATING
C1902 m2_33407_40705# gd 0.02073f ; **FLOATING
C1903 m2_32989_41847# gd 0.02037f ; **FLOATING
C1904 m2_31493_41847# gd 0.02017f ; **FLOATING
C1905 m2_32989_41929# gd 0.04188f ; **FLOATING
C1906 m2_32723_41929# gd 0.01319f ; **FLOATING
C1907 m2_32451_41929# gd 0.0134f ; **FLOATING
C1908 m2_33405_42579# gd 0.04986f ; **FLOATING
C1909 m2_33405_42661# gd 0.02158f ; **FLOATING
C1910 m2_31673_43897# gd 0.01354f ; **FLOATING
C1911 m2_30981_43897# gd 0.07031f ; **FLOATING
C1912 m2_31673_44547# gd 0.01358f ; **FLOATING
C1913 m2_30981_44547# gd 0.06996f ; **FLOATING
C1914 m2_31939_44629# gd 0.01429f ; **FLOATING
C1915 m2_30981_45853# gd 0.06568f ; **FLOATING
C1916 m2_30981_46503# gd 0.04817f ; **FLOATING
C1917 m2_32494_47563# gd 0.01157f ; **FLOATING
C1918 m2_32494_47727# gd 0.01274f ; **FLOATING
C1919 m2_32494_47809# gd 0.02005f ; **FLOATING
C1920 m2_30711_49693# gd 0.02051f ; **FLOATING
C1921 m2_31181_49775# gd 0.06669f ; **FLOATING
C1922 m2_30711_49775# gd 0.03942f ; **FLOATING
C1923 a_31510_22377# gd 0.4441f
C1924 a_30990_22377# gd 0.01751f
C1925 a_31250_23355# gd 0.12992f
C1926 a_30774_23859# gd 1.00667f
C1927 a_32306_24854# gd 0.13013f
C1928 a_32090_24854# gd 0.10278f
C1929 a_31626_24854# gd 0.13012f
C1930 a_31410_24854# gd 0.10276f
C1931 a_32306_25172# gd 0.13013f
C1932 a_32090_25172# gd 0.10278f
C1933 a_31626_25172# gd 0.79281f
C1934 a_31410_25172# gd 0.76545f
C1935 a_32306_26498# gd 0.13013f
C1936 a_32090_26498# gd 0.10278f
C1937 a_31626_26498# gd 0.13012f
C1938 a_31410_26498# gd 0.10276f
C1939 a_32306_26816# gd 0.13013f
C1940 a_32090_26816# gd 0.10278f
C1941 a_31626_26816# gd 0.13012f
C1942 a_31410_26816# gd 0.10276f
C1943 a_33013_28315# gd 1.13753f
C1944 a_31519_28315# gd 0.10277f
C1945 a_31303_28315# gd 1.00417f
C1946 a_30783_28315# gd 0.13193f
C1947 a_32772_28789# gd 0.54441f
C1948 a_32556_28789# gd 0.57183f
C1949 a_31781_28789# gd 0.12355f
C1950 a_31321_28789# gd 0.12416f
C1951 VCO5_selection_0.inverter_2.out gd 0.18376f
C1952 a_31775_29201# gd 0.62266f
C1953 a_33317_29780# gd 0.53914f
C1954 a_32303_30284# gd 0.22741f
C1955 a_32087_30284# gd 2.50433f
C1956 a_31623_30284# gd 0.10278f
C1957 a_31407_30284# gd 0.13013f
C1958 a_32405_30758# gd 0.12355f
C1959 a_31945_30758# gd 0.49317f
C1960 VCO2_selection_0.inverter_4.out gd 0.22327f
C1961 a_32399_31170# gd 0.25732f
C1962 a_31939_31170# gd 3.90035f
C1963 a_32779_32240# gd 0.10277f
C1964 a_32563_32240# gd 0.13013f
C1965 a_32093_32240# gd 0.1005f
C1966 a_31877_32240# gd 0.12768f
C1967 a_31407_32240# gd 0.13195f
C1968 a_33260_32714# gd 0.8284f
C1969 a_33044_32714# gd 0.82674f
C1970 a_32828_32714# gd 0.12753f
C1971 a_32368_32714# gd 0.09939f
C1972 a_32152_32714# gd 0.13013f
C1973 a_31623_32714# gd 0.10275f
C1974 a_31407_32714# gd 0.13012f
C1975 a_33113_33692# gd 0.12883f
C1976 a_32093_34196# gd 1.90684f
C1977 VCO2_selection_0.inverter_1.in gd 0.20145f
C1978 a_31623_34196# gd 0.30423f
C1979 a_31407_34196# gd 2.44305f
C1980 a_33589_34670# gd 0.37925f
C1981 a_33373_34670# gd 0.13009f
C1982 a_31883_34670# gd 1.34151f
C1983 a_31407_34670# gd 0.13195f
C1984 VCO2_selection_0.NAND_3in_5.c gd 1.17964f
C1985 a_32903_35174# gd 1.56344f
C1986 VCO2_selection_0.NOR_2in_2.b gd 0.85512f
C1987 VCO3_selection_0.inverter_2.out gd 1.14651f
C1988 a_32258_36164# gd 1.33043f
C1989 a_31788_36164# gd 2.49956f
C1990 a_31572_36164# gd 2.52692f
C1991 a_32258_36638# gd 0.55615f
C1992 a_31788_36638# gd 0.10277f
C1993 a_31572_36638# gd 0.13013f
C1994 a_33278_37142# gd 0.12807f
C1995 VCO3_selection_0.inverter_4.in gd 0.42648f
C1996 VCO3_selection_0.NOR_2in_0.y gd 1.15722f
C1997 a_33692_38120# gd 0.25426f
C1998 VCO3_selection_0.NOR_2in_1.y gd 0.6925f
C1999 a_33476_38120# gd 0.13009f
C2000 a_32468_38120# gd 0.31292f
C2001 a_32252_38120# gd 0.52665f
C2002 VCO3_selection_0.NAND_3in_3.y gd 0.19783f
C2003 a_31788_38120# gd 0.10278f
C2004 a_31572_38120# gd 0.13013f
C2005 a_32570_38594# gd 1.47493f
C2006 a_32110_38594# gd 0.48779f
C2007 a_33085_39098# gd 0.81138f
C2008 VCO3_selection_0.inverter_0.out gd 0.54326f
C2009 a_32564_39564# gd 0.36662f
C2010 a_33561_40066# gd 0.25357f
C2011 a_33345_40066# gd 0.28099f
C2012 a_32570_40066# gd 0.36755f
C2013 a_32110_40066# gd 0.12416f
C2014 a_32468_40540# gd 1.50932f
C2015 a_32252_40540# gd 0.13013f
C2016 a_31788_40540# gd 0.10278f
C2017 a_31572_40540# gd 0.13013f
C2018 VCO3_selection_0.NAND_3in_6.c gd 0.62878f
C2019 a_33486_41044# gd 0.9158f
C2020 VCO3_selection_0.inverter_7.out gd 0.3509f
C2021 VCO3_selection_0.inverter_12.out gd 0.18131f
C2022 a_33068_41518# gd 0.40582f
C2023 VCO3_selection_0.NAND_3in_6.b gd 0.11956f
C2024 VCO3_selection_0.NOR_2in_4.a gd 0.28779f
C2025 a_32048_42022# gd 0.12968f
C2026 a_31572_42022# gd 0.13195f
C2027 a_32468_42496# gd 0.10277f
C2028 a_32252_42496# gd 0.13013f
C2029 a_31788_42496# gd 1.48386f
C2030 a_31572_42496# gd 0.13013f
C2031 a_33484_43000# gd 1.13304f
C2032 a_32018_43486# gd 1.63773f
C2033 a_32494_43990# gd 0.39089f
C2034 VCO4_selection_0.NAND_3in_0.y gd 0.12486f
C2035 a_31276_43990# gd 0.10277f
C2036 a_31060_43990# gd 0.13013f
C2037 a_31276_44464# gd 0.10277f
C2038 a_31060_44464# gd 0.13013f
C2039 a_32494_44968# gd 1.91239f
C2040 a_32018_44968# gd 1.35902f
C2041 a_31956_45946# gd 0.10277f
C2042 a_31740_45946# gd 0.13013f
C2043 a_31276_45946# gd 0.10278f
C2044 a_31060_45946# gd 0.13013f
C2045 a_31956_46420# gd 0.10277f
C2046 a_31740_46420# gd 0.13013f
C2047 a_31276_46420# gd 0.43387f
C2048 a_31060_46420# gd 0.13013f
C2049 VCO4_selection_0.inverter_4.in gd 1.52119f
C2050 a_32052_47400# gd 0.37245f
C2051 a_32058_47902# gd 0.36823f
C2052 VCO4_selection_0.inverter_5.in gd 0.36845f
C2053 a_31598_47902# gd 0.12416f
C2054 a_32058_48376# gd 0.37753f
C2055 a_31598_48376# gd 0.12416f
C2056 a_32052_48788# gd 0.39992f
C2057 a_31476_49868# gd 0.70395f
C2058 a_31260_49868# gd 0.3806f
C2059 a_30790_49868# gd 0.13195f
C2060 a_31266_50186# gd 0.33661f
C2061 a_30790_50186# gd 0.13195f
C2062 101 gd 1.6558f
.ends
