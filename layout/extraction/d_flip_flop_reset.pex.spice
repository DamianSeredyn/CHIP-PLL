* PEX produced on Wed Sep 23 06:31:52 PM CEST 2026 using /foss/tools/sak/sak-pex.sh with m=2 and s=1
* NGSPICE file created from d_flip_flop_reset.ext - technology: ihp-sg13cmos5l

.subckt d_flip_flop_reset VP GND d q reset clk
X0 a_607_n517# reset GND GND sg13_lv_nmos ad=57f pd=0.68u as=0.102p ps=1.28u w=0.3u l=0.13u
X1 a_579_n79# NAND_3in_nmosx3_3.y GND GND sg13_lv_nmos ad=57f pd=0.68u as=0.102p ps=1.28u w=0.3u l=0.13u
X2 NAND_3in_nmosx3_3.a NAND_3in_nmosx3_3.y VP VP sg13_lv_pmos ad=55.5f pd=0.74u as=0.1005p ps=1.34u w=0.15u l=0.13u
X3 NAND_3in_nmosx3_3.a NAND_3in_nmosx3_1.c a_579_n79# GND sg13_lv_nmos ad=0.102p pd=1.28u as=57f ps=0.68u w=0.3u l=0.13u
X4 VP d NAND_3in_nmosx3_1.c VP sg13_lv_pmos ad=55.5f pd=0.74u as=55.5f ps=0.74u w=0.15u l=0.13u
X5 VP clk NAND_3in_nmosx3_3.y VP sg13_lv_pmos ad=55.5f pd=0.74u as=55.5f ps=0.74u w=0.15u l=0.13u
X6 a_1423_n517# reset GND GND sg13_lv_nmos ad=57f pd=0.68u as=0.102p ps=1.28u w=0.3u l=0.13u
X7 VP NAND_3in_nmosx3_1.c NAND_3in_nmosx3_3.a VP sg13_lv_pmos ad=0.1005p pd=1.34u as=55.5f ps=0.74u w=0.15u l=0.13u
X8 a_709_n517# d a_607_n517# GND sg13_lv_nmos ad=57f pd=0.68u as=57f ps=0.68u w=0.3u l=0.13u
X9 VP NAND_3in_nmosx3_1.y d VP sg13_lv_pmos ad=55.5f pd=0.74u as=55.5f ps=0.74u w=0.15u l=0.13u
X10 a_n175_n517# clk a_n277_n517# GND sg13_lv_nmos ad=57f pd=0.68u as=57f ps=0.68u w=0.3u l=0.13u
X11 NAND_3in_nmosx3_1.y NAND_3in_nmosx3_1.c VP VP sg13_lv_pmos ad=55.5f pd=0.74u as=0.1005p ps=1.34u w=0.15u l=0.13u
X12 NAND_3in_nmosx3_3.y NAND_3in_nmosx3_3.a a_n175_n79# GND sg13_lv_nmos ad=0.102p pd=1.28u as=57f ps=0.68u w=0.3u l=0.13u
X13 NAND_3in_nmosx3_3.y reset VP VP sg13_lv_pmos ad=55.5f pd=0.74u as=0.1005p ps=1.34u w=0.15u l=0.13u
X14 a_1525_n517# NAND_3in_nmosx3_1.y a_1423_n517# GND sg13_lv_nmos ad=57f pd=0.68u as=57f ps=0.68u w=0.3u l=0.13u
X15 q d VP VP sg13_lv_pmos ad=55.5f pd=0.74u as=0.1005p ps=1.34u w=0.15u l=0.13u
X16 NAND_3in_nmosx3_1.c NAND_3in_nmosx3_1.y a_709_n517# GND sg13_lv_nmos ad=0.102p pd=1.28u as=57f ps=0.68u w=0.3u l=0.13u
X17 a_n277_n517# NAND_3in_nmosx3_1.c GND GND sg13_lv_nmos ad=57f pd=0.68u as=0.102p ps=1.28u w=0.3u l=0.13u
X18 NAND_3in_nmosx3_1.y NAND_3in_nmosx3_3.y VP VP sg13_lv_pmos ad=0.1005p pd=1.34u as=55.5f ps=0.74u w=0.15u l=0.13u
X19 NAND_3in_nmosx3_1.c NAND_3in_nmosx3_1.y VP VP sg13_lv_pmos ad=0.1005p pd=1.34u as=55.5f ps=0.74u w=0.15u l=0.13u
X20 NAND_3in_nmosx3_3.y NAND_3in_nmosx3_3.a VP VP sg13_lv_pmos ad=0.1005p pd=1.34u as=55.5f ps=0.74u w=0.15u l=0.13u
X21 d q a_1525_n517# GND sg13_lv_nmos ad=0.102p pd=1.28u as=57f ps=0.68u w=0.3u l=0.13u
X22 a_1327_n79# d GND GND sg13_lv_nmos ad=57f pd=0.68u as=0.102p ps=1.28u w=0.3u l=0.13u
X23 q NAND_3in_nmosx3_3.y a_1327_n79# GND sg13_lv_nmos ad=0.102p pd=1.28u as=57f ps=0.68u w=0.3u l=0.13u
X24 a_n175_n79# clk a_n277_n79# GND sg13_lv_nmos ad=57f pd=0.68u as=57f ps=0.68u w=0.3u l=0.13u
X25 d reset VP VP sg13_lv_pmos ad=55.5f pd=0.74u as=0.1005p ps=1.34u w=0.15u l=0.13u
X26 VP clk NAND_3in_nmosx3_1.y VP sg13_lv_pmos ad=55.5f pd=0.74u as=55.5f ps=0.74u w=0.15u l=0.13u
X27 d q VP VP sg13_lv_pmos ad=0.1005p pd=1.34u as=55.5f ps=0.74u w=0.15u l=0.13u
X28 a_n277_n79# reset GND GND sg13_lv_nmos ad=57f pd=0.68u as=0.102p ps=1.28u w=0.3u l=0.13u
X29 NAND_3in_nmosx3_1.y NAND_3in_nmosx3_3.y a_n175_n517# GND sg13_lv_nmos ad=0.102p pd=1.28u as=57f ps=0.68u w=0.3u l=0.13u
X30 VP NAND_3in_nmosx3_3.y q VP sg13_lv_pmos ad=0.1005p pd=1.34u as=55.5f ps=0.74u w=0.15u l=0.13u
X31 NAND_3in_nmosx3_1.c reset VP VP sg13_lv_pmos ad=55.5f pd=0.74u as=0.1005p ps=1.34u w=0.15u l=0.13u
C0 q a_1525_n517# 0.01218f
C1 NAND_3in_nmosx3_3.y NAND_3in_nmosx3_1.c 0.77349f
C2 d a_1423_n517# 0.0189f
C3 VP reset 0.29727f
C4 d NAND_3in_nmosx3_1.c 0.79415f
C5 VP NAND_3in_nmosx3_3.y 0.13784f
C6 a_579_n79# NAND_3in_nmosx3_3.a 0.09655f
C7 d VP 0.62614f
C8 NAND_3in_nmosx3_1.c clk 0.81347f
C9 a_1423_n517# a_1525_n517# 0.09425f
C10 a_n277_n79# a_n175_n79# 0.09425f
C11 VP clk 0.17671f
C12 NAND_3in_nmosx3_1.c VP 0.14562f
C13 q NAND_3in_nmosx3_1.y 0.5998f
C14 reset NAND_3in_nmosx3_3.a 0.14892f
C15 NAND_3in_nmosx3_3.y NAND_3in_nmosx3_3.a 1.02828f
C16 q a_1327_n79# 0.09596f
C17 d NAND_3in_nmosx3_3.a 0.04529f
C18 NAND_3in_nmosx3_3.a clk 0.58358f
C19 NAND_3in_nmosx3_3.y reset 0.8408f
C20 NAND_3in_nmosx3_1.y a_n175_n517# 0.09708f
C21 NAND_3in_nmosx3_1.c NAND_3in_nmosx3_1.y 1.00306f
C22 d reset 1.22359f
C23 VP NAND_3in_nmosx3_3.a 0.42716f
C24 d NAND_3in_nmosx3_3.y 0.95592f
C25 VP NAND_3in_nmosx3_1.y 0.80397f
C26 reset clk 1.18295f
C27 NAND_3in_nmosx3_3.y clk 0.78615f
C28 q VP 0.1246f
C29 d clk 0.01064f
C30 reset VP 0.14358f
C31 NAND_3in_nmosx3_1.c a_607_n517# 0.01043f
C32 NAND_3in_nmosx3_3.y VP 0.90504f
C33 d VP 0.19735f
C34 d a_1525_n517# 0.09484f
C35 NAND_3in_nmosx3_3.y a_n175_n79# 0.09708f
C36 VP clk 0.17442f
C37 q NAND_3in_nmosx3_3.a 0.06036f
C38 VP NAND_3in_nmosx3_1.c 0.66816f
C39 reset NAND_3in_nmosx3_1.y 1.69672f
C40 NAND_3in_nmosx3_3.y NAND_3in_nmosx3_1.y 0.68914f
C41 d NAND_3in_nmosx3_1.y 1.20107f
C42 q NAND_3in_nmosx3_3.y 0.11839f
C43 a_n277_n517# a_n175_n517# 0.09425f
C44 clk NAND_3in_nmosx3_1.y 0.2195f
C45 q d 1.24072f
C46 NAND_3in_nmosx3_1.c NAND_3in_nmosx3_3.a 0.4246f
C47 a_709_n517# a_607_n517# 0.09425f
C48 NAND_3in_nmosx3_1.c reset 1.30346f
C49 NAND_3in_nmosx3_1.c a_709_n517# 0.09776f
C50 q VP 0.31798f
C51 VP GND 2.62113f
C52 VP GND 1.58473f
C53 a_1525_n517# GND 0.60719f
C54 a_1423_n517# GND 0.12441f
C55 a_709_n517# GND 0.04162f
C56 a_607_n517# GND 1.05048f
C57 a_n175_n517# GND 0.04162f
C58 a_n277_n517# GND 0.12441f
C59 a_1327_n79# GND 0.40749f
C60 a_579_n79# GND 1.50578f
C61 a_n175_n79# GND 0.81679f
C62 a_n277_n79# GND 0.12441f
C63 NAND_3in_nmosx3_1.c GND 0.31171f
.ends
