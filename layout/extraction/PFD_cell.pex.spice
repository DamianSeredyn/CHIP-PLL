* PEX produced on Sun May 17 08:04:44 PM CEST 2026 using /foss/tools/sak/sak-pex.sh with m=3 and s=1
* NGSPICE file created from PFD_cell.ext - technology: ihp-sg13g2

.subckt PFD_cell DOWN UP cVco cRef gnd vp
X0 3.t0 cVco.t11 vp.t2 vp.t0 sg13_lv_pmos ad=55.5f pd=0.74u as=55.5f ps=0.74u w=0.15u l=0.15u
X1 1.t5 gnd.t31 pre_down.t0 gnd.t42 sg13_lv_nmos ad=55.5f pd=0.74u as=55.5f ps=0.74u w=0.15u l=0.15u
X2 4.t1 cVco.t0 gnd.t22 gnd.t21 sg13_lv_nmos ad=55.5f pd=0.74u as=55.5f ps=0.74u w=0.15u l=0.15u
X3 vp.t7 cVco.t12 a_n1390_705.t1 vp.t0 sg13_lv_pmos ad=0.1005p pd=1.34u as=55.5f ps=0.74u w=0.15u l=0.13u
X4 vp.t8 cVco.t10 3.t0 vp.t0 sg13_lv_pmos ad=55.5f pd=0.74u as=55.5f ps=0.74u w=0.15u l=0.15u
X5 2.t0 gnd.t34 gnd.t36 gnd.t35 sg13_lv_nmos ad=57f pd=0.68u as=0.102p ps=1.28u w=0.3u l=0.15u
X6 DOWN.t1 a_2726_836.t3 gnd.t26 gnd.t25 sg13_lv_nmos ad=0.114p pd=0.98u as=0.204p ps=1.88u w=0.6u l=0.15u
X7 gnd.t3 pre_up.t3 a_3614_836.t1 gnd.t2 sg13_lv_nmos ad=0.102p pd=1.28u as=57f ps=0.68u w=0.3u l=0.15u
X8 3.t2 gnd.t31 gnd.t33 gnd.t32 sg13_lv_nmos ad=55.5f pd=0.74u as=0.1005p ps=1.34u w=0.15u l=0.15u
X9 1.t1 DOWN.t2 4.t3 gnd.t60 sg13_lv_nmos ad=57f pd=0.68u as=57f ps=0.68u w=0.3u l=0.15u
X10 gnd.t41 gnd.t34 2.t2 gnd.t40 sg13_lv_nmos ad=0.102p pd=1.28u as=57f ps=0.68u w=0.3u l=0.15u
X11 pre_up.t0 gnd.t31 3.t4 gnd.t44 sg13_lv_nmos ad=55.5f pd=0.74u as=55.5f ps=0.74u w=0.15u l=0.15u
X12 vp.t18 pre_up.t5 a_3614_836.t0 vp.t0 sg13_lv_pmos ad=0.102p pd=1.28u as=57f ps=0.68u w=0.3u l=0.15u
X13 a_n1162_705.t3 cRef.t7 gnd.t73 gnd.t74 sg13_lv_nmos ad=55.5f pd=0.74u as=55.5f ps=0.74u w=0.15u l=0.13u
X14 vp.t4 cRef.t9 1.t6 vp.t0 sg13_lv_pmos ad=55.5f pd=0.74u as=55.5f ps=0.74u w=0.15u l=0.15u
X15 pre_down.t0 cVco.t4 3.t2 gnd.t18 sg13_lv_nmos ad=55.5f pd=0.74u as=55.5f ps=0.74u w=0.15u l=0.15u
X16 vp.t3 cRef.t12 a_n1162_705.t1 vp.t0 sg13_lv_pmos ad=55.5f pd=0.74u as=55.5f ps=0.74u w=0.15u l=0.13u
X17 gnd.t73 cRef.t8 a_n1162_705.t2 gnd.t72 sg13_lv_nmos ad=55.5f pd=0.74u as=55.5f ps=0.74u w=0.15u l=0.13u
X18 3.t6 cRef.t6 4.t4 gnd.t76 sg13_lv_nmos ad=57f pd=0.68u as=57f ps=0.68u w=0.3u l=0.15u
X19 vp.t13 vp.t12 3.t1 vp.t0 sg13_lv_pmos ad=0.1005p pd=1.34u as=55.5f ps=0.74u w=0.15u l=0.15u
X20 gnd.t55 gnd.t53 4.t1 gnd.t54 sg13_lv_nmos ad=0.1005p pd=1.34u as=55.5f ps=0.74u w=0.15u l=0.15u
X21 pre_up.t1 a_n1162_705.t4 gnd.t30 gnd.t69 sg13_lv_nmos ad=57f pd=0.68u as=57f ps=0.68u w=0.3u l=0.15u
X22 vp.t6 cVco.t13 a_n1390_705.t0 vp.t0 sg13_lv_pmos ad=55.5f pd=0.74u as=55.5f ps=0.74u w=0.15u l=0.13u
X23 3.t4 cVco.t2 pre_down.t1 gnd.t20 sg13_lv_nmos ad=55.5f pd=0.74u as=55.5f ps=0.74u w=0.15u l=0.15u
X24 1.t2 vp.t10 vp.t11 vp.t0 sg13_lv_pmos ad=55.5f pd=0.74u as=0.1005p ps=1.34u w=0.15u l=0.15u
X25 2.t4 cRef.t1 gnd.t9 gnd.t81 sg13_lv_nmos ad=55.5f pd=0.74u as=55.5f ps=0.74u w=0.15u l=0.15u
X26 gnd.t58 a_n1162_705.t4 pre_up.t1 gnd.t70 sg13_lv_nmos ad=57f pd=0.68u as=57f ps=0.68u w=0.3u l=0.15u
X27 1.t0 cVco.t6 2.t0 gnd.t16 sg13_lv_nmos ad=57f pd=0.68u as=57f ps=0.68u w=0.3u l=0.15u
X28 a_3614_836.t1 pre_up.t4 gnd.t1 gnd.t0 sg13_lv_nmos ad=57f pd=0.68u as=0.102p ps=1.28u w=0.3u l=0.15u
X29 a_n1162_705.t2 cRef.t8 gnd.t13 gnd.t71 sg13_lv_nmos ad=55.5f pd=0.74u as=55.5f ps=0.74u w=0.15u l=0.13u
X30 4.t3 gnd.t34 4.t3 gnd.t38 sg13_lv_nmos ad=57f pd=0.68u as=0 ps=0 w=0.3u l=0.15u
X31 2.t2 cRef.t5 3.t5 gnd.t77 sg13_lv_nmos ad=57f pd=0.68u as=57f ps=0.68u w=0.3u l=0.15u
X32 gnd.t68 pre_down.t3 a_2726_836.t1 gnd.t67 sg13_lv_nmos ad=0.102p pd=1.28u as=57f ps=0.68u w=0.3u l=0.15u
X33 vp.t22 cRef.t13 a_n1162_705.t0 vp.t0 sg13_lv_pmos ad=55.5f pd=0.74u as=55.5f ps=0.74u w=0.15u l=0.13u
X34 UP.t0 a_3614_836.t5 vp.t17 vp.t0 sg13_lv_pmos ad=0.114p pd=0.98u as=0.204p ps=1.88u w=0.6u l=0.15u
X35 a_2726_836.t1 pre_down.t4 gnd.t5 gnd.t4 sg13_lv_nmos ad=57f pd=0.68u as=0.102p ps=1.28u w=0.3u l=0.15u
X36 4.t0 gnd.t50 gnd.t52 gnd.t51 sg13_lv_nmos ad=55.5f pd=0.74u as=0.1005p ps=1.34u w=0.15u l=0.15u
X37 gnd.t9 cVco.t1 4.t0 gnd.t8 sg13_lv_nmos ad=55.5f pd=0.74u as=55.5f ps=0.74u w=0.15u l=0.15u
X38 DOWN.t0 a_2726_836.t5 vp.t14 vp.t0 sg13_lv_pmos ad=0.114p pd=0.98u as=0.204p ps=1.88u w=0.6u l=0.15u
X39 gnd.t22 cRef.t0 2.t4 gnd.t82 sg13_lv_nmos ad=55.5f pd=0.74u as=55.5f ps=0.74u w=0.15u l=0.15u
X40 1.t6 cRef.t10 vp.t8 vp.t0 sg13_lv_pmos ad=55.5f pd=0.74u as=55.5f ps=0.74u w=0.15u l=0.15u
X41 2.t3 DOWN.t3 1.t0 gnd.t59 sg13_lv_nmos ad=57f pd=0.68u as=57f ps=0.68u w=0.3u l=0.15u
X42 3.t3 gnd.t31 1.t3 gnd.t43 sg13_lv_nmos ad=55.5f pd=0.74u as=55.5f ps=0.74u w=0.15u l=0.15u
X43 3.t1 cVco.t9 vp.t4 vp.t0 sg13_lv_pmos ad=55.5f pd=0.74u as=55.5f ps=0.74u w=0.15u l=0.15u
X44 gnd.t49 gnd.t47 gnd.t28 gnd.t48 sg13_lv_nmos ad=0.102p pd=1.28u as=0 ps=0 w=0.3u l=0.15u
X45 vp.t19 a_3614_836.t4 UP.t0 vp.t0 sg13_lv_pmos ad=0.204p pd=1.88u as=0.114p ps=0.98u w=0.6u l=0.15u
X46 4.t3 UP.t3 3.t6 gnd.t23 sg13_lv_nmos ad=57f pd=0.68u as=57f ps=0.68u w=0.3u l=0.15u
X47 3.t5 UP.t2 2.t1 gnd.t24 sg13_lv_nmos ad=57f pd=0.68u as=57f ps=0.68u w=0.3u l=0.15u
X48 a_n1162_705.t1 cRef.t12 vp.t22 vp.t0 sg13_lv_pmos ad=55.5f pd=0.74u as=55.5f ps=0.74u w=0.15u l=0.13u
X49 a_3614_836.t0 pre_up.t6 vp.t16 vp.t0 sg13_lv_pmos ad=57f pd=0.68u as=0.102p ps=1.28u w=0.3u l=0.15u
X50 pre_down.t1 cVco.t3 3.t3 gnd.t19 sg13_lv_nmos ad=55.5f pd=0.74u as=55.5f ps=0.74u w=0.15u l=0.15u
X51 pre_down.t2 a_n1390_705.t4 gnd.t28 gnd.t27 sg13_lv_nmos ad=57f pd=0.68u as=57f ps=0.68u w=0.3u l=0.15u
X52 4.t4 gnd.t34 2.t3 gnd.t37 sg13_lv_nmos ad=57f pd=0.68u as=57f ps=0.68u w=0.3u l=0.15u
X53 a_n1390_705.t0 cVco.t13 vp.t5 vp.t0 sg13_lv_pmos ad=55.5f pd=0.74u as=0.1005p ps=1.34u w=0.15u l=0.13u
X54 vp.t2 cRef.t11 1.t2 vp.t0 sg13_lv_pmos ad=55.5f pd=0.74u as=55.5f ps=0.74u w=0.15u l=0.15u
X55 a_2726_836.t0 pre_down.t6 vp.t1 vp.t0 sg13_lv_pmos ad=57f pd=0.68u as=0.102p ps=1.28u w=0.3u l=0.15u
X56 gnd.t15 cVco.t7 a_n1390_705.t3 gnd.t14 sg13_lv_nmos ad=0.1005p pd=1.34u as=55.5f ps=0.74u w=0.15u l=0.13u
X57 gnd.t30 a_n1390_705.t4 pre_down.t2 gnd.t29 sg13_lv_nmos ad=57f pd=0.68u as=57f ps=0.68u w=0.3u l=0.15u
X58 gnd.t13 cVco.t8 a_n1390_705.t2 gnd.t12 sg13_lv_nmos ad=55.5f pd=0.74u as=55.5f ps=0.74u w=0.15u l=0.13u
X59 1.t3 cRef.t3 pre_up.t2 gnd.t79 sg13_lv_nmos ad=55.5f pd=0.74u as=55.5f ps=0.74u w=0.15u l=0.15u
X60 a_n1390_705.t1 cVco.t12 vp.t3 vp.t0 sg13_lv_pmos ad=55.5f pd=0.74u as=55.5f ps=0.74u w=0.15u l=0.13u
X61 gnd.t46 gnd.t31 1.t4 gnd.t45 sg13_lv_nmos ad=0.1005p pd=1.34u as=55.5f ps=0.74u w=0.15u l=0.15u
X62 gnd.t66 a_2726_836.t2 DOWN.t1 gnd.t65 sg13_lv_nmos ad=0.204p pd=1.88u as=0.114p ps=0.98u w=0.6u l=0.15u
X63 gnd.t62 a_3614_836.t2 UP.t1 gnd.t61 sg13_lv_nmos ad=0.204p pd=1.88u as=0.114p ps=0.98u w=0.6u l=0.15u
X64 a_n1162_705.t0 cRef.t13 vp.t6 vp.t0 sg13_lv_pmos ad=55.5f pd=0.74u as=55.5f ps=0.74u w=0.15u l=0.13u
X65 a_n1390_705.t3 cVco.t7 gnd.t7 gnd.t6 sg13_lv_nmos ad=55.5f pd=0.74u as=55.5f ps=0.74u w=0.15u l=0.13u
X66 gnd.t58 gnd.t56 gnd.t58 gnd.t57 sg13_lv_nmos ad=57f pd=0.68u as=0 ps=0 w=0.3u l=0.15u
X67 4.t2 cVco.t5 1.t1 gnd.t17 sg13_lv_nmos ad=57f pd=0.68u as=57f ps=0.68u w=0.3u l=0.15u
X68 2.t1 gnd.t34 4.t2 gnd.t39 sg13_lv_nmos ad=57f pd=0.68u as=57f ps=0.68u w=0.3u l=0.15u
X69 vp.t15 a_2726_836.t4 DOWN.t0 vp.t0 sg13_lv_pmos ad=0.204p pd=1.88u as=0.114p ps=0.98u w=0.6u l=0.15u
X70 a_n1390_705.t2 cVco.t8 gnd.t11 gnd.t10 sg13_lv_nmos ad=55.5f pd=0.74u as=0.1005p ps=1.34u w=0.15u l=0.13u
X71 pre_up.t2 cRef.t4 1.t5 gnd.t78 sg13_lv_nmos ad=55.5f pd=0.74u as=55.5f ps=0.74u w=0.15u l=0.15u
X72 vp.t9 pre_down.t5 a_2726_836.t0 vp.t0 sg13_lv_pmos ad=0.102p pd=1.28u as=57f ps=0.68u w=0.3u l=0.15u
X73 1.t4 cRef.t2 pre_up.t0 gnd.t80 sg13_lv_nmos ad=55.5f pd=0.74u as=55.5f ps=0.74u w=0.15u l=0.15u
X74 gnd.t7 cRef.t7 a_n1162_705.t3 gnd.t75 sg13_lv_nmos ad=55.5f pd=0.74u as=55.5f ps=0.74u w=0.15u l=0.13u
X75 UP.t1 a_3614_836.t3 gnd.t64 gnd.t63 sg13_lv_nmos ad=0.114p pd=0.98u as=0.204p ps=1.88u w=0.6u l=0.15u
R0 UP.n1 UP.t0 27.3291
R1 UP.n1 UP.t1 26.6559
R2 UP.n0 UP.t3 13.8556
R3 UP.n0 UP.t2 12.9062
R4 UP.n2 UP.n0 7.3925
R5 UP.n2 UP.n1 4.6105
R6 UP UP.n2 0.4955
R7 DOWN.n1 DOWN.t0 27.5271
R8 DOWN.n1 DOWN.t1 26.4579
R9 DOWN.n0 DOWN.t3 13.5517
R10 DOWN.n0 DOWN.t2 12.5864
R11 DOWN.n2 DOWN.n0 6.1297
R12 DOWN.n2 DOWN.n1 4.6105
R13 DOWN DOWN.n2 2.4535
R14 cRef.n8 cRef.t5 15.068
R15 cRef.n8 cRef.t6 13.4603
R16 cRef.n1 cRef.t2 13.4369
R17 cRef.n3 cRef.n1 13.1243
R18 cRef.n10 cRef.t8 12.5186
R19 cRef.n6 cRef.t13 12.5184
R20 cRef.n4 cRef.t9 12.3574
R21 cRef.n4 cRef.t10 12.0934
R22 cRef.n5 cRef.t11 12.0934
R23 cRef.n10 cRef.t7 12.017
R24 cRef.n6 cRef.t12 12.0168
R25 cRef.n0 cRef.t4 7.68601
R26 cRef.n2 cRef.t1 7.6859
R27 cRef.n0 cRef.t3 7.67554
R28 cRef.n2 cRef.t0 7.67542
R29 cRef cRef.n11 6.4442
R30 cRef.n9 cRef.n7 5.8425
R31 cRef.n11 cRef.n10 5.6357
R32 cRef.n9 cRef.n8 5.5961
R33 cRef.n3 cRef.n2 4.5005
R34 cRef.n1 cRef.n0 3.0005
R35 cRef.n11 cRef.n9 1.9717
R36 cRef.n7 cRef.n6 1.1445
R37 cRef.n5 cRef.n4 0.7749
R38 cRef.n7 cRef.n5 0.7397
R39 cRef cRef.n3 0.625667
R40 cVco.n8 cVco.t5 15.1154
R41 cVco.n6 cVco.t13 13.7764
R42 cVco.n10 cVco.t8 13.7033
R43 cVco.n5 cVco.t9 13.3435
R44 cVco.n8 cVco.t6 13.1647
R45 cVco.n3 cVco.t1 12.319
R46 cVco.n2 cVco.t0 12.319
R47 cVco.n6 cVco.t12 12.2628
R48 cVco.n10 cVco.t7 12.1985
R49 cVco.n2 cVco.n1 12.1786
R50 cVco.n1 cVco.t4 12.1334
R51 cVco.n0 cVco.t3 7.7793
R52 cVco.n0 cVco.t2 7.76883
R53 cVco.n4 cVco.t10 7.65296
R54 cVco.n4 cVco.t11 7.65119
R55 cVco.n9 cVco.n7 6.5993
R56 cVco cVco.n11 6.53293
R57 cVco.n9 cVco.n8 5.0373
R58 cVco.n11 cVco.n10 5.0109
R59 cVco.n5 cVco.n4 4.5005
R60 cVco.n1 cVco.n0 4.4349
R61 cVco.n11 cVco.n9 1.8925
R62 cVco.n7 cVco.n5 1.2105
R63 cVco.n3 cVco.n2 0.664167
R64 cVco.n7 cVco.n6 0.5461
R65 cVco cVco.n3 0.281
R66 vp.n10 vp.t4 31.6973
R67 vp.n12 vp.t8 31.6973
R68 vp.n14 vp.t2 31.6973
R69 vp.n23 vp.t7 31.6973
R70 vp.n28 vp.t6 31.6973
R71 vp.n25 vp.t3 31.6973
R72 vp.n27 vp.t22 31.6973
R73 vp.n29 vp.t5 31.6973
R74 vp.n35 vp.t1 17.9767
R75 vp.n37 vp.t9 17.9767
R76 vp.n42 vp.t16 17.9767
R77 vp.n43 vp.t18 17.9767
R78 vp.n31 vp.t19 17.9627
R79 vp.n39 vp.t14 17.8736
R80 vp.n40 vp.t15 17.8736
R81 vp.n32 vp.t17 17.8534
R82 vp.n7 vp.t13 17.0005
R83 vp.n15 vp.t11 17.0005
R84 vp.n47 vp.n46 17.0005
R85 vp.n8 vp.n7 14.6973
R86 vp.n16 vp.n15 14.6973
R87 vp.n7 vp.t12 9.30844
R88 vp.n15 vp.t10 7.72833
R89 vp.n30 vp.n29 4.58055
R90 vp.n28 vp.n21 4.5005
R91 vp.n23 vp.n22 4.5005
R92 vp.n17 vp.n16 4.5005
R93 vp.n12 vp.n11 4.5005
R94 vp.n8 vp.n1 4.5005
R95 vp.n10 vp.n9 4.5005
R96 vp.n14 vp.n13 4.5005
R97 vp.n25 vp.n24 4.5005
R98 vp.n27 vp.n26 4.5005
R99 vp.n45 vp.n36 2.80696
R100 vp.n45 vp.n38 2.80696
R101 vp.n45 vp.n34 2.80696
R102 vp.n45 vp.n44 2.80696
R103 vp.n45 vp.n33 2.80696
R104 vp.n46 vp.n5 2.80696
R105 vp.n46 vp.n3 2.80696
R106 vp.n46 vp.n2 2.80696
R107 vp.n46 vp.n20 2.80696
R108 vp.n45 vp.n41 2.08777
R109 vp.n46 vp.n4 2.08777
R110 vp.n46 vp.n6 2.08777
R111 vp.n46 vp.n19 2.08777
R112 vp.n45 vp.n31 1.85103
R113 vp.n46 vp.n30 1.66333
R114 vp.n46 vp.n18 1.65246
R115 vp vp.n0 0.935452
R116 vp.n35 vp.n0 0.561549
R117 vp.n46 vp.t0 0.247877
R118 vp.n45 vp.n0 0.210867
R119 vp.t0 vp.n45 0.184296
R120 vp.n22 vp.n18 0.167359
R121 vp.n10 vp.n8 0.148843
R122 vp.n12 vp.n10 0.148843
R123 vp.n14 vp.n12 0.148843
R124 vp.n16 vp.n14 0.148843
R125 vp.n25 vp.n23 0.143814
R126 vp.n27 vp.n25 0.143814
R127 vp.n28 vp.n27 0.143814
R128 vp.n29 vp.n28 0.143814
R129 vp.n18 vp.n17 0.139265
R130 vp.n30 vp.n21 0.130234
R131 vp.n33 vp.n32 0.124623
R132 vp.n40 vp.n34 0.123129
R133 vp.n24 vp.n2 0.123129
R134 vp.n39 vp.n38 0.120956
R135 vp.n9 vp.n4 0.116891
R136 vp.n11 vp.n5 0.115456
R137 vp.n22 vp.n19 0.113993
R138 vp.n44 vp.n43 0.113623
R139 vp.n13 vp.n6 0.113224
R140 vp.n17 vp.n3 0.111789
R141 vp.n37 vp.n36 0.109956
R142 vp.n21 vp.n20 0.109956
R143 vp.n32 vp.n31 0.106995
R144 vp.n13 vp.n3 0.106629
R145 vp.n42 vp.n34 0.106289
R146 vp.n11 vp.n6 0.104827
R147 vp.n9 vp.n5 0.102963
R148 vp.n4 vp.n1 0.10116
R149 vp.n26 vp.n20 0.101129
R150 vp.n41 vp.n39 0.0993266
R151 vp.n41 vp.n40 0.0967242
R152 vp.n24 vp.n19 0.0967242
R153 vp.n26 vp.n2 0.087956
R154 vp.n36 vp.n35 0.0864625
R155 vp.n44 vp.n42 0.0827958
R156 vp.n38 vp.n37 0.0791292
R157 vp.n43 vp.n33 0.0754625
R158 vp.n47 vp.n1 0.0564167
R159 vp vp.n47 0.0133333
R160 gnd.n91 gnd.t4 303.375
R161 gnd.n126 gnd.t35 293.478
R162 gnd.n88 gnd.n87 198.002
R163 gnd.t35 gnd.t16 144.023
R164 gnd.n77 gnd.t63 94.79
R165 gnd.n38 gnd.t25 94.79
R166 gnd.t40 gnd.n106 94.79
R167 gnd.n94 gnd.t44 89.6744
R168 gnd.t79 gnd.n99 89.6744
R169 gnd.n103 gnd.t27 89.6744
R170 gnd.t37 gnd.n117 89.6744
R171 gnd.n109 gnd.t24 86.957
R172 gnd.t32 gnd.n105 84.2396
R173 gnd.n119 gnd.t51 84.2396
R174 gnd.n15 gnd.t75 84.2396
R175 gnd.t82 gnd.n113 81.5222
R176 gnd.n20 gnd.t71 81.5222
R177 gnd.t2 gnd.n77 81.203
R178 gnd.n38 gnd.t67 81.203
R179 gnd.n105 gnd.t18 76.0875
R180 gnd.n112 gnd.t17 76.0875
R181 gnd.t57 gnd.n95 73.3701
R182 gnd.n20 gnd.t12 73.3701
R183 gnd.n93 gnd.t80 72.3974
R184 gnd.t20 gnd.n94 70.6527
R185 gnd.t74 gnd.n15 70.6527
R186 gnd.n126 gnd.t14 67.9353
R187 gnd.t78 gnd.n101 65.2179
R188 gnd.n115 gnd.t38 65.2179
R189 gnd.t69 gnd.t43 62.5005
R190 gnd.n14 gnd.t6 61.5279
R191 gnd.n87 gnd.t0 59.7831
R192 gnd.n98 gnd.t70 59.7831
R193 gnd.t45 gnd.n91 58.8105
R194 gnd.n18 gnd.t72 58.8105
R195 gnd.t39 gnd.n109 57.0657
R196 gnd.t81 gnd.n115 57.0657
R197 gnd.n111 gnd.t54 54.3483
R198 gnd.t60 gnd.t21 54.3483
R199 gnd.n117 gnd.t76 54.3483
R200 gnd.n85 gnd.t61 54.034
R201 gnd.n88 gnd.t65 53.9815
R202 gnd.t61 gnd.n75 53.3757
R203 gnd.t65 gnd.n36 53.3757
R204 gnd.t77 gnd.n107 53.3757
R205 gnd.n108 gnd.t77 53.3757
R206 gnd.n120 gnd.t59 50.6584
R207 gnd.n101 gnd.t29 48.9135
R208 gnd.t59 gnd.n119 48.9135
R209 gnd.n92 gnd.t45 47.9409
R210 gnd.t72 gnd.n17 47.9409
R211 gnd.t19 gnd.n96 46.1962
R212 gnd.n97 gnd.t19 46.1962
R213 gnd.n134 gnd.t6 45.4151
R214 gnd.n104 gnd.t48 45.2235
R215 gnd.t29 gnd.n100 43.4788
R216 gnd.t42 gnd.n103 40.7614
R217 gnd.t4 gnd.n90 39.7895
R218 gnd.t8 gnd.n116 39.7888
R219 gnd.n81 gnd.t0 39.7887
R220 gnd.t54 gnd.n110 38.044
R221 gnd.n110 gnd.t39 35.3266
R222 gnd.t80 gnd.n92 34.354
R223 gnd.t70 gnd.n97 32.6092
R224 gnd.n29 gnd.t7 31.642
R225 gnd.n23 gnd.t15 31.642
R226 gnd.n24 gnd.t11 31.642
R227 gnd.n26 gnd.t13 31.642
R228 gnd.n28 gnd.t73 31.642
R229 gnd.n144 gnd.t22 31.5749
R230 gnd.n143 gnd.t9 31.5749
R231 gnd.n45 gnd.t30 31.4436
R232 gnd.n17 gnd.t74 28.9192
R233 gnd.n102 gnd.t78 27.1744
R234 gnd.t38 gnd.n114 27.1744
R235 gnd.n19 gnd.t10 26.7512
R236 gnd.t12 gnd.n19 26.5095
R237 gnd.n90 gnd.t67 26.2018
R238 gnd.n81 gnd.t2 26.2018
R239 gnd.n113 gnd.t60 24.457
R240 gnd.n135 gnd.t14 24.457
R241 gnd.t18 gnd.n104 23.4844
R242 gnd.n95 gnd.t20 21.7396
R243 gnd.t43 gnd.n98 21.7396
R244 gnd.t23 gnd.t81 21.7396
R245 gnd.n116 gnd.t23 20.7677
R246 gnd.n96 gnd.t57 19.0222
R247 gnd.t71 gnd.n18 18.0496
R248 gnd.n50 gnd.t33 17.8464
R249 gnd.n40 gnd.t46 17.8233
R250 gnd.n73 gnd.t66 17.6089
R251 gnd.n72 gnd.t26 17.6089
R252 gnd.n84 gnd.t62 17.6089
R253 gnd.n82 gnd.t64 17.6089
R254 gnd.n70 gnd.t5 17.5524
R255 gnd.n39 gnd.t68 17.5058
R256 gnd.n79 gnd.t3 17.5058
R257 gnd.n78 gnd.t1 17.5058
R258 gnd.n51 gnd.t41 17.2601
R259 gnd.n5 gnd.t36 17.2601
R260 gnd.n2 gnd.t55 17.2205
R261 gnd.n4 gnd.t52 17.2067
R262 gnd.t58 gnd.n42 17.1629
R263 gnd.n44 gnd.t58 17.1629
R264 gnd.n47 gnd.t28 17.1629
R265 gnd.n49 gnd.t49 17.1629
R266 gnd.n136 gnd.n135 17.0005
R267 gnd.t17 gnd.n111 16.3048
R268 gnd.n106 gnd.t32 15.9856
R269 gnd.t16 gnd.n120 15.3329
R270 gnd.t75 gnd.n14 15.3322
R271 gnd.n58 gnd.n47 14.2812
R272 gnd.n57 gnd.n49 14.2812
R273 gnd.n65 gnd.n42 14.2777
R274 gnd.n64 gnd.n44 14.2777
R275 gnd.t48 gnd.t42 13.5875
R276 gnd.t21 gnd.n112 13.5875
R277 gnd.t63 gnd.n75 12.6148
R278 gnd.t25 gnd.n36 12.6148
R279 gnd.n107 gnd.t40 12.6148
R280 gnd.t24 gnd.n108 12.6148
R281 gnd.n114 gnd.t82 10.8701
R282 gnd.t44 gnd.n93 9.89744
R283 gnd.n133 gnd.n13 8.52304
R284 gnd.n135 gnd.n8 8.501
R285 gnd.n135 gnd.n9 8.501
R286 gnd.n127 gnd.n126 8.501
R287 gnd.n135 gnd.n11 8.501
R288 gnd.n126 gnd.n125 8.501
R289 gnd.n126 gnd.n7 8.501
R290 gnd.n87 gnd.n86 8.5005
R291 gnd.n133 gnd.n20 8.5005
R292 gnd.n133 gnd.n15 8.5005
R293 gnd.n131 gnd.n130 8.5005
R294 gnd.n129 gnd.n128 8.5005
R295 gnd.n34 gnd.n33 8.5005
R296 gnd.n124 gnd.n123 8.5005
R297 gnd.n122 gnd.n121 8.5005
R298 gnd.n10 gnd.n6 8.5005
R299 gnd.n137 gnd.n136 8.5005
R300 gnd.n119 gnd.n1 8.5005
R301 gnd.n118 gnd.n1 8.5005
R302 gnd.n117 gnd.n1 8.5005
R303 gnd.n112 gnd.n1 8.5005
R304 gnd.n111 gnd.n1 8.5005
R305 gnd.n110 gnd.n1 8.5005
R306 gnd.n109 gnd.n1 8.5005
R307 gnd.n105 gnd.n1 8.5005
R308 gnd.n94 gnd.n1 8.5005
R309 gnd.n69 gnd.n1 8.5005
R310 gnd.n95 gnd.n1 8.5005
R311 gnd.n41 gnd.n1 8.5005
R312 gnd.n96 gnd.n1 8.5005
R313 gnd.n97 gnd.n1 8.5005
R314 gnd.n98 gnd.n1 8.5005
R315 gnd.n99 gnd.n1 8.5005
R316 gnd.n100 gnd.n1 8.5005
R317 gnd.n101 gnd.n1 8.5005
R318 gnd.n102 gnd.n1 8.5005
R319 gnd.n103 gnd.n1 8.5005
R320 gnd.n113 gnd.n1 8.5005
R321 gnd.n114 gnd.n1 8.5005
R322 gnd.n115 gnd.n1 8.5005
R323 gnd.n99 gnd.t69 8.15267
R324 gnd.t51 gnd.n118 8.15267
R325 gnd.n2 gnd.t53 7.5589
R326 gnd.n4 gnd.t50 7.5589
R327 gnd.n43 gnd.t56 7.53301
R328 gnd.n48 gnd.t47 7.53301
R329 gnd.t31 gnd.n40 7.47647
R330 gnd.n51 gnd.t34 7.47438
R331 gnd.t34 gnd.n5 7.47438
R332 gnd.n50 gnd.t31 7.46996
R333 gnd.t76 gnd.t8 5.43528
R334 gnd.n135 gnd.n134 4.91444
R335 gnd.n24 gnd.n21 4.6148
R336 gnd.n28 gnd.n27 4.5005
R337 gnd.n26 gnd.n25 4.5005
R338 gnd.n30 gnd.n29 4.5005
R339 gnd.n23 gnd.n13 4.5005
R340 gnd.n143 gnd.n142 4.5005
R341 gnd.n59 gnd.n58 4.5005
R342 gnd.n61 gnd.n45 4.5005
R343 gnd.n64 gnd.n63 4.5005
R344 gnd.n66 gnd.n65 4.5005
R345 gnd.n57 gnd.n56 4.5005
R346 gnd.n145 gnd.n144 4.5005
R347 gnd.n89 gnd.n35 4.25187
R348 gnd.n126 gnd.n12 4.251
R349 gnd.n133 gnd.n132 4.2357
R350 gnd.n89 gnd.n71 4.23566
R351 gnd.n133 gnd.n31 4.23547
R352 gnd.n46 gnd.n1 4.23547
R353 gnd.n148 gnd.n1 4.23547
R354 gnd.n52 gnd.n51 3.04791
R355 gnd.n138 gnd.n5 3.04791
R356 gnd.n54 gnd.n50 3.00855
R357 gnd.n68 gnd.n40 2.98549
R358 gnd.n85 gnd.n84 2.91432
R359 gnd.n86 gnd.n80 2.80711
R360 gnd.n86 gnd.n83 2.80696
R361 gnd.n89 gnd.n74 2.80696
R362 gnd.n133 gnd.n16 2.80696
R363 gnd.n133 gnd.n22 2.80696
R364 gnd.n141 gnd.n1 2.80696
R365 gnd.n62 gnd.n1 2.80696
R366 gnd.n60 gnd.n1 2.80696
R367 gnd.n55 gnd.n1 2.80696
R368 gnd.n53 gnd.n1 2.80696
R369 gnd.n1 gnd.n0 2.80696
R370 gnd.n3 gnd.n1 2.80696
R371 gnd.n139 gnd.n1 2.80691
R372 gnd.n100 gnd.t79 2.71789
R373 gnd.t27 gnd.n102 2.71789
R374 gnd.n118 gnd.t37 2.71789
R375 gnd.n86 gnd.n76 2.08777
R376 gnd.n89 gnd.n37 2.08777
R377 gnd.n146 gnd.n1 2.08777
R378 gnd.n133 gnd.n21 2.08773
R379 gnd.n67 gnd.n1 1.14739
R380 gnd.n70 gnd.n69 0.998804
R381 gnd.n140 gnd.n4 0.856437
R382 gnd.n147 gnd.n2 0.842688
R383 gnd.n90 gnd.n89 0.661721
R384 gnd.n120 gnd.n1 0.661721
R385 gnd.n116 gnd.n1 0.661721
R386 gnd.n86 gnd.n81 0.661473
R387 gnd.n86 gnd.n75 0.661473
R388 gnd.n89 gnd.n36 0.661473
R389 gnd.n133 gnd.n18 0.661473
R390 gnd.n133 gnd.n17 0.661473
R391 gnd.n133 gnd.n14 0.661473
R392 gnd.n108 gnd.n1 0.661473
R393 gnd.n107 gnd.n1 0.661473
R394 gnd.n93 gnd.n1 0.661473
R395 gnd.n92 gnd.n1 0.661473
R396 gnd.n91 gnd.n1 0.661473
R397 gnd.n104 gnd.n1 0.661473
R398 gnd.n134 gnd.n133 0.453347
R399 gnd.n133 gnd.n19 0.349794
R400 gnd.n139 gnd.n138 0.215375
R401 gnd.n68 gnd.n67 0.204616
R402 gnd.n67 gnd.n66 0.185866
R403 gnd.n138 gnd.n137 0.18475
R404 gnd.n144 gnd.n143 0.148843
R405 gnd.n29 gnd.n23 0.143814
R406 gnd.n29 gnd.n28 0.143814
R407 gnd.n28 gnd.n26 0.143814
R408 gnd.n26 gnd.n24 0.143814
R409 gnd.n44 gnd.n43 0.143238
R410 gnd.n49 gnd.n48 0.143238
R411 gnd.n43 gnd.n42 0.13931
R412 gnd.n48 gnd.n47 0.13931
R413 gnd.n58 gnd.n45 0.133757
R414 gnd.n64 gnd.n45 0.1325
R415 gnd.n78 gnd.n35 0.12877
R416 gnd.n145 gnd.n3 0.124963
R417 gnd.n80 gnd.n79 0.12459
R418 gnd.n147 gnd.n146 0.12316
R419 gnd.n25 gnd.n16 0.123129
R420 gnd.n141 gnd.n140 0.122789
R421 gnd.n74 gnd.n72 0.115796
R422 gnd.n83 gnd.n82 0.115796
R423 gnd.n52 gnd.n0 0.115796
R424 gnd.n60 gnd.n59 0.113623
R425 gnd.n55 gnd.n54 0.111789
R426 gnd.n30 gnd.n22 0.109956
R427 gnd gnd.n0 0.109039
R428 gnd.n62 gnd.n61 0.106289
R429 gnd.n72 gnd.n37 0.104058
R430 gnd.n82 gnd.n76 0.104058
R431 gnd.n56 gnd.n55 0.102963
R432 gnd.n27 gnd.n22 0.101129
R433 gnd.n25 gnd.n21 0.096904
R434 gnd.n39 gnd.n37 0.09566
R435 gnd.n79 gnd.n76 0.09566
R436 gnd.n142 gnd.n141 0.0956292
R437 gnd.n132 gnd.n131 0.0953079
R438 gnd.n146 gnd.n145 0.0948909
R439 gnd.n71 gnd.n39 0.0938426
R440 gnd.n142 gnd.n3 0.093456
R441 gnd.n63 gnd.n62 0.0882959
R442 gnd.n27 gnd.n16 0.087956
R443 gnd.n61 gnd.n60 0.0827958
R444 gnd.n74 gnd.n73 0.0806227
R445 gnd.n84 gnd.n83 0.0806227
R446 gnd.n54 gnd.n53 0.0772959
R447 gnd.n53 gnd.n52 0.0732893
R448 gnd.n80 gnd.n78 0.0718311
R449 gnd.n32 gnd.n31 0.0705528
R450 gnd.n65 gnd.n64 0.0671286
R451 gnd.n58 gnd.n57 0.0671286
R452 gnd.n73 gnd.n35 0.0664419
R453 gnd.n140 gnd.n139 0.0663661
R454 gnd.n148 gnd.n147 0.0659695
R455 gnd.n132 gnd.n32 0.0633784
R456 gnd.n131 gnd.n129 0.0628333
R457 gnd.n129 gnd.n33 0.0628333
R458 gnd.n123 gnd.n33 0.0628333
R459 gnd.n123 gnd.n122 0.0628333
R460 gnd.n122 gnd.n6 0.0628333
R461 gnd.n137 gnd.n6 0.0628333
R462 gnd.n66 gnd.n41 0.0600833
R463 gnd.n56 gnd.n46 0.0549695
R464 gnd.n89 gnd.n88 0.0526709
R465 gnd gnd.n148 0.0485528
R466 gnd.n31 gnd.n30 0.0476361
R467 gnd.n71 gnd.n70 0.0473445
R468 gnd.n59 gnd.n46 0.0439695
R469 gnd.n69 gnd.n68 0.0435833
R470 gnd.n63 gnd.n41 0.0380833
R471 gnd.n32 gnd.n13 0.00861475
R472 gnd.n86 gnd.n77 0.00504252
R473 gnd.n89 gnd.n38 0.00504252
R474 gnd.n106 gnd.n1 0.00504252
R475 gnd.n130 gnd.n12 0.00175
R476 gnd.n133 gnd.n12 0.00124998
R477 gnd.n86 gnd.n85 0.00116605
R478 gnd.n130 gnd.n8 0.001
R479 gnd.n127 gnd.n34 0.001
R480 gnd.n34 gnd.n9 0.001
R481 gnd.n125 gnd.n121 0.001
R482 gnd.n121 gnd.n11 0.001
R483 gnd.n136 gnd.n7 0.001
R484 gnd.n128 gnd.n8 0.001
R485 gnd.n128 gnd.n127 0.001
R486 gnd.n124 gnd.n9 0.001
R487 gnd.n125 gnd.n124 0.001
R488 gnd.n11 gnd.n10 0.001
R489 gnd.n10 gnd.n7 0.001
R490 4.t1 4.n0 21.8846
R491 4 4.n0 0.846528
R492 4 4.n2 0.593528
R493 4.n2 4.n3 8.89047
R494 4.n3 4.t4 17.6419
R495 4.n3 4.t3 17.6669
R496 4.n2 4.t0 21.8846
R497 4.n0 4.n1 8.87287
R498 4.n1 4.t3 17.6217
R499 4.n1 4.t2 17.6427
R500 2.t4 2 26.9819
R501 2 2.n2 4.5005
R502 2.n2 2.n1 0.623833
R503 2.n2 2.n0 0.7375
R504 2.n1 2.t0 22.4872
R505 2.n1 2.t3 22.1117
R506 2.n0 2.t1 22.1117
R507 2.n0 2.t2 22.4872
R508 pre_up.n4 pre_up.t0 31.8637
R509 pre_up.n0 pre_up.t2 32.1585
R510 pre_up pre_up.n0 0.3833
R511 pre_up pre_up.n4 0.4097
R512 pre_up.n4 pre_up.n3 29.0873
R513 pre_up.n3 pre_up.n2 0.131452
R514 pre_up.n3 pre_up.n1 0.147167
R515 pre_up.n2 pre_up.t4 8.7238
R516 pre_up.n2 pre_up.t6 8.20817
R517 pre_up.n1 pre_up.t3 8.7238
R518 pre_up.n1 pre_up.t5 8.20817
R519 pre_up.n0 pre_up.t1 22.2011
R520 pre_down.n0 pre_down.t0 31.9246
R521 pre_down pre_down.n0 0.2953
R522 pre_down pre_down.n1 0.5461
R523 pre_down.n1 pre_down.n4 17.5045
R524 pre_down.n4 pre_down.n3 0.13669
R525 pre_down.n4 pre_down.n2 0.141929
R526 pre_down.n3 pre_down.t4 8.7238
R527 pre_down.n3 pre_down.t6 8.20817
R528 pre_down.n2 pre_down.t3 8.7238
R529 pre_down.n2 pre_down.t5 8.20817
R530 pre_down.n1 pre_down.t1 31.4714
R531 pre_down.n0 pre_down.t2 22.6686
R532 a_3614_836.t0 a_3614_836.n0 26.7345
R533 a_3614_836.n0 a_3614_836.n3 9.9421
R534 a_3614_836.n3 a_3614_836.n2 0.13669
R535 a_3614_836.n3 a_3614_836.n1 0.141929
R536 a_3614_836.n2 a_3614_836.t3 8.8888
R537 a_3614_836.n2 a_3614_836.t5 7.83692
R538 a_3614_836.n1 a_3614_836.t2 8.8888
R539 a_3614_836.n1 a_3614_836.t4 7.83692
R540 a_3614_836.n0 a_3614_836.t1 27.5397
R541 a_2726_836.t0 a_2726_836.n0 26.7345
R542 a_2726_836.n0 a_2726_836.n3 9.9421
R543 a_2726_836.n3 a_2726_836.n2 0.13669
R544 a_2726_836.n3 a_2726_836.n1 0.141929
R545 a_2726_836.n2 a_2726_836.t3 8.8888
R546 a_2726_836.n2 a_2726_836.t5 7.83692
R547 a_2726_836.n1 a_2726_836.t2 8.8888
R548 a_2726_836.n1 a_2726_836.t4 7.83692
R549 a_2726_836.n0 a_2726_836.t1 27.5397
R550 3.n4 3.t1 27.0829
R551 3.n3 3.n4 3.0005
R552 3.n4 3.t5 27.8037
R553 3.n3 3.n1 1.22674
R554 3.n1 3.n2 3.77604
R555 3.n2 3.t4 27.7553
R556 3.n2 3.t3 27.7465
R557 3.n1 3.t2 32.0038
R558 3 3.n3 0.235271
R559 3 3.n0 5.49197
R560 3.n0 3.t6 27.6718
R561 3.n0 3.t0 26.9268
R562 1.n4 1.t6 26.8292
R563 1.n3 1.n4 4.50198
R564 1.n4 1.t1 27.7963
R565 1.n3 1.n1 2.29698
R566 1.n1 1.n2 0.512188
R567 1.n2 1.t4 33.4672
R568 1.n2 1.t3 32.1886
R569 1.n1 1.t5 32.1886
R570 1 1.n3 0.784988
R571 1 1.n0 5.11714
R572 1.n0 1.t0 27.8301
R573 1.n0 1.t2 26.8849
R574 a_n1162_705.t1 a_n1162_705.n0 28.5129
R575 a_n1162_705.n0 a_n1162_705.n1 2.9573
R576 a_n1162_705.n1 a_n1162_705.n2 3.0365
R577 a_n1162_705.n2 a_n1162_705.t2 26.0948
R578 a_n1162_705.n2 a_n1162_705.t0 28.5129
R579 a_n1162_705.n1 a_n1162_705.t4 30.3388
R580 a_n1162_705.n0 a_n1162_705.t3 26.0948
R581 a_n1390_705.t1 a_n1390_705.n0 28.5129
R582 a_n1390_705.n0 a_n1390_705.n2 7.45667
R583 a_n1390_705.n2 a_n1390_705.n1 8.9489
R584 a_n1390_705.n2 a_n1390_705.t4 27.112
R585 a_n1390_705.n1 a_n1390_705.t2 26.0948
R586 a_n1390_705.n1 a_n1390_705.t0 28.5129
R587 a_n1390_705.n0 a_n1390_705.t3 26.0948
C0 DOWN UP 4.0335f
C1 DOWN pre_up 0.20954f
C2 2 3 0.08485f
C3 cVco UP 0.44239f
C4 1 4 0.14923f
C5 pre_up cVco 0.04416f
C6 UP pre_down 0.11868f
C7 DOWN 1 0.2712f
C8 pre_up pre_down 1.25666f
C9 2 cRef 0.25799f
C10 cVco 1 0.12261f
C11 1 pre_down 0.31372f
C12 DOWN vp 0.28572f
C13 3 4 0.14435f
C14 vp cVco 3.05571f
C15 DOWN 3 0.26577f
C16 pre_up UP 0.16301f
C17 vp pre_down 0.23629f
C18 3 cVco 0.12827f
C19 4 cRef 0.24288f
C20 1 UP 0.12726f
C21 3 pre_down 0.92057f
C22 DOWN cRef 0.21962f
C23 pre_up 1 1.2096f
C24 cVco cRef 8.68415f
C25 pre_down cRef 0.18807f
C26 vp UP 0.29931f
C27 pre_up vp 0.39078f
C28 2 4 1.34286f
C29 3 UP 0.37475f
C30 2 DOWN 0.05844f
C31 3 pre_up 0.30963f
C32 vp 1 1.80921f
C33 2 cVco 0.02802f
C34 UP cRef 0.57351f
C35 3 1 3.96373f
C36 pre_up cRef 0.15336f
C37 1 cRef 0.6681f
C38 3 vp 1.40691f
C39 DOWN 4 0.06611f
C40 cVco 4 0.0738f
C41 2 UP 0.01229f
C42 DOWN cVco 0.52146f
C43 vp cRef 1.59105f
C44 DOWN pre_down 0.16673f
C45 3 cRef 1.00905f
C46 2 1 0.084f
C47 cVco pre_down 0.49553f
C48 4 UP 0.02694f
C49 UP gnd 1.36523f
C50 DOWN gnd 1.74955f
C51 cRef gnd 3.78676f
C52 cVco gnd 5.73549f
C53 vp gnd 1.15603f
C54 4 gnd 1.69775f
C55 2 gnd 1.94952f
C56 pre_up gnd 1.74181f
C57 pre_down gnd 1.53664f
C58 3 gnd 1.21636f
C59 1 gnd 1.18192f
C60 a_n1390_705.t1 gnd 0.1341f
C61 a_n1390_705.t3 gnd 0.09731f
C62 a_n1390_705.n0 gnd 1.34171f
C63 a_n1390_705.t0 gnd 0.1341f
C64 a_n1390_705.t2 gnd 0.09731f
C65 a_n1390_705.n1 gnd 1.39392f
C66 a_n1390_705.t4 gnd 0.53442f
C67 a_n1390_705.n2 gnd 1.83057f
C68 a_n1162_705.t1 gnd 0.13394f
C69 a_n1162_705.t3 gnd 0.09719f
C70 a_n1162_705.n0 gnd 1.11669f
C71 a_n1162_705.t4 gnd 0.69278f
C72 a_n1162_705.n1 gnd 2.06386f
C73 a_n1162_705.t0 gnd 0.13394f
C74 a_n1162_705.t2 gnd 0.09719f
C75 a_n1162_705.n2 gnd 1.12406f
C76 1.t6 gnd 0.16756f
C77 1.t2 gnd 0.16871f
C78 1.t0 gnd 0.19497f
C79 1.n0 gnd 1.46775f
C80 1.n1 gnd 1.25426f
C81 1.t5 gnd 0.31429f
C82 1.n2 gnd 2.05643f
C83 1.t3 gnd 0.31429f
C84 1.t4 gnd 0.35269f
C85 1.n3 gnd 0.52435f
C86 1.t1 gnd 0.19496f
C87 1.n4 gnd 1.40749f
C88 3.t1 gnd 0.18403f
C89 3.n0 gnd 1.41022f
C90 3.t0 gnd 0.18032f
C91 3.t6 gnd 0.20257f
C92 3.n1 gnd 1.50816f
C93 3.t2 gnd 0.32111f
C94 3.t3 gnd 0.20269f
C95 3.t4 gnd 0.20294f
C96 3.n2 gnd 1.95138f
C97 3.n3 gnd 0.2757f
C98 3.n4 gnd 1.58258f
C99 3.t5 gnd 0.20679f
C100 a_2726_836.t0 gnd 0.10359f
C101 a_2726_836.t1 gnd 0.11504f
C102 a_2726_836.n0 gnd 0.95329f
C103 a_2726_836.t2 gnd 0.14565f
C104 a_2726_836.t4 gnd 0.13163f
C105 a_2726_836.n1 gnd 0.24364f
C106 a_2726_836.t3 gnd 0.14565f
C107 a_2726_836.t5 gnd 0.13163f
C108 a_2726_836.n2 gnd 0.24413f
C109 a_2726_836.n3 gnd 0.14635f
C110 a_3614_836.t0 gnd 0.06889f
C111 a_3614_836.t1 gnd 0.07651f
C112 a_3614_836.n0 gnd 0.63398f
C113 a_3614_836.t2 gnd 0.09686f
C114 a_3614_836.t4 gnd 0.08754f
C115 a_3614_836.n1 gnd 0.16203f
C116 a_3614_836.t3 gnd 0.09686f
C117 a_3614_836.t5 gnd 0.08754f
C118 a_3614_836.n2 gnd 0.16235f
C119 a_3614_836.n3 gnd 0.09733f
C120 pre_down.t0 gnd 0.20827f
C121 pre_down.t2 gnd 0.11732f
C122 pre_down.n0 gnd 0.81166f
C123 pre_down.n1 gnd 1.35042f
C124 pre_down.t1 gnd 0.20073f
C125 pre_down.t3 gnd 0.14891f
C126 pre_down.t5 gnd 0.13984f
C127 pre_down.n2 gnd 0.32299f
C128 pre_down.t4 gnd 0.14891f
C129 pre_down.t6 gnd 0.13984f
C130 pre_down.n3 gnd 0.32357f
C131 pre_down.n4 gnd 0.4296f
C132 pre_up.t0 gnd 0.19597f
C133 pre_up.t1 gnd 0.09343f
C134 pre_up.n0 gnd 0.72144f
C135 pre_up.t2 gnd 0.20069f
C136 pre_up.t3 gnd 0.13475f
C137 pre_up.t5 gnd 0.12655f
C138 pre_up.n1 gnd 0.29282f
C139 pre_up.t4 gnd 0.13475f
C140 pre_up.t6 gnd 0.12655f
C141 pre_up.n2 gnd 0.29335f
C142 pre_up.n3 gnd 0.73163f
C143 pre_up.n4 gnd 1.77183f
C144 2.t4 gnd 0.09618f
C145 2.t2 gnd 0.07434f
C146 2.t1 gnd 0.07106f
C147 2.n0 gnd 0.46758f
C148 2.t3 gnd 0.07106f
C149 2.n1 gnd 0.45195f
C150 2.t0 gnd 0.07434f
C151 2.n2 gnd 0.18711f
C152 4.t1 gnd 0.0535f
C153 4.n0 gnd 0.47701f
C154 4.t2 gnd 0.04336f
C155 4.n1 gnd 0.31096f
C156 4.t0 gnd 0.0535f
C157 4.n2 gnd 0.45048f
C158 4.t3 gnd 0.08673f
C159 4.t4 gnd 0.04326f
C160 4.n3 gnd 0.31243f
C161 vp.n0 gnd 0.17248f
C162 vp.n1 gnd 0.01905f
C163 vp.n2 gnd 0.01567f
C164 vp.n3 gnd 0.01672f
C165 vp.n4 gnd 0.01257f
C166 vp.n5 gnd 0.0167f
C167 vp.n6 gnd 0.0126f
C168 vp.t12 gnd 0.0167f
C169 vp.n7 gnd 0.04793f
C170 vp.n8 gnd 0.06014f
C171 vp.t4 gnd 0.02242f
C172 vp.n9 gnd 0.02722f
C173 vp.n10 gnd 0.09915f
C174 vp.t8 gnd 0.02242f
C175 vp.n11 gnd 0.02739f
C176 vp.n12 gnd 0.09915f
C177 vp.t2 gnd 0.02242f
C178 vp.n13 gnd 0.02727f
C179 vp.n14 gnd 0.09915f
C180 vp.t10 gnd 0.01421f
C181 vp.n15 gnd 0.05315f
C182 vp.n16 gnd 0.06014f
C183 vp.n17 gnd 0.03144f
C184 vp.n18 gnd 0.02041f
C185 vp.n19 gnd 0.0115f
C186 vp.n20 gnd 0.01581f
C187 vp.n21 gnd 0.02905f
C188 vp.t7 gnd 0.02179f
C189 vp.n22 gnd 0.03555f
C190 vp.n23 gnd 0.0774f
C191 vp.t3 gnd 0.02242f
C192 vp.n24 gnd 0.02769f
C193 vp.n25 gnd 0.09744f
C194 vp.t22 gnd 0.02242f
C195 vp.n26 gnd 0.02297f
C196 vp.n27 gnd 0.09744f
C197 vp.t6 gnd 0.02242f
C198 vp.n28 gnd 0.09744f
C199 vp.t5 gnd 0.02179f
C200 vp.n29 gnd 0.07789f
C201 vp.n30 gnd 0.03687f
C202 vp.t19 gnd 0.01309f
C203 vp.n31 gnd 0.05193f
C204 vp.t17 gnd 0.01286f
C205 vp.n32 gnd 0.0451f
C206 vp.n33 gnd 0.01413f
C207 vp.n34 gnd 0.01801f
C208 vp.n35 gnd 0.11155f
C209 vp.n36 gnd 0.01392f
C210 vp.n37 gnd 0.03921f
C211 vp.n38 gnd 0.01422f
C212 vp.t14 gnd 0.01287f
C213 vp.n39 gnd 0.04368f
C214 vp.t15 gnd 0.01287f
C215 vp.n40 gnd 0.04382f
C216 vp.n42 gnd 0.03915f
C217 vp.n43 gnd 0.03929f
C218 vp.n44 gnd 0.01386f
C219 vp.n45 gnd 0.76473f
C220 vp.t0 gnd 9.06335f
C221 vp.n46 gnd 0.57082f
C222 cVco.t2 gnd 0.22919f
C223 cVco.t3 gnd 0.22933f
C224 cVco.n0 gnd 0.40489f
C225 cVco.t4 gnd 0.29169f
C226 cVco.n1 gnd 1.11167f
C227 cVco.t0 gnd 0.23993f
C228 cVco.n2 gnd 1.27059f
C229 cVco.t1 gnd 0.23993f
C230 cVco.n3 gnd 0.36084f
C231 cVco.t9 gnd 0.27365f
C232 cVco.t10 gnd 0.17505f
C233 cVco.t11 gnd 0.17586f
C234 cVco.n4 gnd 0.46971f
C235 cVco.n5 gnd 0.64887f
C236 cVco.t13 gnd 0.36452f
C237 cVco.t12 gnd 0.29928f
C238 cVco.n6 gnd 0.93624f
C239 cVco.n7 gnd 0.43224f
C240 cVco.t5 gnd 0.48005f
C241 cVco.t6 gnd 0.40555f
C242 cVco.n8 gnd 1.27767f
C243 cVco.n9 gnd 0.98268f
C244 cVco.t8 gnd 0.39638f
C245 cVco.t7 gnd 0.33786f
C246 cVco.n10 gnd 1.17977f
C247 cVco.n11 gnd 0.82784f
C248 cRef.t2 gnd 0.31639f
C249 cRef.t3 gnd 0.23094f
C250 cRef.t4 gnd 0.23101f
C251 cRef.n0 gnd 0.20708f
C252 cRef.n1 gnd 1.46853f
C253 cRef.t0 gnd 0.16566f
C254 cRef.t1 gnd 0.16589f
C255 cRef.n2 gnd 0.16359f
C256 cRef.n3 gnd 1.26175f
C257 cRef.t11 gnd 0.21819f
C258 cRef.t10 gnd 0.21819f
C259 cRef.t9 gnd 0.22413f
C260 cRef.n4 gnd 0.58389f
C261 cRef.n5 gnd 0.39348f
C262 cRef.t13 gnd 0.31795f
C263 cRef.t12 gnd 0.29974f
C264 cRef.n6 gnd 0.87321f
C265 cRef.n7 gnd 0.46901f
C266 cRef.t5 gnd 0.48945f
C267 cRef.t6 gnd 0.43243f
C268 cRef.n8 gnd 1.41414f
C269 cRef.n9 gnd 0.81396f
C270 cRef.t8 gnd 0.3133f
C271 cRef.t7 gnd 0.29508f
C272 cRef.n10 gnd 0.9768f
C273 cRef.n11 gnd 0.88811f
C274 DOWN.t3 gnd 0.41302f
C275 DOWN.t2 gnd 0.38574f
C276 DOWN.n0 gnd 1.80361f
C277 DOWN.t0 gnd 0.29357f
C278 DOWN.t1 gnd 0.26788f
C279 DOWN.n1 gnd 1.40695f
C280 DOWN.n2 gnd 1.56143f
C281 UP.t3 gnd 0.45246f
C282 UP.t2 gnd 0.42138f
C283 UP.n0 gnd 2.16432f
C284 UP.t0 gnd 0.29718f
C285 UP.t1 gnd 0.28045f
C286 UP.n1 gnd 1.4548f
C287 UP.n2 gnd 1.48178f
.ends
