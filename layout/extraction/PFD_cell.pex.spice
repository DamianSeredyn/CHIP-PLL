* PEX produced on Fri May 29 10:43:20 PM CEST 2026 using /foss/tools/sak/sak-pex.sh with m=3 and s=1
* NGSPICE file created from PFD_cell.ext - technology: ihp-sg13g2

.subckt PFD_cell DOWN UP cVco cRef gnd vp
X0 3.t3 cVco.t11 vp.t8 vp.t0 sg13_lv_pmos ad=55.5f pd=0.74u as=55.5f ps=0.74u w=0.15u l=0.15u
X1 vp.t6 pre_down.t5 buf_in_down.t0 vp.t0 sg13_lv_pmos ad=0.1005p pd=1.34u as=55.5f ps=0.74u w=0.15u l=0.15u
X2 4.t1 cVco.t0 gnd.t19 gnd.t18 sg13_lv_nmos ad=55.5f pd=0.74u as=55.5f ps=0.74u w=0.15u l=0.15u
X3 vp.t12 cVco.t12 inv_out_down.t3 vp.t0 sg13_lv_pmos ad=0.1005p pd=1.34u as=55.5f ps=0.74u w=0.15u l=0.13u
X4 vp.t13 cVco.t10 3.t3 vp.t0 sg13_lv_pmos ad=55.5f pd=0.74u as=55.5f ps=0.74u w=0.15u l=0.15u
X5 1.t4 cRef.t6 pre_up.t1 gnd.t42 sg13_lv_nmos ad=57f pd=0.68u as=57f ps=0.68u w=0.3u l=0.15u
X6 2.t0 gnd.t64 gnd.t66 gnd.t65 sg13_lv_nmos ad=57f pd=0.68u as=0.102p ps=1.28u w=0.3u l=0.15u
X7 pre_down.t1 cVco.t8 3.t0 gnd.t13 sg13_lv_nmos ad=57f pd=0.68u as=57f ps=0.68u w=0.3u l=0.15u
X8 pre_down.t2 cVco.t7 3.t1 gnd.t14 sg13_lv_nmos ad=57f pd=0.68u as=57f ps=0.68u w=0.3u l=0.15u
X9 1.t1 DOWN.t2 2.t4 gnd.t55 sg13_lv_nmos ad=57f pd=0.68u as=57f ps=0.68u w=0.3u l=0.15u
X10 gnd.t74 gnd.t64 4.t2 gnd.t73 sg13_lv_nmos ad=0.102p pd=1.28u as=57f ps=0.68u w=0.3u l=0.15u
X11 inv_out_up.t1 cRef.t4 gnd.t45 gnd.t44 sg13_lv_nmos ad=55.5f pd=0.74u as=55.5f ps=0.74u w=0.15u l=0.13u
X12 vp.t7 cRef.t9 1.t6 vp.t0 sg13_lv_pmos ad=55.5f pd=0.74u as=55.5f ps=0.74u w=0.15u l=0.15u
X13 UP.t1 buf_in_up.t3 gnd.t31 gnd.t30 sg13_lv_nmos ad=57f pd=0.68u as=0.102p ps=1.28u w=0.3u l=0.15u
X14 vp.t9 cRef.t12 inv_out_up.t3 vp.t0 sg13_lv_pmos ad=55.5f pd=0.74u as=55.5f ps=0.74u w=0.15u l=0.13u
X15 gnd.t45 cRef.t5 inv_out_up.t0 gnd.t46 sg13_lv_nmos ad=55.5f pd=0.74u as=55.5f ps=0.74u w=0.15u l=0.13u
X16 3.t5 cRef.t3 4.t3 gnd.t48 sg13_lv_nmos ad=57f pd=0.68u as=57f ps=0.68u w=0.3u l=0.15u
X17 vp.t24 vp.t23 3.t4 vp.t0 sg13_lv_pmos ad=0.1005p pd=1.34u as=55.5f ps=0.74u w=0.15u l=0.15u
X18 DOWN.t1 buf_in_down.t3 gnd.t33 gnd.t32 sg13_lv_nmos ad=57f pd=0.68u as=0.102p ps=1.28u w=0.3u l=0.15u
X19 gnd.t72 gnd.t70 4.t1 gnd.t71 sg13_lv_nmos ad=0.1005p pd=1.34u as=55.5f ps=0.74u w=0.15u l=0.15u
X20 pre_up.t0 inv_out_up.t4 gnd.t7 gnd.t6 sg13_lv_nmos ad=57f pd=0.68u as=57f ps=0.68u w=0.3u l=0.15u
X21 vp.t11 cVco.t13 inv_out_down.t2 vp.t0 sg13_lv_pmos ad=55.5f pd=0.74u as=55.5f ps=0.74u w=0.15u l=0.13u
X22 vp.t1 pre_up.t5 buf_in_up.t0 vp.t0 sg13_lv_pmos ad=0.1005p pd=1.34u as=55.5f ps=0.74u w=0.15u l=0.15u
X23 1.t5 vp.t25 vp.t26 vp.t0 sg13_lv_pmos ad=55.5f pd=0.74u as=0.1005p ps=1.34u w=0.15u l=0.15u
X24 2.t2 cRef.t1 gnd.t29 gnd.t50 sg13_lv_nmos ad=55.5f pd=0.74u as=55.5f ps=0.74u w=0.15u l=0.15u
X25 gnd.t9 inv_out_up.t4 pre_up.t0 gnd.t8 sg13_lv_nmos ad=57f pd=0.68u as=57f ps=0.68u w=0.3u l=0.15u
X26 1.t0 cVco.t3 2.t0 gnd.t26 sg13_lv_nmos ad=57f pd=0.68u as=57f ps=0.68u w=0.3u l=0.15u
X27 3.t1 gnd.t56 1.t3 gnd.t60 sg13_lv_nmos ad=57f pd=0.68u as=57f ps=0.68u w=0.3u l=0.15u
X28 pre_up.t1 gnd.t56 3.t2 gnd.t61 sg13_lv_nmos ad=57f pd=0.68u as=57f ps=0.68u w=0.3u l=0.15u
X29 inv_out_up.t0 cRef.t5 gnd.t23 gnd.t43 sg13_lv_nmos ad=55.5f pd=0.74u as=55.5f ps=0.74u w=0.15u l=0.13u
X30 2.t4 gnd.t64 4.t5 gnd.t68 sg13_lv_nmos ad=57f pd=0.68u as=57f ps=0.68u w=0.3u l=0.15u
X31 4.t2 cRef.t2 3.t6 gnd.t49 sg13_lv_nmos ad=57f pd=0.68u as=57f ps=0.68u w=0.3u l=0.15u
X32 vp.t16 cRef.t13 inv_out_up.t2 vp.t0 sg13_lv_pmos ad=55.5f pd=0.74u as=55.5f ps=0.74u w=0.15u l=0.13u
X33 UP.t0 buf_in_up.t5 vp.t22 vp.t0 sg13_lv_pmos ad=57f pd=0.68u as=0.102p ps=1.28u w=0.3u l=0.15u
X34 3.t0 gnd.t56 gnd.t58 gnd.t57 sg13_lv_nmos ad=57f pd=0.68u as=0.102p ps=1.28u w=0.3u l=0.15u
X35 4.t0 gnd.t75 gnd.t77 gnd.t76 sg13_lv_nmos ad=55.5f pd=0.74u as=0.1005p ps=1.34u w=0.15u l=0.15u
X36 gnd.t29 cVco.t1 4.t0 gnd.t28 sg13_lv_nmos ad=55.5f pd=0.74u as=55.5f ps=0.74u w=0.15u l=0.15u
X37 DOWN.t0 buf_in_down.t5 vp.t14 vp.t0 sg13_lv_pmos ad=57f pd=0.68u as=0.102p ps=1.28u w=0.3u l=0.15u
X38 gnd.t19 cRef.t0 2.t2 gnd.t51 sg13_lv_nmos ad=55.5f pd=0.74u as=55.5f ps=0.74u w=0.15u l=0.15u
X39 1.t6 cRef.t10 vp.t13 vp.t0 sg13_lv_pmos ad=55.5f pd=0.74u as=55.5f ps=0.74u w=0.15u l=0.15u
X40 2.t3 DOWN.t3 1.t0 gnd.t54 sg13_lv_nmos ad=57f pd=0.68u as=57f ps=0.68u w=0.3u l=0.15u
X41 gnd.t1 pre_up.t3 buf_in_up.t1 gnd.t0 sg13_lv_nmos ad=0.1005p pd=1.34u as=55.5f ps=0.74u w=0.15u l=0.15u
X42 3.t4 cVco.t9 vp.t7 vp.t0 sg13_lv_pmos ad=55.5f pd=0.74u as=55.5f ps=0.74u w=0.15u l=0.15u
X43 buf_in_up.t0 pre_up.t6 vp.t2 vp.t0 sg13_lv_pmos ad=55.5f pd=0.74u as=0.1005p ps=1.34u w=0.15u l=0.15u
X44 gnd.t80 gnd.t78 gnd.t11 gnd.t79 sg13_lv_nmos ad=0.102p pd=1.28u as=0 ps=0 w=0.3u l=0.15u
X45 vp.t3 buf_in_up.t4 UP.t0 vp.t0 sg13_lv_pmos ad=0.102p pd=1.28u as=57f ps=0.68u w=0.3u l=0.15u
X46 1.t3 cRef.t7 pre_up.t2 gnd.t41 sg13_lv_nmos ad=57f pd=0.68u as=57f ps=0.68u w=0.3u l=0.15u
X47 4.t5 UP.t3 3.t5 gnd.t52 sg13_lv_nmos ad=57f pd=0.68u as=57f ps=0.68u w=0.3u l=0.15u
X48 3.t6 UP.t2 4.t4 gnd.t53 sg13_lv_nmos ad=57f pd=0.68u as=57f ps=0.68u w=0.3u l=0.15u
X49 inv_out_up.t3 cRef.t12 vp.t16 vp.t0 sg13_lv_pmos ad=55.5f pd=0.74u as=55.5f ps=0.74u w=0.15u l=0.13u
X50 pre_down.t0 inv_out_down.t4 gnd.t11 gnd.t10 sg13_lv_nmos ad=57f pd=0.68u as=57f ps=0.68u w=0.3u l=0.15u
X51 4.t3 gnd.t64 2.t3 gnd.t67 sg13_lv_nmos ad=57f pd=0.68u as=57f ps=0.68u w=0.3u l=0.15u
X52 inv_out_down.t2 cVco.t13 vp.t10 vp.t0 sg13_lv_pmos ad=55.5f pd=0.74u as=0.1005p ps=1.34u w=0.15u l=0.13u
X53 vp.t8 cRef.t11 1.t5 vp.t0 sg13_lv_pmos ad=55.5f pd=0.74u as=55.5f ps=0.74u w=0.15u l=0.15u
X54 gnd.t25 cVco.t4 inv_out_down.t1 gnd.t24 sg13_lv_nmos ad=0.1005p pd=1.34u as=55.5f ps=0.74u w=0.15u l=0.13u
X55 gnd.t7 inv_out_down.t4 pre_down.t0 gnd.t12 sg13_lv_nmos ad=57f pd=0.68u as=57f ps=0.68u w=0.3u l=0.15u
X56 buf_in_down.t1 pre_down.t4 gnd.t37 gnd.t36 sg13_lv_nmos ad=55.5f pd=0.74u as=0.1005p ps=1.34u w=0.15u l=0.15u
X57 gnd.t23 cVco.t5 inv_out_down.t0 gnd.t22 sg13_lv_nmos ad=55.5f pd=0.74u as=55.5f ps=0.74u w=0.15u l=0.13u
X58 buf_in_up.t1 pre_up.t4 gnd.t3 gnd.t2 sg13_lv_nmos ad=55.5f pd=0.74u as=0.1005p ps=1.34u w=0.15u l=0.15u
X59 inv_out_down.t3 cVco.t12 vp.t9 vp.t0 sg13_lv_pmos ad=55.5f pd=0.74u as=55.5f ps=0.74u w=0.15u l=0.13u
X60 inv_out_up.t2 cRef.t13 vp.t11 vp.t0 sg13_lv_pmos ad=55.5f pd=0.74u as=55.5f ps=0.74u w=0.15u l=0.13u
X61 inv_out_down.t1 cVco.t4 gnd.t17 gnd.t16 sg13_lv_nmos ad=55.5f pd=0.74u as=55.5f ps=0.74u w=0.15u l=0.13u
X62 gnd.t9 gnd.t81 gnd.t9 gnd.t82 sg13_lv_nmos ad=57f pd=0.68u as=0 ps=0 w=0.3u l=0.15u
X63 pre_up.t2 cRef.t8 1.t2 gnd.t40 sg13_lv_nmos ad=57f pd=0.68u as=57f ps=0.68u w=0.3u l=0.15u
X64 3.t2 cVco.t6 pre_down.t2 gnd.t15 sg13_lv_nmos ad=57f pd=0.68u as=57f ps=0.68u w=0.3u l=0.15u
X65 gnd.t63 gnd.t56 1.t4 gnd.t62 sg13_lv_nmos ad=0.102p pd=1.28u as=57f ps=0.68u w=0.3u l=0.15u
X66 2.t1 cVco.t2 1.t1 gnd.t27 sg13_lv_nmos ad=57f pd=0.68u as=57f ps=0.68u w=0.3u l=0.15u
X67 4.t4 gnd.t64 2.t1 gnd.t69 sg13_lv_nmos ad=57f pd=0.68u as=57f ps=0.68u w=0.3u l=0.15u
X68 gnd.t39 pre_down.t3 buf_in_down.t1 gnd.t38 sg13_lv_nmos ad=0.1005p pd=1.34u as=55.5f ps=0.74u w=0.15u l=0.15u
X69 buf_in_down.t0 pre_down.t6 vp.t5 vp.t0 sg13_lv_pmos ad=55.5f pd=0.74u as=0.1005p ps=1.34u w=0.15u l=0.15u
X70 vp.t4 buf_in_down.t4 DOWN.t0 vp.t0 sg13_lv_pmos ad=0.102p pd=1.28u as=57f ps=0.68u w=0.3u l=0.15u
X71 1.t2 gnd.t56 pre_down.t1 gnd.t59 sg13_lv_nmos ad=57f pd=0.68u as=57f ps=0.68u w=0.3u l=0.15u
X72 inv_out_down.t0 cVco.t5 gnd.t21 gnd.t20 sg13_lv_nmos ad=55.5f pd=0.74u as=0.1005p ps=1.34u w=0.15u l=0.13u
X73 gnd.t35 buf_in_down.t2 DOWN.t1 gnd.t34 sg13_lv_nmos ad=0.102p pd=1.28u as=57f ps=0.68u w=0.3u l=0.15u
X74 gnd.t5 buf_in_up.t2 UP.t1 gnd.t4 sg13_lv_nmos ad=0.102p pd=1.28u as=57f ps=0.68u w=0.3u l=0.15u
X75 gnd.t17 cRef.t4 inv_out_up.t1 gnd.t47 sg13_lv_nmos ad=55.5f pd=0.74u as=55.5f ps=0.74u w=0.15u l=0.13u
R0 UP.n1 UP.t0 27.4077
R1 UP.n1 UP.t1 26.7345
R2 UP.n0 UP.t3 13.8556
R3 UP.n0 UP.t2 12.9062
R4 UP.n2 UP.n0 7.3925
R5 UP.n2 UP.n1 4.6105
R6 UP UP.n2 0.4955
R7 DOWN.n1 DOWN.t0 27.6057
R8 DOWN.n1 DOWN.t1 26.5365
R9 DOWN.n0 DOWN.t3 13.5517
R10 DOWN.n0 DOWN.t2 12.5864
R11 DOWN.n2 DOWN.n0 6.1297
R12 DOWN.n2 DOWN.n1 4.6105
R13 DOWN DOWN.n2 2.4535
R14 cRef.n8 cRef.t2 15.068
R15 cRef.n8 cRef.t3 13.4603
R16 cRef.n1 cRef.t6 13.2975
R17 cRef.n3 cRef.n1 13.0099
R18 cRef.n10 cRef.t5 12.5186
R19 cRef.n6 cRef.t13 12.5184
R20 cRef.n4 cRef.t9 12.3574
R21 cRef.n4 cRef.t10 12.0934
R22 cRef.n5 cRef.t11 12.0934
R23 cRef.n10 cRef.t4 12.017
R24 cRef.n6 cRef.t12 12.0168
R25 cRef.n2 cRef.t1 7.6859
R26 cRef.n2 cRef.t0 7.67542
R27 cRef.n0 cRef.t7 7.6703
R28 cRef.n0 cRef.t8 7.65982
R29 cRef cRef.n11 6.4442
R30 cRef.n9 cRef.n7 5.8425
R31 cRef.n11 cRef.n10 5.6357
R32 cRef.n9 cRef.n8 5.5961
R33 cRef.n3 cRef.n2 4.5005
R34 cRef.n1 cRef.n0 3.0005
R35 cRef.n11 cRef.n9 1.9717
R36 cRef.n7 cRef.n6 1.1445
R37 cRef.n5 cRef.n4 0.7749
R38 cRef.n7 cRef.n5 0.7397
R39 cRef cRef.n3 0.625667
R40 cVco.n8 cVco.t2 15.1154
R41 cVco.n6 cVco.t13 13.7764
R42 cVco.n10 cVco.t5 13.7033
R43 cVco.n5 cVco.t9 13.3435
R44 cVco.n8 cVco.t3 13.1647
R45 cVco.n3 cVco.t1 12.319
R46 cVco.n2 cVco.t0 12.319
R47 cVco.n6 cVco.t12 12.2628
R48 cVco.n10 cVco.t4 12.1985
R49 cVco.n2 cVco.n1 12.1786
R50 cVco.n1 cVco.t8 12.1334
R51 cVco.n0 cVco.t7 7.78978
R52 cVco.n0 cVco.t6 7.72692
R53 cVco.n4 cVco.t10 7.65296
R54 cVco.n4 cVco.t11 7.65119
R55 cVco.n9 cVco.n7 6.5993
R56 cVco cVco.n11 6.53293
R57 cVco.n9 cVco.n8 5.0373
R58 cVco.n11 cVco.n10 5.0109
R59 cVco.n5 cVco.n4 4.5005
R60 cVco.n1 cVco.n0 4.2721
R61 cVco.n11 cVco.n9 1.8925
R62 cVco.n7 cVco.n5 1.2105
R63 cVco.n3 cVco.n2 0.664167
R64 cVco.n7 cVco.n6 0.5461
R65 cVco cVco.n3 0.281
R66 vp.n10 vp.t7 31.6973
R67 vp.n12 vp.t13 31.6973
R68 vp.n14 vp.t8 31.6973
R69 vp.n23 vp.t12 31.6973
R70 vp.n28 vp.t11 31.6973
R71 vp.n25 vp.t9 31.6973
R72 vp.n27 vp.t16 31.6973
R73 vp.n29 vp.t10 31.6973
R74 vp.n31 vp.t3 18.0658
R75 vp.n35 vp.t5 18.0317
R76 vp.n37 vp.t6 18.0317
R77 vp.n42 vp.t2 18.0317
R78 vp.n43 vp.t1 18.0317
R79 vp.n39 vp.t14 17.9767
R80 vp.n40 vp.t4 17.9767
R81 vp.n32 vp.t22 17.9767
R82 vp.n7 vp.t24 17.0005
R83 vp.n15 vp.t26 17.0005
R84 vp.n47 vp.n46 17.0005
R85 vp.n8 vp.n7 14.6973
R86 vp.n16 vp.n15 14.6973
R87 vp.n7 vp.t23 9.30844
R88 vp.n15 vp.t25 7.72833
R89 vp.n30 vp.n29 4.58055
R90 vp.n28 vp.n21 4.5005
R91 vp.n23 vp.n22 4.5005
R92 vp.n17 vp.n16 4.5005
R93 vp.n12 vp.n11 4.5005
R94 vp.n8 vp.n1 4.5005
R95 vp.n10 vp.n9 4.5005
R96 vp.n14 vp.n13 4.5005
R97 vp.n25 vp.n24 4.5005
R98 vp.n27 vp.n26 4.5005
R99 vp.n45 vp.n36 2.80696
R100 vp.n45 vp.n38 2.80696
R101 vp.n45 vp.n34 2.80696
R102 vp.n45 vp.n44 2.80696
R103 vp.n45 vp.n33 2.80696
R104 vp.n46 vp.n5 2.80696
R105 vp.n46 vp.n3 2.80696
R106 vp.n46 vp.n2 2.80696
R107 vp.n46 vp.n20 2.80696
R108 vp.n45 vp.n41 2.08777
R109 vp.n46 vp.n4 2.08777
R110 vp.n46 vp.n6 2.08777
R111 vp.n46 vp.n19 2.08777
R112 vp.n45 vp.n31 1.85103
R113 vp.n46 vp.n30 1.66333
R114 vp.n46 vp.n18 1.65246
R115 vp vp.n0 0.935452
R116 vp.n35 vp.n0 0.550549
R117 vp.n46 vp.t0 0.247877
R118 vp.n45 vp.n0 0.210867
R119 vp.t0 vp.n45 0.184296
R120 vp.n22 vp.n18 0.167359
R121 vp.n10 vp.n8 0.148843
R122 vp.n12 vp.n10 0.148843
R123 vp.n14 vp.n12 0.148843
R124 vp.n16 vp.n14 0.148843
R125 vp.n25 vp.n23 0.143814
R126 vp.n27 vp.n25 0.143814
R127 vp.n28 vp.n27 0.143814
R128 vp.n29 vp.n28 0.143814
R129 vp.n18 vp.n17 0.139265
R130 vp.n30 vp.n21 0.130234
R131 vp.n33 vp.n32 0.124623
R132 vp.n44 vp.n43 0.124623
R133 vp.n40 vp.n34 0.123129
R134 vp.n24 vp.n2 0.123129
R135 vp.n39 vp.n38 0.120956
R136 vp.n37 vp.n36 0.120956
R137 vp.n9 vp.n4 0.116891
R138 vp.n11 vp.n5 0.115456
R139 vp.n22 vp.n19 0.113993
R140 vp.n13 vp.n6 0.113224
R141 vp.n17 vp.n3 0.111789
R142 vp.n21 vp.n20 0.109956
R143 vp.n32 vp.n31 0.106995
R144 vp.n13 vp.n3 0.106629
R145 vp.n11 vp.n6 0.104827
R146 vp.n9 vp.n5 0.102963
R147 vp.n4 vp.n1 0.10116
R148 vp.n26 vp.n20 0.101129
R149 vp.n41 vp.n39 0.0993266
R150 vp.n36 vp.n35 0.0974625
R151 vp.n41 vp.n40 0.0967242
R152 vp.n24 vp.n19 0.0967242
R153 vp.n42 vp.n34 0.0952893
R154 vp.n44 vp.n42 0.0937958
R155 vp.n26 vp.n2 0.087956
R156 vp.n38 vp.n37 0.0681292
R157 vp.n43 vp.n33 0.0644625
R158 vp.n47 vp.n1 0.0564167
R159 vp vp.n47 0.0133333
R160 gnd.n91 gnd.t36 295.875
R161 gnd.n124 gnd.t65 293.478
R162 gnd.n88 gnd.n87 198.002
R163 gnd.t65 gnd.t26 144.023
R164 gnd.n77 gnd.t30 94.79
R165 gnd.n38 gnd.t32 94.79
R166 gnd.t73 gnd.n104 94.79
R167 gnd.t57 gnd.n103 92.3918
R168 gnd.t42 gnd.n92 89.6744
R169 gnd.t67 gnd.n115 89.6744
R170 gnd.n107 gnd.t53 86.957
R171 gnd.n96 gnd.t15 84.2396
R172 gnd.t6 gnd.n97 84.2396
R173 gnd.n117 gnd.t76 84.2396
R174 gnd.n15 gnd.t47 84.2396
R175 gnd.t51 gnd.n111 81.5222
R176 gnd.n20 gnd.t43 81.5222
R177 gnd.n110 gnd.t27 76.0875
R178 gnd.t82 gnd.n94 73.3701
R179 gnd.n99 gnd.t60 73.3701
R180 gnd.n20 gnd.t22 73.3701
R181 gnd.t0 gnd.n77 73.0508
R182 gnd.n38 gnd.t38 73.0508
R183 gnd.t44 gnd.n15 70.6527
R184 gnd.n124 gnd.t24 67.9353
R185 gnd.n113 gnd.t68 65.2179
R186 gnd.n101 gnd.t40 62.5005
R187 gnd.n14 gnd.t16 61.5279
R188 gnd.n18 gnd.t46 58.8105
R189 gnd.t69 gnd.n107 57.0657
R190 gnd.t50 gnd.n113 57.0657
R191 gnd.t61 gnd.n93 56.0931
R192 gnd.n92 gnd.t62 54.3483
R193 gnd.t79 gnd.n101 54.3483
R194 gnd.n109 gnd.t71 54.3483
R195 gnd.t55 gnd.t18 54.3483
R196 gnd.n115 gnd.t48 54.3483
R197 gnd.n85 gnd.t4 54.034
R198 gnd.n88 gnd.t34 53.9815
R199 gnd.t4 gnd.n75 53.3757
R200 gnd.t34 gnd.n36 53.3757
R201 gnd.t49 gnd.n105 53.3757
R202 gnd.n106 gnd.t49 53.3757
R203 gnd.n87 gnd.t2 51.6309
R204 gnd.n103 gnd.t13 51.6309
R205 gnd.n118 gnd.t54 50.6584
R206 gnd.t54 gnd.n117 48.9135
R207 gnd.t36 gnd.n90 47.9416
R208 gnd.n78 gnd.t2 47.9409
R209 gnd.t13 gnd.n102 47.9409
R210 gnd.t46 gnd.n17 47.9409
R211 gnd.t62 gnd.n91 45.8769
R212 gnd.n132 gnd.t16 45.4151
R213 gnd.n94 gnd.t61 43.4788
R214 gnd.t12 gnd.n99 43.4788
R215 gnd.t28 gnd.n114 39.7888
R216 gnd.t71 gnd.n108 38.044
R217 gnd.n108 gnd.t69 35.3266
R218 gnd.n90 gnd.t38 34.354
R219 gnd.n78 gnd.t0 34.354
R220 gnd.t8 gnd.n96 32.6092
R221 gnd.n97 gnd.t14 32.6092
R222 gnd.n29 gnd.t17 31.642
R223 gnd.n23 gnd.t25 31.642
R224 gnd.n24 gnd.t21 31.642
R225 gnd.n26 gnd.t23 31.642
R226 gnd.n28 gnd.t45 31.642
R227 gnd.n142 gnd.t19 31.5749
R228 gnd.n141 gnd.t29 31.5749
R229 gnd.n44 gnd.t7 31.4436
R230 gnd.n100 gnd.t41 28.9199
R231 gnd.n17 gnd.t44 28.9192
R232 gnd.t14 gnd.t8 27.1744
R233 gnd.t41 gnd.t12 27.1744
R234 gnd.t40 gnd.t10 27.1744
R235 gnd.t59 gnd.t79 27.1744
R236 gnd.t68 gnd.n112 27.1744
R237 gnd.n19 gnd.t20 26.7512
R238 gnd.t22 gnd.n19 26.5095
R239 gnd.n111 gnd.t55 24.457
R240 gnd.n133 gnd.t24 24.457
R241 gnd.t52 gnd.t50 21.7396
R242 gnd.n114 gnd.t52 20.7677
R243 gnd.n95 gnd.t82 19.0222
R244 gnd.t60 gnd.n98 19.0222
R245 gnd.n102 gnd.t59 18.0496
R246 gnd.t43 gnd.n18 18.0496
R247 gnd.n49 gnd.t58 17.8464
R248 gnd.n39 gnd.t63 17.8307
R249 gnd.n73 gnd.t35 17.7121
R250 gnd.n72 gnd.t33 17.7121
R251 gnd.n84 gnd.t5 17.7121
R252 gnd.n82 gnd.t31 17.7121
R253 gnd.n69 gnd.t37 17.6074
R254 gnd.n70 gnd.t39 17.5608
R255 gnd.n80 gnd.t1 17.5608
R256 gnd.n79 gnd.t3 17.5608
R257 gnd.n50 gnd.t74 17.2601
R258 gnd.n5 gnd.t66 17.2601
R259 gnd.n2 gnd.t72 17.2205
R260 gnd.n4 gnd.t77 17.2067
R261 gnd.t9 gnd.n41 17.1629
R262 gnd.n43 gnd.t9 17.1629
R263 gnd.n46 gnd.t11 17.1629
R264 gnd.n48 gnd.t80 17.1629
R265 gnd.n134 gnd.n133 17.0005
R266 gnd.t27 gnd.n109 16.3048
R267 gnd.t26 gnd.n118 15.3329
R268 gnd.t47 gnd.n14 15.3322
R269 gnd.n57 gnd.n46 14.2812
R270 gnd.n56 gnd.n48 14.2812
R271 gnd.n64 gnd.n41 14.2777
R272 gnd.n63 gnd.n43 14.2777
R273 gnd.t18 gnd.n110 13.5875
R274 gnd.t30 gnd.n75 12.6148
R275 gnd.t32 gnd.n36 12.6148
R276 gnd.n105 gnd.t73 12.6148
R277 gnd.t53 gnd.n106 12.6148
R278 gnd.n112 gnd.t51 10.8701
R279 gnd.t10 gnd.n100 9.89749
R280 gnd.n93 gnd.t42 9.89744
R281 gnd.n131 gnd.n13 8.52304
R282 gnd.n133 gnd.n8 8.501
R283 gnd.n133 gnd.n9 8.501
R284 gnd.n125 gnd.n124 8.501
R285 gnd.n133 gnd.n11 8.501
R286 gnd.n124 gnd.n123 8.501
R287 gnd.n124 gnd.n7 8.501
R288 gnd.n87 gnd.n86 8.5005
R289 gnd.n131 gnd.n20 8.5005
R290 gnd.n131 gnd.n15 8.5005
R291 gnd.n129 gnd.n128 8.5005
R292 gnd.n127 gnd.n126 8.5005
R293 gnd.n34 gnd.n33 8.5005
R294 gnd.n122 gnd.n121 8.5005
R295 gnd.n120 gnd.n119 8.5005
R296 gnd.n10 gnd.n6 8.5005
R297 gnd.n135 gnd.n134 8.5005
R298 gnd.n117 gnd.n1 8.5005
R299 gnd.n116 gnd.n1 8.5005
R300 gnd.n115 gnd.n1 8.5005
R301 gnd.n110 gnd.n1 8.5005
R302 gnd.n109 gnd.n1 8.5005
R303 gnd.n108 gnd.n1 8.5005
R304 gnd.n107 gnd.n1 8.5005
R305 gnd.n103 gnd.n1 8.5005
R306 gnd.n92 gnd.n1 8.5005
R307 gnd.n94 gnd.n1 8.5005
R308 gnd.n40 gnd.n1 8.5005
R309 gnd.n95 gnd.n1 8.5005
R310 gnd.n96 gnd.n1 8.5005
R311 gnd.n97 gnd.n1 8.5005
R312 gnd.n98 gnd.n1 8.5005
R313 gnd.n99 gnd.n1 8.5005
R314 gnd.n101 gnd.n1 8.5005
R315 gnd.n111 gnd.n1 8.5005
R316 gnd.n112 gnd.n1 8.5005
R317 gnd.n113 gnd.n1 8.5005
R318 gnd.t15 gnd.n95 8.15267
R319 gnd.n98 gnd.t6 8.15267
R320 gnd.t76 gnd.n116 8.15267
R321 gnd.n104 gnd.t57 7.83344
R322 gnd.n2 gnd.t70 7.5589
R323 gnd.n4 gnd.t75 7.5589
R324 gnd.n42 gnd.t81 7.53301
R325 gnd.n47 gnd.t78 7.53301
R326 gnd.t56 gnd.n39 7.47438
R327 gnd.n50 gnd.t64 7.47438
R328 gnd.t64 gnd.n5 7.47438
R329 gnd.n49 gnd.t56 7.46996
R330 gnd.t48 gnd.t28 5.43528
R331 gnd.n133 gnd.n132 4.91444
R332 gnd.n24 gnd.n21 4.6148
R333 gnd.n28 gnd.n27 4.5005
R334 gnd.n26 gnd.n25 4.5005
R335 gnd.n30 gnd.n29 4.5005
R336 gnd.n23 gnd.n13 4.5005
R337 gnd.n141 gnd.n140 4.5005
R338 gnd.n58 gnd.n57 4.5005
R339 gnd.n60 gnd.n44 4.5005
R340 gnd.n63 gnd.n62 4.5005
R341 gnd.n65 gnd.n64 4.5005
R342 gnd.n56 gnd.n55 4.5005
R343 gnd.n143 gnd.n142 4.5005
R344 gnd.n89 gnd.n35 4.25187
R345 gnd.n124 gnd.n12 4.251
R346 gnd.n131 gnd.n130 4.2357
R347 gnd.n131 gnd.n31 4.23547
R348 gnd.n45 gnd.n1 4.23547
R349 gnd.n146 gnd.n1 4.23547
R350 gnd.n51 gnd.n50 3.04791
R351 gnd.n136 gnd.n5 3.04791
R352 gnd.n53 gnd.n49 3.00855
R353 gnd.n67 gnd.n39 2.99291
R354 gnd.n85 gnd.n84 2.91432
R355 gnd.n89 gnd.n71 2.80696
R356 gnd.n86 gnd.n76 2.80696
R357 gnd.n86 gnd.n83 2.80696
R358 gnd.n89 gnd.n37 2.80696
R359 gnd.n89 gnd.n74 2.80696
R360 gnd.n131 gnd.n16 2.80696
R361 gnd.n131 gnd.n22 2.80696
R362 gnd.n139 gnd.n1 2.80696
R363 gnd.n68 gnd.n1 2.80696
R364 gnd.n61 gnd.n1 2.80696
R365 gnd.n59 gnd.n1 2.80696
R366 gnd.n54 gnd.n1 2.80696
R367 gnd.n52 gnd.n1 2.80696
R368 gnd.n1 gnd.n0 2.80696
R369 gnd.n3 gnd.n1 2.80696
R370 gnd.n137 gnd.n1 2.80691
R371 gnd.n116 gnd.t67 2.71789
R372 gnd.n86 gnd.n81 2.08786
R373 gnd.n144 gnd.n1 2.08777
R374 gnd.n131 gnd.n21 2.08773
R375 gnd.n66 gnd.n1 1.65246
R376 gnd.n69 gnd.n68 1.06185
R377 gnd.n138 gnd.n4 0.856437
R378 gnd.n145 gnd.n2 0.842688
R379 gnd.n90 gnd.n89 0.661721
R380 gnd.n118 gnd.n1 0.661721
R381 gnd.n100 gnd.n1 0.661721
R382 gnd.n114 gnd.n1 0.661721
R383 gnd.n86 gnd.n78 0.661473
R384 gnd.n86 gnd.n75 0.661473
R385 gnd.n89 gnd.n36 0.661473
R386 gnd.n131 gnd.n18 0.661473
R387 gnd.n131 gnd.n17 0.661473
R388 gnd.n131 gnd.n14 0.661473
R389 gnd.n106 gnd.n1 0.661473
R390 gnd.n105 gnd.n1 0.661473
R391 gnd.n93 gnd.n1 0.661473
R392 gnd.n102 gnd.n1 0.661473
R393 gnd.n132 gnd.n131 0.453347
R394 gnd.n131 gnd.n19 0.349794
R395 gnd.n137 gnd.n136 0.215375
R396 gnd.n136 gnd.n135 0.18475
R397 gnd.n142 gnd.n141 0.148843
R398 gnd.n67 gnd.n66 0.148432
R399 gnd.n29 gnd.n23 0.143814
R400 gnd.n29 gnd.n28 0.143814
R401 gnd.n28 gnd.n26 0.143814
R402 gnd.n26 gnd.n24 0.143814
R403 gnd.n43 gnd.n42 0.143238
R404 gnd.n48 gnd.n47 0.143238
R405 gnd.n42 gnd.n41 0.13931
R406 gnd.n47 gnd.n46 0.13931
R407 gnd.n57 gnd.n44 0.133757
R408 gnd.n63 gnd.n44 0.1325
R409 gnd.n66 gnd.n65 0.127026
R410 gnd.n143 gnd.n3 0.124963
R411 gnd.n145 gnd.n144 0.12316
R412 gnd.n25 gnd.n16 0.123129
R413 gnd.n139 gnd.n138 0.122789
R414 gnd.n79 gnd.n35 0.11777
R415 gnd.n74 gnd.n72 0.115796
R416 gnd.n70 gnd.n37 0.115796
R417 gnd.n83 gnd.n82 0.115796
R418 gnd.n80 gnd.n76 0.115796
R419 gnd.n51 gnd.n0 0.115796
R420 gnd.n81 gnd.n79 0.113931
R421 gnd.n59 gnd.n58 0.113623
R422 gnd.n54 gnd.n53 0.111789
R423 gnd.n30 gnd.n22 0.109956
R424 gnd gnd.n0 0.109039
R425 gnd.n61 gnd.n60 0.106289
R426 gnd.n81 gnd.n80 0.104032
R427 gnd.n55 gnd.n54 0.102963
R428 gnd.n68 gnd.n67 0.102623
R429 gnd.n27 gnd.n22 0.101129
R430 gnd.n25 gnd.n21 0.096904
R431 gnd.n140 gnd.n139 0.0956292
R432 gnd.n130 gnd.n129 0.0953079
R433 gnd.n144 gnd.n143 0.0948909
R434 gnd.n140 gnd.n3 0.093456
R435 gnd.n62 gnd.n61 0.0882959
R436 gnd.n27 gnd.n16 0.087956
R437 gnd.n60 gnd.n59 0.0827958
R438 gnd.n74 gnd.n73 0.0806227
R439 gnd.n84 gnd.n83 0.0806227
R440 gnd.n71 gnd.n69 0.0789607
R441 gnd.n53 gnd.n52 0.0772959
R442 gnd.n71 gnd.n70 0.0735339
R443 gnd.n72 gnd.n37 0.0732893
R444 gnd.n82 gnd.n76 0.0732893
R445 gnd.n52 gnd.n51 0.0732893
R446 gnd.n32 gnd.n31 0.0705528
R447 gnd.n64 gnd.n63 0.0671286
R448 gnd.n57 gnd.n56 0.0671286
R449 gnd.n73 gnd.n35 0.0664419
R450 gnd.n138 gnd.n137 0.0663661
R451 gnd.n146 gnd.n145 0.0659695
R452 gnd.n130 gnd.n32 0.0633784
R453 gnd.n129 gnd.n127 0.0628333
R454 gnd.n127 gnd.n33 0.0628333
R455 gnd.n121 gnd.n33 0.0628333
R456 gnd.n121 gnd.n120 0.0628333
R457 gnd.n120 gnd.n6 0.0628333
R458 gnd.n135 gnd.n6 0.0628333
R459 gnd.n65 gnd.n40 0.0600833
R460 gnd.n55 gnd.n45 0.0549695
R461 gnd.n89 gnd.n88 0.0526709
R462 gnd gnd.n146 0.0485528
R463 gnd.n31 gnd.n30 0.0476361
R464 gnd.n58 gnd.n45 0.0439695
R465 gnd.n62 gnd.n40 0.0380833
R466 gnd.n32 gnd.n13 0.00861475
R467 gnd.n91 gnd.n1 0.00507852
R468 gnd.n86 gnd.n77 0.00504252
R469 gnd.n89 gnd.n38 0.00504252
R470 gnd.n104 gnd.n1 0.00504252
R471 gnd.n128 gnd.n12 0.00175
R472 gnd.n131 gnd.n12 0.00124998
R473 gnd.n86 gnd.n85 0.00116605
R474 gnd.n128 gnd.n8 0.001
R475 gnd.n125 gnd.n34 0.001
R476 gnd.n34 gnd.n9 0.001
R477 gnd.n123 gnd.n119 0.001
R478 gnd.n119 gnd.n11 0.001
R479 gnd.n134 gnd.n7 0.001
R480 gnd.n126 gnd.n8 0.001
R481 gnd.n126 gnd.n125 0.001
R482 gnd.n122 gnd.n9 0.001
R483 gnd.n123 gnd.n122 0.001
R484 gnd.n11 gnd.n10 0.001
R485 gnd.n10 gnd.n7 0.001
R486 4.t0 4.n0 21.8846
R487 4 4.n0 0.593528
R488 4 4.n3 0.557833
R489 4.n3 4.n2 11.4399
R490 4.n3 4.t1 22.1733
R491 4.n2 4.t4 17.6217
R492 4.n2 4.t2 17.6427
R493 4.n0 4.n1 8.89047
R494 4.n1 4.t3 17.6419
R495 4.n1 4.t5 17.6669
R496 2.t2 2 26.9819
R497 2 2.n2 4.5005
R498 2.n2 2.n1 0.623833
R499 2.n2 2.n0 0.1545
R500 2.n1 2.t0 22.4872
R501 2.n1 2.t3 22.1117
R502 2.n0 2.t4 22.1117
R503 2.n0 2.t1 22.5004
R504 buf_in_up.t0 buf_in_up.n0 26.7185
R505 buf_in_up buf_in_up.n0 5.0021
R506 buf_in_up buf_in_up.n3 4.9405
R507 buf_in_up.n3 buf_in_up.n2 0.13669
R508 buf_in_up.n3 buf_in_up.n1 0.141929
R509 buf_in_up.n2 buf_in_up.t3 8.8888
R510 buf_in_up.n2 buf_in_up.t5 7.83692
R511 buf_in_up.n1 buf_in_up.t2 8.8888
R512 buf_in_up.n1 buf_in_up.t4 7.83692
R513 buf_in_up.n0 buf_in_up.t1 27.5045
R514 pre_up.t0 pre_up.n4 22.2011
R515 pre_up.n4 pre_up.t2 32.2641
R516 pre_up pre_up.n4 0.3833
R517 pre_up pre_up.n0 0.3085
R518 pre_up.n0 pre_up.n3 29.1885
R519 pre_up.n3 pre_up.n2 0.131452
R520 pre_up.n3 pre_up.n1 0.147167
R521 pre_up.n2 pre_up.t4 8.68255
R522 pre_up.n2 pre_up.t6 8.1463
R523 pre_up.n1 pre_up.t3 8.68255
R524 pre_up.n1 pre_up.t5 8.1463
R525 pre_up.n0 pre_up.t1 31.7706
R526 buf_in_down.t0 buf_in_down.n0 26.7185
R527 buf_in_down buf_in_down.n0 5.0263
R528 buf_in_down buf_in_down.n3 4.9163
R529 buf_in_down.n3 buf_in_down.n2 0.13669
R530 buf_in_down.n3 buf_in_down.n1 0.141929
R531 buf_in_down.n2 buf_in_down.t3 8.8888
R532 buf_in_down.n2 buf_in_down.t5 7.83692
R533 buf_in_down.n1 buf_in_down.t2 8.8888
R534 buf_in_down.n1 buf_in_down.t4 7.83692
R535 buf_in_down.n0 buf_in_down.t1 27.5045
R536 pre_down.t0 pre_down.n4 22.6686
R537 pre_down.n4 pre_down.t1 31.9693
R538 pre_down pre_down.n4 0.2953
R539 pre_down pre_down.n0 0.3613
R540 pre_down.n0 pre_down.n3 17.6893
R541 pre_down.n3 pre_down.n2 0.13669
R542 pre_down.n3 pre_down.n1 0.141929
R543 pre_down.n2 pre_down.t4 8.68255
R544 pre_down.n2 pre_down.t6 8.1463
R545 pre_down.n1 pre_down.t3 8.68255
R546 pre_down.n1 pre_down.t5 8.1463
R547 pre_down.n0 pre_down.t2 31.4714
R548 3.n4 3.t4 27.0829
R549 3.n3 3.n4 3.0005
R550 3.n4 3.t6 27.8037
R551 3.n3 3.n1 1.20034
R552 3.n1 3.n2 3.67484
R553 3.n2 3.t2 27.6717
R554 3.n2 3.t1 27.7773
R555 3.n1 3.t0 32.0038
R556 3 3.n3 0.235271
R557 3 3.n0 5.49197
R558 3.n0 3.t5 27.6718
R559 3.n0 3.t3 26.9268
R560 1.n4 1.t6 26.8292
R561 1.n3 1.n4 4.50198
R562 1.n4 1.t1 27.7963
R563 1.n3 1.n1 2.29698
R564 1.n1 1.n2 0.428588
R565 1.n2 1.t4 33.2861
R566 1.n2 1.t3 32.2245
R567 1.n1 1.t2 32.2553
R568 1 1.n3 0.784988
R569 1 1.n0 5.11714
R570 1.n0 1.t0 27.8301
R571 1.n0 1.t5 26.8849
R572 inv_out_up.t1 inv_out_up.n2 26.0948
R573 inv_out_up.n0 inv_out_up.n2 2.9573
R574 inv_out_up.n0 inv_out_up.n1 3.0365
R575 inv_out_up.n1 inv_out_up.t0 26.0948
R576 inv_out_up.n1 inv_out_up.t2 28.5129
R577 inv_out_up inv_out_up.n0 8.1553
R578 inv_out_up inv_out_up.t4 22.184
R579 inv_out_up.n2 inv_out_up.t3 28.5129
R580 inv_out_down.t1 inv_out_down.n2 26.0948
R581 inv_out_down.n1 inv_out_down.n2 7.45667
R582 inv_out_down.n1 inv_out_down.n0 8.9489
R583 inv_out_down inv_out_down.n1 4.7349
R584 inv_out_down inv_out_down.t4 22.3776
R585 inv_out_down.n0 inv_out_down.t0 26.0948
R586 inv_out_down.n0 inv_out_down.t2 28.5129
R587 inv_out_down.n2 inv_out_down.t3 28.5129
C0 pre_up 1 1.24368f
C1 cVco inv_out_down 0.57865f
C2 3 4 0.28352f
C3 3 UP 0.36256f
C4 pre_down vp 0.22493f
C5 cRef pre_up 0.15565f
C6 inv_out_down inv_out_up 3.46692f
C7 DOWN pre_up 0.20992f
C8 cVco 3 0.13284f
C9 buf_in_down vp 0.5034f
C10 cRef inv_out_down 0.09353f
C11 pre_down UP 0.11866f
C12 DOWN buf_in_up 0.18842f
C13 3 1 4.07196f
C14 buf_in_down UP 0.1188f
C15 cRef 3 1.00908f
C16 pre_down cVco 0.51147f
C17 pre_up buf_in_up 0.41886f
C18 inv_out_down pre_up 0.02787f
C19 DOWN 3 0.26372f
C20 vp UP 0.30257f
C21 pre_down 1 0.3782f
C22 3 pre_up 0.36921f
C23 pre_down cRef 0.15323f
C24 cVco vp 3.05475f
C25 pre_down DOWN 0.17332f
C26 inv_out_up vp 1.34866f
C27 buf_in_down 1 0.01342f
C28 4 UP 0.05375f
C29 4 2 1.21831f
C30 buf_in_down DOWN 0.30051f
C31 vp 1 1.79977f
C32 pre_down pre_up 1.32182f
C33 cVco 4 0.04857f
C34 cVco UP 0.44232f
C35 cRef vp 1.59102f
C36 cVco 2 0.03252f
C37 DOWN vp 0.28489f
C38 buf_in_down pre_up 0.66682f
C39 pre_down inv_out_down 0.05284f
C40 4 1 0.01071f
C41 UP 1 0.12427f
C42 cVco inv_out_up 0.27776f
C43 2 1 0.16234f
C44 vp pre_up 0.38135f
C45 cRef 4 0.32228f
C46 cRef UP 0.57348f
C47 cRef 2 0.21594f
C48 buf_in_down buf_in_up 0.01452f
C49 DOWN 4 0.043f
C50 DOWN UP 4.03279f
C51 DOWN 2 0.06369f
C52 cVco 1 0.12476f
C53 pre_down 3 1.10366f
C54 cRef cVco 8.70535f
C55 vp buf_in_up 0.51886f
C56 inv_out_down vp 1.35065f
C57 cRef inv_out_up 0.28634f
C58 cVco DOWN 0.52244f
C59 UP pre_up 0.16441f
C60 cRef 1 0.64326f
C61 3 vp 1.40617f
C62 cVco pre_up 0.059f
C63 UP buf_in_up 0.37186f
C64 DOWN 1 0.27022f
C65 inv_out_up pre_up 0.07153f
C66 cRef DOWN 0.20799f
C67 pre_down buf_in_down 0.67429f
C68 UP gnd 1.34936f
C69 DOWN gnd 1.75673f
C70 cRef gnd 3.74848f
C71 cVco gnd 5.7328f
C72 vp gnd 1.17475f
C73 4 gnd 1.85868f
C74 2 gnd 1.69776f
C75 buf_in_up gnd 1.11764f
C76 pre_up gnd 1.72604f
C77 buf_in_down gnd 1.07521f
C78 pre_down gnd 1.51841f
C79 3 gnd 1.19984f
C80 1 gnd 1.20636f
C81 inv_out_up gnd 6.51441f
C82 inv_out_down gnd 6.0546f
C83 inv_out_down.t1 gnd 0.09746f
C84 inv_out_down.t3 gnd 0.13431f
C85 inv_out_down.t2 gnd 0.13431f
C86 inv_out_down.t0 gnd 0.09746f
C87 inv_out_down.n0 gnd 1.39608f
C88 inv_out_down.t4 gnd 0.37399f
C89 inv_out_down.n1 gnd 1.07122f
C90 inv_out_down.n2 gnd 1.34379f
C91 inv_out_up.t1 gnd 0.09723f
C92 inv_out_up.t3 gnd 0.134f
C93 inv_out_up.t4 gnd 0.36226f
C94 inv_out_up.n0 gnd 1.16483f
C95 inv_out_up.t2 gnd 0.134f
C96 inv_out_up.t0 gnd 0.09723f
C97 inv_out_up.n1 gnd 1.12452f
C98 inv_out_up.n2 gnd 1.11715f
C99 1.t6 gnd 0.17176f
C100 1.t5 gnd 0.17293f
C101 1.t0 gnd 0.19985f
C102 1.n0 gnd 1.5045f
C103 1.n1 gnd 1.26964f
C104 1.t2 gnd 0.32596f
C105 1.n2 gnd 2.00978f
C106 1.t3 gnd 0.32527f
C107 1.t4 gnd 0.35652f
C108 1.n3 gnd 0.53748f
C109 1.t1 gnd 0.19985f
C110 1.n4 gnd 1.44273f
C111 3.t4 gnd 0.19354f
C112 3.n0 gnd 1.48304f
C113 3.t3 gnd 0.18964f
C114 3.t5 gnd 0.21304f
C115 3.n1 gnd 1.55683f
C116 3.t0 gnd 0.3402f
C117 3.t1 gnd 0.21659f
C118 3.t2 gnd 0.21333f
C119 3.n2 gnd 2.03969f
C120 3.n3 gnd 0.28492f
C121 3.n4 gnd 1.66431f
C122 3.t6 gnd 0.21747f
C123 pre_down.t0 gnd 0.12591f
C124 pre_down.t1 gnd 0.2259f
C125 pre_down.n0 gnd 1.46478f
C126 pre_down.t2 gnd 0.21722f
C127 pre_down.t3 gnd 0.15034f
C128 pre_down.t5 gnd 0.14327f
C129 pre_down.n1 gnd 0.33404f
C130 pre_down.t4 gnd 0.15034f
C131 pre_down.t6 gnd 0.14327f
C132 pre_down.n2 gnd 0.33467f
C133 pre_down.n3 gnd 0.4708f
C134 pre_down.n4 gnd 0.8705f
C135 buf_in_down.t0 gnd 0.10389f
C136 buf_in_down.t1 gnd 0.1157f
C137 buf_in_down.n0 gnd 0.84735f
C138 buf_in_down.t2 gnd 0.12612f
C139 buf_in_down.t4 gnd 0.11197f
C140 buf_in_down.n1 gnd 0.24587f
C141 buf_in_down.t3 gnd 0.12612f
C142 buf_in_down.t5 gnd 0.11197f
C143 buf_in_down.n2 gnd 0.24635f
C144 buf_in_down.n3 gnd 0.03225f
C145 pre_up.t0 gnd 0.09721f
C146 pre_up.t2 gnd 0.21231f
C147 pre_up.n0 gnd 1.85233f
C148 pre_up.t1 gnd 0.20427f
C149 pre_up.t3 gnd 0.13191f
C150 pre_up.t5 gnd 0.1257f
C151 pre_up.n1 gnd 0.29363f
C152 pre_up.t4 gnd 0.13191f
C153 pre_up.t6 gnd 0.1257f
C154 pre_up.n2 gnd 0.29419f
C155 pre_up.n3 gnd 0.76592f
C156 pre_up.n4 gnd 0.77409f
C157 buf_in_up.t0 gnd 0.06846f
C158 buf_in_up.t1 gnd 0.07624f
C159 buf_in_up.n0 gnd 0.55799f
C160 buf_in_up.t2 gnd 0.0831f
C161 buf_in_up.t4 gnd 0.07378f
C162 buf_in_up.n1 gnd 0.16201f
C163 buf_in_up.t3 gnd 0.0831f
C164 buf_in_up.t5 gnd 0.07378f
C165 buf_in_up.n2 gnd 0.16233f
C166 buf_in_up.n3 gnd 0.02162f
C167 2.t2 gnd 0.09559f
C168 2.t1 gnd 0.07392f
C169 2.t4 gnd 0.07063f
C170 2.n0 gnd 0.38764f
C171 2.t3 gnd 0.07063f
C172 2.n1 gnd 0.4492f
C173 2.t0 gnd 0.07389f
C174 2.n2 gnd 0.10627f
C175 4.t0 gnd 0.04932f
C176 4.n0 gnd 0.41532f
C177 4.t5 gnd 0.04007f
C178 4.t3 gnd 0.03989f
C179 4.n1 gnd 0.28805f
C180 4.t2 gnd 0.03998f
C181 4.t4 gnd 0.03989f
C182 4.n2 gnd 0.29855f
C183 4.t1 gnd 0.05245f
C184 4.n3 gnd 0.56887f
C185 vp.n0 gnd 0.1698f
C186 vp.n1 gnd 0.01894f
C187 vp.n2 gnd 0.01558f
C188 vp.n3 gnd 0.01662f
C189 vp.n4 gnd 0.0125f
C190 vp.n5 gnd 0.01661f
C191 vp.n6 gnd 0.01253f
C192 vp.t23 gnd 0.01661f
C193 vp.n7 gnd 0.04765f
C194 vp.n8 gnd 0.05979f
C195 vp.t7 gnd 0.02229f
C196 vp.n9 gnd 0.02706f
C197 vp.n10 gnd 0.09857f
C198 vp.t13 gnd 0.02229f
C199 vp.n11 gnd 0.02723f
C200 vp.n12 gnd 0.09857f
C201 vp.t8 gnd 0.02229f
C202 vp.n13 gnd 0.02711f
C203 vp.n14 gnd 0.09857f
C204 vp.t25 gnd 0.01413f
C205 vp.n15 gnd 0.05283f
C206 vp.n16 gnd 0.05979f
C207 vp.n17 gnd 0.03126f
C208 vp.n18 gnd 0.02029f
C209 vp.n19 gnd 0.01143f
C210 vp.n20 gnd 0.01572f
C211 vp.n21 gnd 0.02888f
C212 vp.t12 gnd 0.02166f
C213 vp.n22 gnd 0.03534f
C214 vp.n23 gnd 0.07695f
C215 vp.t9 gnd 0.02229f
C216 vp.n24 gnd 0.02753f
C217 vp.n25 gnd 0.09687f
C218 vp.t16 gnd 0.02229f
C219 vp.n26 gnd 0.02284f
C220 vp.n27 gnd 0.09687f
C221 vp.t11 gnd 0.02229f
C222 vp.n28 gnd 0.09687f
C223 vp.t10 gnd 0.02166f
C224 vp.n29 gnd 0.07743f
C225 vp.n30 gnd 0.03665f
C226 vp.n31 gnd 0.05162f
C227 vp.n32 gnd 0.04453f
C228 vp.n33 gnd 0.01237f
C229 vp.n34 gnd 0.01654f
C230 vp.n35 gnd 0.11169f
C231 vp.n36 gnd 0.01657f
C232 vp.n37 gnd 0.03984f
C233 vp.n38 gnd 0.01253f
C234 vp.n39 gnd 0.04341f
C235 vp.n40 gnd 0.04356f
C236 vp.n42 gnd 0.03938f
C237 vp.n43 gnd 0.03999f
C238 vp.n44 gnd 0.01653f
C239 vp.n45 gnd 0.76026f
C240 vp.t0 gnd 9.01035f
C241 vp.n46 gnd 0.56748f
C242 cVco.t6 gnd 0.23719f
C243 cVco.t7 gnd 0.23807f
C244 cVco.n0 gnd 0.40552f
C245 cVco.t8 gnd 0.30035f
C246 cVco.n1 gnd 1.11283f
C247 cVco.t0 gnd 0.24014f
C248 cVco.n2 gnd 1.2717f
C249 cVco.t1 gnd 0.24014f
C250 cVco.n3 gnd 0.36115f
C251 cVco.t9 gnd 0.27389f
C252 cVco.t10 gnd 0.17521f
C253 cVco.t11 gnd 0.17601f
C254 cVco.n4 gnd 0.47012f
C255 cVco.n5 gnd 0.64944f
C256 cVco.t13 gnd 0.36484f
C257 cVco.t12 gnd 0.29954f
C258 cVco.n6 gnd 0.93706f
C259 cVco.n7 gnd 0.43262f
C260 cVco.t2 gnd 0.48047f
C261 cVco.t3 gnd 0.4059f
C262 cVco.n8 gnd 1.27879f
C263 cVco.n9 gnd 0.98353f
C264 cVco.t5 gnd 0.39672f
C265 cVco.t4 gnd 0.33816f
C266 cVco.n10 gnd 1.1808f
C267 cVco.n11 gnd 0.82856f
C268 cRef.t6 gnd 0.31784f
C269 cRef.t7 gnd 0.2406f
C270 cRef.t8 gnd 0.24052f
C271 cRef.n0 gnd 0.20834f
C272 cRef.n1 gnd 1.38538f
C273 cRef.t0 gnd 0.16647f
C274 cRef.t1 gnd 0.1667f
C275 cRef.n2 gnd 0.16439f
C276 cRef.n3 gnd 1.26031f
C277 cRef.t11 gnd 0.21926f
C278 cRef.t10 gnd 0.21926f
C279 cRef.t9 gnd 0.22523f
C280 cRef.n4 gnd 0.58676f
C281 cRef.n5 gnd 0.39541f
C282 cRef.t13 gnd 0.31951f
C283 cRef.t12 gnd 0.30121f
C284 cRef.n6 gnd 0.87749f
C285 cRef.n7 gnd 0.47131f
C286 cRef.t2 gnd 0.49185f
C287 cRef.t3 gnd 0.43456f
C288 cRef.n8 gnd 1.42108f
C289 cRef.n9 gnd 0.81795f
C290 cRef.t5 gnd 0.31484f
C291 cRef.t4 gnd 0.29653f
C292 cRef.n10 gnd 0.98159f
C293 cRef.n11 gnd 0.89247f
C294 DOWN.t3 gnd 0.42397f
C295 DOWN.t2 gnd 0.39597f
C296 DOWN.n0 gnd 1.85143f
C297 DOWN.t0 gnd 0.20756f
C298 DOWN.t1 gnd 0.17547f
C299 DOWN.n1 gnd 1.41922f
C300 DOWN.n2 gnd 1.60283f
C301 UP.t3 gnd 0.46723f
C302 UP.t2 gnd 0.43514f
C303 UP.n0 gnd 2.23498f
C304 UP.t0 gnd 0.20948f
C305 UP.t1 gnd 0.18604f
C306 UP.n1 gnd 1.47648f
C307 UP.n2 gnd 1.53015f
.ends
