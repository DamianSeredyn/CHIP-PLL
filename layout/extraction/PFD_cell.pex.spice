* PEX produced on Mon Aug  3 04:59:10 PM CEST 2026 using /foss/tools/sak/sak-pex.sh with m=3 and s=1 (extresist threshold=10000 mOhm, minres=1000 mOhm, mindelay=1 ps)
* NGSPICE file created from PFD_cell.ext - technology: ihp-sg13g2

.subckt PFD_cell DOWN UP cVco cRef vp gnd
X0 vp cVco inv_out_down vp sg13_lv_pmos ad=0.1005p pd=1.34u as=55.5f ps=0.74u w=0.15u l=0.13u
X1 vp cRef 1 vp sg13_lv_pmos ad=57f pd=0.68u as=57f ps=0.68u w=0.3u l=0.15u
X2 buf_in_down pre_down vp vp sg13_lv_pmos ad=55.5f pd=0.74u as=0.1005p ps=1.34u w=0.15u l=0.15u
X3 vp buf_in_down DOWN vp sg13_lv_pmos ad=0.102p pd=1.28u as=57f ps=0.68u w=0.3u l=0.15u
X4 2 gnd.t48 gnd.t50 gnd.t49 sg13_lv_nmos ad=57f pd=0.68u as=0.102p ps=1.28u w=0.3u l=0.15u
X5 4 cVco gnd.t27 gnd.t26 sg13_lv_nmos ad=55.5f pd=0.74u as=55.5f ps=0.74u w=0.15u l=0.15u
X6 gnd.t3 inv_out_up pre_up gnd.t2 sg13_lv_nmos ad=57f pd=0.68u as=57f ps=0.68u w=0.3u l=0.15u
X7 1 cRef pre_up gnd.t33 sg13_lv_nmos ad=57f pd=0.68u as=57f ps=0.68u w=0.3u l=0.15u
X8 gnd.t70 gnd.t29 gnd.t29 gnd.t68 sg13_lv_nmos ad=0.102p pd=1.28u as=0 ps=0 w=0.3u l=0.15u
X9 pre_down cVco 3 gnd.t11 sg13_lv_nmos ad=57f pd=0.68u as=57f ps=0.68u w=0.3u l=0.15u
X10 pre_down cVco 3 gnd.t12 sg13_lv_nmos ad=57f pd=0.68u as=57f ps=0.68u w=0.3u l=0.15u
X11 1 DOWN 2 gnd.t74 sg13_lv_nmos ad=57f pd=0.68u as=57f ps=0.68u w=0.3u l=0.15u
X12 gnd.t63 gnd.t48 4 gnd.t62 sg13_lv_nmos ad=0.102p pd=1.28u as=57f ps=0.68u w=0.3u l=0.15u
X13 vp cRef inv_out_up vp sg13_lv_pmos ad=55.5f pd=0.74u as=55.5f ps=0.74u w=0.15u l=0.13u
X14 inv_out_up cRef gnd.t36 gnd.t37 sg13_lv_nmos ad=55.5f pd=0.74u as=55.5f ps=0.74u w=0.15u l=0.13u
X15 UP buf_in_up gnd.t5 gnd.t4 sg13_lv_nmos ad=57f pd=0.68u as=0.102p ps=1.28u w=0.3u l=0.15u
X16 vp cVco inv_out_down vp sg13_lv_pmos ad=55.5f pd=0.74u as=55.5f ps=0.74u w=0.15u l=0.13u
X17 vp pre_down buf_in_down vp sg13_lv_pmos ad=0.1005p pd=1.34u as=55.5f ps=0.74u w=0.15u l=0.15u
X18 gnd.t36 cRef inv_out_up gnd.t35 sg13_lv_nmos ad=55.5f pd=0.74u as=55.5f ps=0.74u w=0.15u l=0.13u
X19 3 cRef 4 gnd.t39 sg13_lv_nmos ad=57f pd=0.68u as=57f ps=0.68u w=0.3u l=0.15u
X20 DOWN buf_in_down gnd.t44 gnd.t43 sg13_lv_nmos ad=57f pd=0.68u as=0.102p ps=1.28u w=0.3u l=0.15u
X21 gnd.t66 gnd.t66 4 gnd.t67 sg13_lv_nmos ad=0.1005p pd=1.34u as=55.5f ps=0.74u w=0.15u l=0.15u
X22 vp cVco 3 vp sg13_lv_pmos ad=57f pd=0.68u as=57f ps=0.68u w=0.3u l=0.15u
X23 2 cRef gnd.t15 gnd.t41 sg13_lv_nmos ad=55.5f pd=0.74u as=55.5f ps=0.74u w=0.15u l=0.15u
X24 pre_up inv_out_up gnd.t1 gnd.t0 sg13_lv_nmos ad=57f pd=0.68u as=57f ps=0.68u w=0.3u l=0.15u
X25 vp cRef inv_out_up vp sg13_lv_pmos ad=55.5f pd=0.74u as=55.5f ps=0.74u w=0.15u l=0.13u
X26 1 cVco 2 gnd.t24 sg13_lv_nmos ad=57f pd=0.68u as=57f ps=0.68u w=0.3u l=0.15u
X27 3 gnd.t51 gnd.t53 gnd.t52 sg13_lv_nmos ad=57f pd=0.68u as=0.102p ps=1.28u w=0.3u l=0.15u
X28 3 gnd.t51 1 gnd.t55 sg13_lv_nmos ad=57f pd=0.68u as=57f ps=0.68u w=0.3u l=0.15u
X29 pre_up gnd.t51 3 gnd.t56 sg13_lv_nmos ad=57f pd=0.68u as=57f ps=0.68u w=0.3u l=0.15u
X30 inv_out_up cRef gnd.t19 gnd.t34 sg13_lv_nmos ad=55.5f pd=0.74u as=55.5f ps=0.74u w=0.15u l=0.13u
X31 2 gnd.t48 4 gnd.t60 sg13_lv_nmos ad=57f pd=0.68u as=57f ps=0.68u w=0.3u l=0.15u
X32 4 cRef 3 gnd.t40 sg13_lv_nmos ad=57f pd=0.68u as=57f ps=0.68u w=0.3u l=0.15u
X33 4 gnd.t64 gnd.t64 gnd.t65 sg13_lv_nmos ad=55.5f pd=0.74u as=0.1005p ps=1.34u w=0.15u l=0.15u
X34 gnd.t15 cVco 4 gnd.t14 sg13_lv_nmos ad=55.5f pd=0.74u as=55.5f ps=0.74u w=0.15u l=0.15u
X35 vp pre_up buf_in_up vp sg13_lv_pmos ad=0.1005p pd=1.34u as=55.5f ps=0.74u w=0.15u l=0.15u
X36 gnd.t27 cRef 2 gnd.t42 sg13_lv_nmos ad=55.5f pd=0.74u as=55.5f ps=0.74u w=0.15u l=0.15u
X37 3 cVco vp vp sg13_lv_pmos ad=57f pd=0.68u as=57f ps=0.68u w=0.3u l=0.15u
X38 3 cVco vp vp sg13_lv_pmos ad=57f pd=0.68u as=57f ps=0.68u w=0.3u l=0.15u
X39 1 cRef vp vp sg13_lv_pmos ad=57f pd=0.68u as=57f ps=0.68u w=0.3u l=0.15u
X40 1 vp vp vp sg13_lv_pmos ad=57f pd=0.68u as=0.102p ps=1.28u w=0.3u l=0.15u
X41 UP buf_in_up vp vp sg13_lv_pmos ad=57f pd=0.68u as=0.102p ps=1.28u w=0.3u l=0.15u
X42 2 DOWN 1 gnd.t73 sg13_lv_nmos ad=57f pd=0.68u as=57f ps=0.68u w=0.3u l=0.15u
X43 gnd.t5 pre_up buf_in_up gnd.t47 sg13_lv_nmos ad=0.1005p pd=1.34u as=55.5f ps=0.74u w=0.15u l=0.15u
X44 gnd.t1 inv_out_down pre_down gnd.t30 sg13_lv_nmos ad=57f pd=0.68u as=57f ps=0.68u w=0.3u l=0.15u
X45 inv_out_up cRef vp vp sg13_lv_pmos ad=55.5f pd=0.74u as=55.5f ps=0.74u w=0.15u l=0.13u
X46 DOWN buf_in_down vp vp sg13_lv_pmos ad=57f pd=0.68u as=0.102p ps=1.28u w=0.3u l=0.15u
X47 1 cRef pre_up gnd.t32 sg13_lv_nmos ad=57f pd=0.68u as=57f ps=0.68u w=0.3u l=0.15u
X48 4 UP 3 gnd.t75 sg13_lv_nmos ad=57f pd=0.68u as=57f ps=0.68u w=0.3u l=0.15u
X49 3 UP 4 gnd.t76 sg13_lv_nmos ad=57f pd=0.68u as=57f ps=0.68u w=0.3u l=0.15u
X50 inv_out_down cVco vp vp sg13_lv_pmos ad=55.5f pd=0.74u as=0.1005p ps=1.34u w=0.15u l=0.13u
X51 4 gnd.t48 2 gnd.t59 sg13_lv_nmos ad=57f pd=0.68u as=57f ps=0.68u w=0.3u l=0.15u
X52 inv_out_down cVco vp vp sg13_lv_pmos ad=55.5f pd=0.74u as=55.5f ps=0.74u w=0.15u l=0.13u
X53 vp vp 3 vp sg13_lv_pmos ad=0.102p pd=1.28u as=57f ps=0.68u w=0.3u l=0.15u
X54 gnd.t23 cVco inv_out_down gnd.t22 sg13_lv_nmos ad=0.1005p pd=1.34u as=55.5f ps=0.74u w=0.15u l=0.13u
X55 inv_out_up cRef vp vp sg13_lv_pmos ad=55.5f pd=0.74u as=55.5f ps=0.74u w=0.15u l=0.13u
X56 buf_in_up pre_up vp vp sg13_lv_pmos ad=55.5f pd=0.74u as=0.1005p ps=1.34u w=0.15u l=0.15u
X57 buf_in_down pre_down gnd.t9 gnd.t8 sg13_lv_nmos ad=55.5f pd=0.74u as=0.1005p ps=1.34u w=0.15u l=0.15u
X58 gnd.t19 cVco inv_out_down gnd.t18 sg13_lv_nmos ad=55.5f pd=0.74u as=55.5f ps=0.74u w=0.15u l=0.13u
X59 buf_in_up pre_up gnd.t5 gnd.t46 sg13_lv_nmos ad=55.5f pd=0.74u as=0.1005p ps=1.34u w=0.15u l=0.15u
X60 vp buf_in_up UP vp sg13_lv_pmos ad=0.102p pd=1.28u as=57f ps=0.68u w=0.3u l=0.15u
X61 pre_down inv_out_down gnd.t29 gnd.t28 sg13_lv_nmos ad=57f pd=0.68u as=57f ps=0.68u w=0.3u l=0.15u
X62 inv_out_down cVco gnd.t21 gnd.t20 sg13_lv_nmos ad=55.5f pd=0.74u as=55.5f ps=0.74u w=0.15u l=0.13u
X63 4 gnd.t48 2 gnd.t61 sg13_lv_nmos ad=57f pd=0.68u as=57f ps=0.68u w=0.3u l=0.15u
X64 gnd.t3 gnd.t71 gnd.t71 gnd.t72 sg13_lv_nmos ad=57f pd=0.68u as=0 ps=0 w=0.3u l=0.15u
X65 1 gnd.t51 pre_down gnd.t54 sg13_lv_nmos ad=57f pd=0.68u as=57f ps=0.68u w=0.3u l=0.15u
X66 pre_up cRef 1 gnd.t31 sg13_lv_nmos ad=57f pd=0.68u as=57f ps=0.68u w=0.3u l=0.15u
X67 3 cVco pre_down gnd.t13 sg13_lv_nmos ad=57f pd=0.68u as=57f ps=0.68u w=0.3u l=0.15u
X68 gnd.t58 gnd.t51 1 gnd.t57 sg13_lv_nmos ad=0.102p pd=1.28u as=57f ps=0.68u w=0.3u l=0.15u
X69 2 cVco 1 gnd.t25 sg13_lv_nmos ad=57f pd=0.68u as=57f ps=0.68u w=0.3u l=0.15u
X70 gnd.t9 pre_down buf_in_down gnd.t10 sg13_lv_nmos ad=0.1005p pd=1.34u as=55.5f ps=0.74u w=0.15u l=0.15u
X71 vp cRef 1 vp sg13_lv_pmos ad=57f pd=0.68u as=57f ps=0.68u w=0.3u l=0.15u
X72 inv_out_down cVco gnd.t17 gnd.t16 sg13_lv_nmos ad=55.5f pd=0.74u as=0.1005p ps=1.34u w=0.15u l=0.13u
X73 gnd.t44 buf_in_down DOWN gnd.t45 sg13_lv_nmos ad=0.102p pd=1.28u as=57f ps=0.68u w=0.3u l=0.15u
X74 gnd.t7 buf_in_up UP gnd.t6 sg13_lv_nmos ad=0.102p pd=1.28u as=57f ps=0.68u w=0.3u l=0.15u
X75 gnd.t21 cRef inv_out_up gnd.t38 sg13_lv_nmos ad=55.5f pd=0.74u as=55.5f ps=0.74u w=0.15u l=0.13u
R0 gnd.n23 gnd.t8 288.365
R1 gnd.t49 gnd.n9 287.046
R2 gnd.n14 gnd.n37 193.036
R3 gnd.t24 gnd.t49 140.274
R4 gnd.n24 gnd.n23 0.626725
R5 gnd.n25 gnd.n26 0.302181
R6 gnd.t62 gnd.n20 10.8981
R7 gnd.n51 gnd.t59 87.3406
R8 gnd.n28 gnd.t33 91.5736
R9 gnd.n45 gnd.t76 84.6939
R10 gnd.t38 gnd.n5 11.9769
R11 gnd.t65 gnd.n49 82.0473
R12 gnd.t0 gnd.n34 82.0473
R13 gnd.n39 gnd.t13 82.0473
R14 gnd.n8 gnd.t34 85.134
R15 gnd.n47 gnd.t42 79.4006
R16 gnd.t25 gnd.n31 74.1073
R17 gnd.n8 gnd.t18 17.5309
R18 gnd.t55 gnd.n33 71.4606
R19 gnd.n38 gnd.t72 71.4606
R20 gnd.n25 gnd.n27 0.457416
R21 gnd.t37 gnd.n5 75.3922
R22 gnd.n48 gnd.t60 63.5206
R23 gnd.n41 gnd.t31 60.8739
R24 gnd.t16 gnd.t20 25.4647
R25 gnd.t35 gnd.n4 57.4371
R26 gnd.t11 gnd.n24 57.4834
R27 gnd.t41 gnd.n48 55.5806
R28 gnd.n45 gnd.t61 55.5806
R29 gnd.t56 gnd.n18 54.7904
R30 gnd.t39 gnd.n51 52.9339
R31 gnd.t74 gnd.t26 52.9339
R32 gnd.n46 gnd.t67 52.9339
R33 gnd.t68 gnd.n41 52.9339
R34 gnd.t57 gnd.n28 22.3441
R35 gnd.n15 gnd.n14 0.297035
R36 gnd.t40 gnd.n16 52.1437
R37 gnd.n15 gnd.t45 26.099
R38 gnd.t6 gnd.n26 26.1137
R39 gnd.n37 gnd.t46 50.2872
R40 gnd.t73 gnd.n21 49.4971
R41 gnd.n49 gnd.t73 47.6406
R42 gnd.n3 gnd.t35 46.8504
R43 gnd.n19 gnd.t11 46.8504
R44 gnd.n27 gnd.t46 47.066
R45 gnd.n23 gnd.n28 3.58884
R46 gnd.n33 gnd.t30 42.3472
R47 gnd.n38 gnd.t56 42.3472
R48 gnd.n22 gnd.t14 38.9104
R49 gnd.t67 gnd.n32 37.0539
R50 gnd.t61 gnd.n32 34.4072
R51 gnd.n13 gnd.t10 22.704
R52 gnd.t47 gnd.n27 22.7041
R53 gnd.t12 gnd.n34 31.7605
R54 gnd.n39 gnd.t2 31.7605
R55 gnd.t32 gnd.n17 28.3244
R56 gnd.n3 gnd.t37 28.3237
R57 gnd.t60 gnd.n30 26.4672
R58 gnd.t54 gnd.t68 26.4672
R59 gnd.t31 gnd.t28 26.4672
R60 gnd.t30 gnd.t32 26.4672
R61 gnd.t2 gnd.t12 26.4672
R62 gnd.n8 gnd.t16 2.08614
R63 gnd.n9 gnd.t22 17.9938
R64 gnd.n47 gnd.t74 23.8205
R65 gnd.t75 gnd.t41 21.1739
R66 gnd.n22 gnd.t75 20.3844
R67 gnd.n40 gnd.t55 18.5272
R68 gnd.t72 gnd.n35 18.5272
R69 gnd.t34 gnd.n4 17.737
R70 gnd.n19 gnd.t54 17.737
R71 gnd.n46 gnd.t25 15.8805
R72 gnd.n21 gnd.t24 15.0911
R73 gnd.t16 gnd.n5 1.2417
R74 gnd.t29 gnd.n43 14.1186
R75 gnd.t71 gnd.n12 14.1486
R76 gnd.n42 gnd.t3 14.1151
R77 gnd.t26 gnd.n31 13.2338
R78 gnd.t76 gnd.n16 12.4437
R79 gnd.t40 gnd.n20 52.2239
R80 gnd.n15 gnd.t43 11.1923
R81 gnd.t4 gnd.n26 11.1912
R82 gnd.t42 gnd.n30 10.5872
R83 gnd.t28 gnd.n17 9.79708
R84 gnd.t33 gnd.n18 9.79704
R85 gnd.n23 gnd.n48 8.5005
R86 gnd.n23 gnd.n30 8.5005
R87 gnd.n23 gnd.n47 8.5005
R88 gnd.n23 gnd.n41 8.5005
R89 gnd.n23 gnd.n33 8.5005
R90 gnd.n23 gnd.n40 8.5005
R91 gnd.n23 gnd.n34 8.5005
R92 gnd.n23 gnd.n39 8.5005
R93 gnd.n23 gnd.n35 8.5005
R94 gnd.n23 gnd.n38 8.5005
R95 gnd.n23 gnd.n45 8.5005
R96 gnd.n23 gnd.n32 8.5005
R97 gnd.n23 gnd.n46 8.5005
R98 gnd.n23 gnd.n31 8.5005
R99 gnd.n23 gnd.n51 8.5005
R100 gnd.n23 gnd.n50 8.5005
R101 gnd.n23 gnd.n49 8.5005
R102 gnd.n37 gnd.n25 8.5005
R103 gnd.n50 gnd.t65 7.94051
R104 gnd.n40 gnd.t0 7.94051
R105 gnd.t13 gnd.n35 7.94051
R106 gnd.t48 gnd.t50 7.47438
R107 gnd.t63 gnd.t48 7.47438
R108 gnd.t51 gnd.t58 7.47438
R109 gnd.t53 gnd.t51 7.46996
R110 gnd.n24 gnd.t52 6.62091
R111 gnd.t14 gnd.t39 5.29384
R112 gnd.t17 gnd.n6 4.6148
R113 gnd.t27 gnd.t66 4.5005
R114 gnd.n0 gnd.n11 2.23447
R115 gnd.n12 gnd.n0 2.23447
R116 gnd.n42 gnd.n12 0.0340695
R117 gnd.t1 gnd.n0 4.5005
R118 gnd.n43 gnd.n11 0.0340695
R119 gnd.t64 gnd.t15 4.5005
R120 gnd.n10 gnd.n6 2.21573
R121 gnd.n10 gnd.t21 0.071534
R122 gnd.t19 gnd.n7 0.071534
R123 gnd.n7 gnd.n6 2.21573
R124 gnd.n9 gnd.t16 0.462772
R125 gnd.t64 gnd.t50 3.04791
R126 gnd.n0 gnd.t63 3.04791
R127 gnd.n0 gnd.t53 3.00855
R128 gnd.t58 gnd.n44 2.99291
R129 gnd.n25 gnd.n29 0.55771
R130 gnd.n14 gnd.t44 0.67241
R131 gnd.n23 gnd.n2 0.781317
R132 gnd.n1 gnd.n0 0.146336
R133 gnd.n23 gnd.n36 2.80696
R134 gnd.t64 gnd.n2 0.201248
R135 gnd.t59 gnd.n50 2.64717
R136 gnd.n29 gnd.t5 0.055323
R137 gnd.n0 gnd.t66 0.379743
R138 gnd.t64 gnd.n6 0.721272
R139 gnd.n23 gnd.n1 0.125603
R140 gnd.t9 gnd.n36 1.06185
R141 gnd.n23 gnd.n22 0.676566
R142 gnd.n23 gnd.n17 0.676566
R143 gnd.n23 gnd.n21 0.676566
R144 gnd.t8 gnd.n13 47.0668
R145 gnd.n23 gnd.n16 0.735674
R146 gnd.n23 gnd.n18 0.676317
R147 gnd.n23 gnd.n19 0.676317
R148 gnd.n23 gnd.n20 0.592843
R149 gnd.t16 gnd.n3 0.676317
R150 gnd.t16 gnd.n4 0.676317
R151 gnd.t44 gnd.t5 0.658416
R152 gnd.n14 gnd.n13 0.516976
R153 gnd.t70 gnd.t29 0.40056
R154 gnd.t3 gnd.t71 0.40056
R155 gnd.t9 gnd.t44 0.307227
R156 gnd.n29 gnd.t7 0.210564
R157 gnd.t15 gnd.t27 0.148843
R158 gnd.n44 gnd.n1 0.662703
R159 gnd.t19 gnd.t17 0.143814
R160 gnd.t36 gnd.n7 0.071534
R161 gnd.t21 gnd.t36 0.143814
R162 gnd.n10 gnd.t23 0.071534
R163 gnd.n43 gnd.t1 0.133757
R164 gnd.t1 gnd.n42 0.1325
R165 gnd.t66 gnd.n2 0.539236
R166 gnd.n44 gnd.n36 0.102623
R167 gnd.t70 gnd.n11 14.1522
R168 gnd.t16 gnd.t64 1.01062
C0 inv_out_up cVco 0.27763f
C1 vp pre_up 0.39944f
C2 1 pre_down 0.38703f
C3 4 DOWN 0.043f
C4 buf_in_down pre_down 0.55298f
C5 1 DOWN 0.26802f
C6 buf_in_up UP 0.37509f
C7 buf_in_down DOWN 0.30416f
C8 cVco inv_out_down 0.59896f
C9 3 pre_down 1.10649f
C10 cRef UP 0.57415f
C11 cVco pre_down 0.79f
C12 3 DOWN 0.26455f
C13 1 pre_up 1.40494f
C14 2 DOWN 0.06369f
C15 inv_out_up cRef 0.28707f
C16 vp 1 2.0796f
C17 cVco DOWN 0.52246f
C18 buf_in_down pre_up 0.67175f
C19 buf_in_down vp 0.47836f
C20 pre_up 3 0.36828f
C21 cRef inv_out_down 0.08964f
C22 vp 3 1.6373f
C23 cVco pre_up 0.06697f
C24 DOWN buf_in_up 0.21576f
C25 vp cVco 3.0428f
C26 cRef pre_down 0.17672f
C27 inv_out_up inv_out_down 3.50305f
C28 pre_down UP 0.26788f
C29 cRef DOWN 0.20808f
C30 buf_in_down 1 0.01351f
C31 DOWN UP 4.03279f
C32 4 3 0.28411f
C33 pre_up buf_in_up 0.32702f
C34 2 4 1.21831f
C35 1 3 4.31645f
C36 vp buf_in_up 0.49355f
C37 4 cVco 0.0488f
C38 2 1 0.16426f
C39 1 cVco 0.1267f
C40 cRef pre_up 0.15726f
C41 pre_down inv_out_down 0.05225f
C42 vp cRef 1.59052f
C43 pre_up UP 0.26719f
C44 vp UP 0.2942f
C45 inv_out_up pre_up 0.07642f
C46 cVco 3 0.14599f
C47 vp inv_out_up 1.34872f
C48 DOWN pre_down 0.19035f
C49 2 cVco 0.03249f
C50 4 cRef 0.32233f
C51 buf_in_down buf_in_up 0.01425f
C52 pre_up inv_out_down 0.03111f
C53 4 UP 0.05375f
C54 vp inv_out_down 1.35073f
C55 cRef 1 0.64271f
C56 1 UP 0.11934f
C57 pre_up pre_down 2.0556f
C58 buf_in_down UP 0.11778f
C59 vp pre_down 0.20725f
C60 pre_up DOWN 0.24876f
C61 cRef 3 0.99275f
C62 vp DOWN 0.28147f
C63 2 cRef 0.21587f
C64 3 UP 0.36018f
C65 cRef cVco 8.82667f
C66 cVco UP 0.44033f
C67 DOWN 0 0.95847f
C68 4 0 3.10615f
C69 2 0 2.3967f
C70 3 0 2.79165f
C71 1 0 8.18576f
C72 gnd.t5 0 0.51803f
C73 gnd.t44 0 0.95847f
C74 gnd.t9 0 1.91694f
C75 gnd.t3 0 2.58437f
C76 gnd.t1 0 3.83387f
.ends
