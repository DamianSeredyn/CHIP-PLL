* PEX produced on Sat May 30 02:39:24 PM CEST 2026 using /foss/tools/sak/sak-pex.sh with m=3 and s=1
* NGSPICE file created from PFD_cell.ext - technology: ihp-sg13g2

.subckt PFD_cell DOWN UP cVco cRef gnd vp
X0 vp.t6 pre_down.t5 buf_in_down.t0 vp.t0 sg13_lv_pmos ad=0.1005p pd=1.34u as=55.5f ps=0.74u w=0.15u l=0.15u
X1 4.t3 cVco.t0 gnd.t28 gnd.t51 sg13_lv_nmos ad=55.5f pd=0.74u as=55.5f ps=0.74u w=0.15u l=0.15u
X2 vp.t20 cVco.t12 inv_out_down.t3 vp.t0 sg13_lv_pmos ad=0.1005p pd=1.34u as=55.5f ps=0.74u w=0.15u l=0.13u
X3 vp.t13 cRef.t9 1.t4 vp.t0 sg13_lv_pmos ad=57f pd=0.68u as=57f ps=0.68u w=0.3u l=0.15u
X4 1.t2 cRef.t6 pre_up.t2 gnd.t15 sg13_lv_nmos ad=57f pd=0.68u as=57f ps=0.68u w=0.3u l=0.15u
X5 2.t2 gnd.t54 gnd.t56 gnd.t55 sg13_lv_nmos ad=57f pd=0.68u as=0.102p ps=1.28u w=0.3u l=0.15u
X6 pre_down.t1 cVco.t8 3.t2 gnd.t39 sg13_lv_nmos ad=57f pd=0.68u as=57f ps=0.68u w=0.3u l=0.15u
X7 pre_down.t2 cVco.t7 3.t3 gnd.t40 sg13_lv_nmos ad=57f pd=0.68u as=57f ps=0.68u w=0.3u l=0.15u
X8 1.t6 DOWN.t2 2.t3 gnd.t53 sg13_lv_nmos ad=57f pd=0.68u as=57f ps=0.68u w=0.3u l=0.15u
X9 gnd.t69 gnd.t54 4.t1 gnd.t68 sg13_lv_nmos ad=0.102p pd=1.28u as=57f ps=0.68u w=0.3u l=0.15u
X10 inv_out_up.t1 cRef.t4 gnd.t19 gnd.t18 sg13_lv_nmos ad=55.5f pd=0.74u as=55.5f ps=0.74u w=0.15u l=0.13u
X11 UP.t1 buf_in_up.t3 gnd.t30 gnd.t29 sg13_lv_nmos ad=57f pd=0.68u as=0.102p ps=1.28u w=0.3u l=0.15u
X12 vp.t12 cRef.t12 inv_out_up.t3 vp.t0 sg13_lv_pmos ad=55.5f pd=0.74u as=55.5f ps=0.74u w=0.15u l=0.13u
X13 gnd.t19 cRef.t5 inv_out_up.t0 gnd.t20 sg13_lv_nmos ad=55.5f pd=0.74u as=55.5f ps=0.74u w=0.15u l=0.13u
X14 3.t0 cRef.t3 4.t0 gnd.t23 sg13_lv_nmos ad=57f pd=0.68u as=57f ps=0.68u w=0.3u l=0.15u
X15 DOWN.t1 buf_in_down.t3 gnd.t32 gnd.t31 sg13_lv_nmos ad=57f pd=0.68u as=0.102p ps=1.28u w=0.3u l=0.15u
X16 gnd.t75 gnd.t73 4.t3 gnd.t74 sg13_lv_nmos ad=0.1005p pd=1.34u as=55.5f ps=0.74u w=0.15u l=0.15u
X17 pre_up.t0 inv_out_up.t4 gnd.t7 gnd.t6 sg13_lv_nmos ad=57f pd=0.68u as=57f ps=0.68u w=0.3u l=0.15u
X18 vp.t7 cVco.t13 inv_out_down.t2 vp.t0 sg13_lv_pmos ad=55.5f pd=0.74u as=55.5f ps=0.74u w=0.15u l=0.13u
X19 vp.t1 pre_up.t5 buf_in_up.t0 vp.t0 sg13_lv_pmos ad=0.1005p pd=1.34u as=55.5f ps=0.74u w=0.15u l=0.15u
X20 2.t0 cRef.t1 gnd.t26 gnd.t25 sg13_lv_nmos ad=55.5f pd=0.74u as=55.5f ps=0.74u w=0.15u l=0.15u
X21 gnd.t9 inv_out_up.t4 pre_up.t0 gnd.t8 sg13_lv_nmos ad=57f pd=0.68u as=57f ps=0.68u w=0.3u l=0.15u
X22 1.t5 cVco.t3 2.t2 gnd.t49 sg13_lv_nmos ad=57f pd=0.68u as=57f ps=0.68u w=0.3u l=0.15u
X23 3.t3 gnd.t57 1.t1 gnd.t61 sg13_lv_nmos ad=57f pd=0.68u as=57f ps=0.68u w=0.3u l=0.15u
X24 pre_up.t2 gnd.t57 3.t4 gnd.t62 sg13_lv_nmos ad=57f pd=0.68u as=57f ps=0.68u w=0.3u l=0.15u
X25 inv_out_up.t0 cRef.t5 gnd.t17 gnd.t16 sg13_lv_nmos ad=55.5f pd=0.74u as=55.5f ps=0.74u w=0.15u l=0.13u
X26 2.t3 gnd.t54 4.t5 gnd.t66 sg13_lv_nmos ad=57f pd=0.68u as=57f ps=0.68u w=0.3u l=0.15u
X27 4.t1 cRef.t2 3.t1 gnd.t24 sg13_lv_nmos ad=57f pd=0.68u as=57f ps=0.68u w=0.3u l=0.15u
X28 vp.t8 cRef.t13 inv_out_up.t2 vp.t0 sg13_lv_pmos ad=55.5f pd=0.74u as=55.5f ps=0.74u w=0.15u l=0.13u
X29 vp.t10 cVco.t10 3.t5 vp.t0 sg13_lv_pmos ad=57f pd=0.68u as=57f ps=0.68u w=0.3u l=0.15u
X30 UP.t0 buf_in_up.t5 vp.t22 vp.t0 sg13_lv_pmos ad=57f pd=0.68u as=0.102p ps=1.28u w=0.3u l=0.15u
X31 3.t2 gnd.t57 gnd.t59 gnd.t58 sg13_lv_nmos ad=57f pd=0.68u as=0.102p ps=1.28u w=0.3u l=0.15u
X32 4.t2 gnd.t70 gnd.t72 gnd.t71 sg13_lv_nmos ad=55.5f pd=0.74u as=0.1005p ps=1.34u w=0.15u l=0.15u
X33 gnd.t26 cVco.t1 4.t2 gnd.t43 sg13_lv_nmos ad=55.5f pd=0.74u as=55.5f ps=0.74u w=0.15u l=0.15u
X34 DOWN.t0 buf_in_down.t5 vp.t14 vp.t0 sg13_lv_pmos ad=57f pd=0.68u as=0.102p ps=1.28u w=0.3u l=0.15u
X35 gnd.t28 cRef.t0 2.t0 gnd.t27 sg13_lv_nmos ad=55.5f pd=0.74u as=55.5f ps=0.74u w=0.15u l=0.15u
X36 2.t4 DOWN.t3 1.t5 gnd.t52 sg13_lv_nmos ad=57f pd=0.68u as=57f ps=0.68u w=0.3u l=0.15u
X37 gnd.t1 pre_up.t3 buf_in_up.t1 gnd.t0 sg13_lv_nmos ad=0.1005p pd=1.34u as=55.5f ps=0.74u w=0.15u l=0.15u
X38 3.t5 cVco.t11 vp.t9 vp.t0 sg13_lv_pmos ad=57f pd=0.68u as=57f ps=0.68u w=0.3u l=0.15u
X39 3.t6 cVco.t9 vp.t13 vp.t0 sg13_lv_pmos ad=57f pd=0.68u as=57f ps=0.68u w=0.3u l=0.15u
X40 buf_in_up.t0 pre_up.t6 vp.t2 vp.t0 sg13_lv_pmos ad=55.5f pd=0.74u as=0.1005p ps=1.34u w=0.15u l=0.15u
X41 gnd.t78 gnd.t76 gnd.t11 gnd.t77 sg13_lv_nmos ad=0.102p pd=1.28u as=0 ps=0 w=0.3u l=0.15u
X42 1.t4 cRef.t10 vp.t10 vp.t0 sg13_lv_pmos ad=57f pd=0.68u as=57f ps=0.68u w=0.3u l=0.15u
X43 vp.t3 buf_in_up.t4 UP.t0 vp.t0 sg13_lv_pmos ad=0.102p pd=1.28u as=57f ps=0.68u w=0.3u l=0.15u
X44 1.t1 cRef.t7 pre_up.t1 gnd.t14 sg13_lv_nmos ad=57f pd=0.68u as=57f ps=0.68u w=0.3u l=0.15u
X45 4.t5 UP.t3 3.t0 gnd.t81 sg13_lv_nmos ad=57f pd=0.68u as=57f ps=0.68u w=0.3u l=0.15u
X46 3.t1 UP.t2 4.t4 gnd.t82 sg13_lv_nmos ad=57f pd=0.68u as=57f ps=0.68u w=0.3u l=0.15u
X47 inv_out_up.t3 cRef.t12 vp.t8 vp.t0 sg13_lv_pmos ad=55.5f pd=0.74u as=55.5f ps=0.74u w=0.15u l=0.13u
X48 1.t3 vp.t23 vp.t24 vp.t0 sg13_lv_pmos ad=57f pd=0.68u as=0.102p ps=1.28u w=0.3u l=0.15u
X49 pre_down.t0 inv_out_down.t4 gnd.t11 gnd.t10 sg13_lv_nmos ad=57f pd=0.68u as=57f ps=0.68u w=0.3u l=0.15u
X50 4.t0 gnd.t54 2.t4 gnd.t65 sg13_lv_nmos ad=57f pd=0.68u as=57f ps=0.68u w=0.3u l=0.15u
X51 inv_out_down.t2 cVco.t13 vp.t18 vp.t0 sg13_lv_pmos ad=55.5f pd=0.74u as=0.1005p ps=1.34u w=0.15u l=0.13u
X52 gnd.t48 cVco.t4 inv_out_down.t1 gnd.t47 sg13_lv_nmos ad=0.1005p pd=1.34u as=55.5f ps=0.74u w=0.15u l=0.13u
X53 gnd.t7 inv_out_down.t4 pre_down.t0 gnd.t12 sg13_lv_nmos ad=57f pd=0.68u as=57f ps=0.68u w=0.3u l=0.15u
X54 buf_in_down.t1 pre_down.t4 gnd.t36 gnd.t35 sg13_lv_nmos ad=55.5f pd=0.74u as=0.1005p ps=1.34u w=0.15u l=0.15u
X55 gnd.t17 cVco.t5 inv_out_down.t0 gnd.t46 sg13_lv_nmos ad=55.5f pd=0.74u as=55.5f ps=0.74u w=0.15u l=0.13u
X56 buf_in_up.t1 pre_up.t4 gnd.t3 gnd.t2 sg13_lv_nmos ad=55.5f pd=0.74u as=0.1005p ps=1.34u w=0.15u l=0.15u
X57 inv_out_down.t3 cVco.t12 vp.t12 vp.t0 sg13_lv_pmos ad=55.5f pd=0.74u as=55.5f ps=0.74u w=0.15u l=0.13u
X58 vp.t26 vp.t25 3.t6 vp.t0 sg13_lv_pmos ad=0.102p pd=1.28u as=57f ps=0.68u w=0.3u l=0.15u
X59 inv_out_up.t2 cRef.t13 vp.t7 vp.t0 sg13_lv_pmos ad=55.5f pd=0.74u as=55.5f ps=0.74u w=0.15u l=0.13u
X60 inv_out_down.t1 cVco.t4 gnd.t22 gnd.t42 sg13_lv_nmos ad=55.5f pd=0.74u as=55.5f ps=0.74u w=0.15u l=0.13u
X61 gnd.t9 gnd.t79 gnd.t9 gnd.t80 sg13_lv_nmos ad=57f pd=0.68u as=0 ps=0 w=0.3u l=0.15u
X62 pre_up.t1 cRef.t8 1.t0 gnd.t13 sg13_lv_nmos ad=57f pd=0.68u as=57f ps=0.68u w=0.3u l=0.15u
X63 3.t4 cVco.t6 pre_down.t2 gnd.t41 sg13_lv_nmos ad=57f pd=0.68u as=57f ps=0.68u w=0.3u l=0.15u
X64 gnd.t64 gnd.t57 1.t2 gnd.t63 sg13_lv_nmos ad=0.102p pd=1.28u as=57f ps=0.68u w=0.3u l=0.15u
X65 2.t1 cVco.t2 1.t6 gnd.t50 sg13_lv_nmos ad=57f pd=0.68u as=57f ps=0.68u w=0.3u l=0.15u
X66 4.t4 gnd.t54 2.t1 gnd.t67 sg13_lv_nmos ad=57f pd=0.68u as=57f ps=0.68u w=0.3u l=0.15u
X67 gnd.t38 pre_down.t3 buf_in_down.t1 gnd.t37 sg13_lv_nmos ad=0.1005p pd=1.34u as=55.5f ps=0.74u w=0.15u l=0.15u
X68 buf_in_down.t0 pre_down.t6 vp.t5 vp.t0 sg13_lv_pmos ad=55.5f pd=0.74u as=0.1005p ps=1.34u w=0.15u l=0.15u
X69 vp.t4 buf_in_down.t4 DOWN.t0 vp.t0 sg13_lv_pmos ad=0.102p pd=1.28u as=57f ps=0.68u w=0.3u l=0.15u
X70 1.t0 gnd.t57 pre_down.t1 gnd.t60 sg13_lv_nmos ad=57f pd=0.68u as=57f ps=0.68u w=0.3u l=0.15u
X71 inv_out_down.t0 cVco.t5 gnd.t45 gnd.t44 sg13_lv_nmos ad=55.5f pd=0.74u as=0.1005p ps=1.34u w=0.15u l=0.13u
X72 vp.t9 cRef.t11 1.t3 vp.t0 sg13_lv_pmos ad=57f pd=0.68u as=57f ps=0.68u w=0.3u l=0.15u
X73 gnd.t34 buf_in_down.t2 DOWN.t1 gnd.t33 sg13_lv_nmos ad=0.102p pd=1.28u as=57f ps=0.68u w=0.3u l=0.15u
X74 gnd.t5 buf_in_up.t2 UP.t1 gnd.t4 sg13_lv_nmos ad=0.102p pd=1.28u as=57f ps=0.68u w=0.3u l=0.15u
X75 gnd.t22 cRef.t4 inv_out_up.t1 gnd.t21 sg13_lv_nmos ad=55.5f pd=0.74u as=55.5f ps=0.74u w=0.15u l=0.13u
R0 UP.n1 UP.t0 27.4077
R1 UP.n1 UP.t1 26.7345
R2 UP.n0 UP.t3 13.8556
R3 UP.n0 UP.t2 12.9062
R4 UP.n2 UP.n0 7.3925
R5 UP.n2 UP.n1 4.6105
R6 UP UP.n2 0.4955
R7 DOWN.n1 DOWN.t0 27.6057
R8 DOWN.n1 DOWN.t1 26.5365
R9 DOWN.n0 DOWN.t3 13.5517
R10 DOWN.n0 DOWN.t2 12.5864
R11 DOWN.n2 DOWN.n0 6.1297
R12 DOWN.n2 DOWN.n1 4.6105
R13 DOWN DOWN.n2 2.4535
R14 cVco.n8 cVco.t2 15.1154
R15 cVco.n6 cVco.t13 13.7764
R16 cVco.n10 cVco.t5 13.7033
R17 cVco.n5 cVco.t9 13.3235
R18 cVco.n8 cVco.t3 13.1647
R19 cVco.n3 cVco.t1 12.319
R20 cVco.n2 cVco.t0 12.319
R21 cVco.n6 cVco.t12 12.2628
R22 cVco.n10 cVco.t4 12.1985
R23 cVco.n2 cVco.n1 12.1786
R24 cVco.n1 cVco.t8 12.1334
R25 cVco.n0 cVco.t7 7.78978
R26 cVco.n0 cVco.t6 7.72692
R27 cVco.n4 cVco.t10 7.64764
R28 cVco.n4 cVco.t11 7.64409
R29 cVco.n9 cVco.n7 6.5993
R30 cVco cVco.n11 6.53293
R31 cVco.n9 cVco.n8 5.0373
R32 cVco.n11 cVco.n10 5.0109
R33 cVco.n5 cVco.n4 4.5005
R34 cVco.n1 cVco.n0 4.2721
R35 cVco.n11 cVco.n9 1.8925
R36 cVco.n7 cVco.n5 1.1313
R37 cVco.n3 cVco.n2 0.664167
R38 cVco.n7 cVco.n6 0.5461
R39 cVco cVco.n3 0.281
R40 cRef.n8 cRef.t2 15.068
R41 cRef.n8 cRef.t3 13.4603
R42 cRef.n1 cRef.t6 13.2975
R43 cRef.n3 cRef.n1 13.0099
R44 cRef.n10 cRef.t5 12.5186
R45 cRef.n6 cRef.t13 12.5184
R46 cRef.n4 cRef.t9 12.3178
R47 cRef.n4 cRef.t10 12.0802
R48 cRef.n5 cRef.t11 12.0802
R49 cRef.n10 cRef.t4 12.017
R50 cRef.n6 cRef.t12 12.0168
R51 cRef.n2 cRef.t1 7.6859
R52 cRef.n2 cRef.t0 7.67542
R53 cRef.n0 cRef.t7 7.6703
R54 cRef.n0 cRef.t8 7.65982
R55 cRef cRef.n11 6.4442
R56 cRef.n9 cRef.n7 5.8425
R57 cRef.n11 cRef.n10 5.6357
R58 cRef.n9 cRef.n8 5.5961
R59 cRef.n3 cRef.n2 4.5005
R60 cRef.n1 cRef.n0 3.0005
R61 cRef.n11 cRef.n9 1.9717
R62 cRef.n7 cRef.n6 1.1445
R63 cRef.n7 cRef.n5 0.7001
R64 cRef.n5 cRef.n4 0.6957
R65 cRef cRef.n3 0.625667
R66 vp.n38 vp.t9 31.6973
R67 vp.n19 vp.t10 31.6973
R68 vp.n44 vp.t13 31.6973
R69 vp.n33 vp.t20 31.6973
R70 vp.n26 vp.t7 31.6973
R71 vp.n32 vp.t12 31.6973
R72 vp.n23 vp.t8 31.6973
R73 vp.n25 vp.t18 31.6973
R74 vp.n1 vp.t3 18.0658
R75 vp.n5 vp.t5 18.0317
R76 vp.n7 vp.t6 18.0317
R77 vp.n12 vp.t2 18.0317
R78 vp.n13 vp.t1 18.0317
R79 vp.n9 vp.t14 17.9767
R80 vp.n10 vp.t4 17.9767
R81 vp.n2 vp.t22 17.9767
R82 vp.n18 vp.t26 17.0005
R83 vp.n21 vp.t24 17.0005
R84 vp.n45 vp.n18 14.6973
R85 vp.n37 vp.n21 14.6973
R86 vp.n18 vp.t25 7.79705
R87 vp.n21 vp.t23 7.72833
R88 vp.n25 vp.n24 4.58055
R89 vp.n27 vp.n26 4.5005
R90 vp.n34 vp.n33 4.5005
R91 vp.n37 vp.n36 4.5005
R92 vp.n39 vp.n38 4.5005
R93 vp.n41 vp.n19 4.5005
R94 vp.n46 vp.n45 4.5005
R95 vp.n44 vp.n43 4.5005
R96 vp.n32 vp.n31 4.5005
R97 vp.n29 vp.n23 4.5005
R98 vp.n47 vp.n16 3.37627
R99 vp.n15 vp.n6 2.80696
R100 vp.n15 vp.n8 2.80696
R101 vp.n15 vp.n4 2.80696
R102 vp.n15 vp.n14 2.80696
R103 vp.n15 vp.n3 2.80696
R104 vp.n17 vp.n16 2.80696
R105 vp.n42 vp.n16 2.80696
R106 vp.n40 vp.n16 2.80696
R107 vp.n20 vp.n16 2.80696
R108 vp.n30 vp.n16 2.80696
R109 vp.n28 vp.n16 2.80696
R110 vp.n15 vp.n11 2.08777
R111 vp.n22 vp.n16 2.08777
R112 vp.n15 vp.n1 1.85103
R113 vp.n24 vp.n16 1.66333
R114 vp.n35 vp.n16 1.65246
R115 vp vp.n0 0.935452
R116 vp.n5 vp.n0 0.550549
R117 vp.n16 vp.t0 0.247877
R118 vp.n15 vp.n0 0.210867
R119 vp.t0 vp.n15 0.184296
R120 vp.n35 vp.n34 0.167359
R121 vp.n33 vp.n32 0.143814
R122 vp.n32 vp.n23 0.143814
R123 vp.n26 vp.n23 0.143814
R124 vp.n26 vp.n25 0.143814
R125 vp.n36 vp.n35 0.139265
R126 vp.n45 vp.n44 0.133757
R127 vp.n44 vp.n19 0.133757
R128 vp.n38 vp.n19 0.133757
R129 vp.n38 vp.n37 0.133757
R130 vp.n27 vp.n24 0.130234
R131 vp.n3 vp.n2 0.124623
R132 vp.n14 vp.n13 0.124623
R133 vp.n10 vp.n4 0.123129
R134 vp.n31 vp.n30 0.123129
R135 vp.n9 vp.n8 0.120956
R136 vp.n7 vp.n6 0.120956
R137 vp.n34 vp.n22 0.113993
R138 vp.n36 vp.n20 0.111789
R139 vp.n28 vp.n27 0.109956
R140 vp.n2 vp.n1 0.106995
R141 vp.n46 vp.n17 0.106629
R142 vp.n40 vp.n39 0.104456
R143 vp.n29 vp.n28 0.101129
R144 vp.n11 vp.n9 0.0993266
R145 vp.n43 vp.n42 0.0992959
R146 vp.n6 vp.n5 0.0974625
R147 vp.n42 vp.n41 0.0971227
R148 vp.n11 vp.n10 0.0967242
R149 vp.n31 vp.n22 0.0967242
R150 vp.n12 vp.n4 0.0952893
R151 vp.n14 vp.n12 0.0937958
R152 vp.n41 vp.n40 0.0919625
R153 vp.n43 vp.n17 0.0897893
R154 vp vp.n47 0.0889687
R155 vp.n30 vp.n29 0.087956
R156 vp.n39 vp.n20 0.0846292
R157 vp.n47 vp.n46 0.0701389
R158 vp.n8 vp.n7 0.0681292
R159 vp.n13 vp.n3 0.0644625
R160 gnd.n91 gnd.t35 295.875
R161 gnd.n124 gnd.t55 293.478
R162 gnd.n88 gnd.n87 198.002
R163 gnd.t55 gnd.t49 144.023
R164 gnd.n77 gnd.t29 94.79
R165 gnd.n38 gnd.t31 94.79
R166 gnd.t68 gnd.n104 94.79
R167 gnd.t58 gnd.n103 92.3918
R168 gnd.t15 gnd.n92 89.6744
R169 gnd.t65 gnd.n115 89.6744
R170 gnd.n107 gnd.t82 86.957
R171 gnd.n96 gnd.t41 84.2396
R172 gnd.t6 gnd.n97 84.2396
R173 gnd.n117 gnd.t71 84.2396
R174 gnd.n15 gnd.t21 84.2396
R175 gnd.t27 gnd.n111 81.5222
R176 gnd.n20 gnd.t16 81.5222
R177 gnd.n110 gnd.t50 76.0875
R178 gnd.t80 gnd.n94 73.3701
R179 gnd.n99 gnd.t61 73.3701
R180 gnd.n20 gnd.t46 73.3701
R181 gnd.t0 gnd.n77 73.0508
R182 gnd.n38 gnd.t37 73.0508
R183 gnd.t18 gnd.n15 70.6527
R184 gnd.n124 gnd.t47 67.9353
R185 gnd.n113 gnd.t66 65.2179
R186 gnd.n101 gnd.t13 62.5005
R187 gnd.n14 gnd.t42 61.5279
R188 gnd.n18 gnd.t20 58.8105
R189 gnd.t67 gnd.n107 57.0657
R190 gnd.t25 gnd.n113 57.0657
R191 gnd.t62 gnd.n93 56.0931
R192 gnd.n92 gnd.t63 54.3483
R193 gnd.t77 gnd.n101 54.3483
R194 gnd.n109 gnd.t74 54.3483
R195 gnd.t53 gnd.t51 54.3483
R196 gnd.n115 gnd.t23 54.3483
R197 gnd.n85 gnd.t4 54.034
R198 gnd.n88 gnd.t33 53.9815
R199 gnd.t4 gnd.n75 53.3757
R200 gnd.t33 gnd.n36 53.3757
R201 gnd.t24 gnd.n105 53.3757
R202 gnd.n106 gnd.t24 53.3757
R203 gnd.n87 gnd.t2 51.6309
R204 gnd.n103 gnd.t39 51.6309
R205 gnd.n118 gnd.t52 50.6584
R206 gnd.t52 gnd.n117 48.9135
R207 gnd.t35 gnd.n90 47.9416
R208 gnd.n78 gnd.t2 47.9409
R209 gnd.t39 gnd.n102 47.9409
R210 gnd.t20 gnd.n17 47.9409
R211 gnd.t63 gnd.n91 45.8769
R212 gnd.n132 gnd.t42 45.4151
R213 gnd.n94 gnd.t62 43.4788
R214 gnd.t12 gnd.n99 43.4788
R215 gnd.t43 gnd.n114 39.7888
R216 gnd.t74 gnd.n108 38.044
R217 gnd.n108 gnd.t67 35.3266
R218 gnd.n90 gnd.t37 34.354
R219 gnd.n78 gnd.t0 34.354
R220 gnd.t8 gnd.n96 32.6092
R221 gnd.n97 gnd.t40 32.6092
R222 gnd.n29 gnd.t22 31.642
R223 gnd.n23 gnd.t48 31.642
R224 gnd.n24 gnd.t45 31.642
R225 gnd.n26 gnd.t17 31.642
R226 gnd.n28 gnd.t19 31.642
R227 gnd.n142 gnd.t28 31.5749
R228 gnd.n141 gnd.t26 31.5749
R229 gnd.n44 gnd.t7 31.4436
R230 gnd.n100 gnd.t14 28.9199
R231 gnd.n17 gnd.t18 28.9192
R232 gnd.t40 gnd.t8 27.1744
R233 gnd.t14 gnd.t12 27.1744
R234 gnd.t13 gnd.t10 27.1744
R235 gnd.t60 gnd.t77 27.1744
R236 gnd.t66 gnd.n112 27.1744
R237 gnd.n19 gnd.t44 26.7512
R238 gnd.t46 gnd.n19 26.5095
R239 gnd.n111 gnd.t53 24.457
R240 gnd.n133 gnd.t47 24.457
R241 gnd.t81 gnd.t25 21.7396
R242 gnd.n114 gnd.t81 20.7677
R243 gnd.n95 gnd.t80 19.0222
R244 gnd.t61 gnd.n98 19.0222
R245 gnd.n102 gnd.t60 18.0496
R246 gnd.t16 gnd.n18 18.0496
R247 gnd.n49 gnd.t59 17.8464
R248 gnd.n39 gnd.t64 17.8307
R249 gnd.n73 gnd.t34 17.7121
R250 gnd.n72 gnd.t32 17.7121
R251 gnd.n84 gnd.t5 17.7121
R252 gnd.n82 gnd.t30 17.7121
R253 gnd.n69 gnd.t36 17.6074
R254 gnd.n70 gnd.t38 17.5608
R255 gnd.n80 gnd.t1 17.5608
R256 gnd.n79 gnd.t3 17.5608
R257 gnd.n50 gnd.t69 17.2601
R258 gnd.n5 gnd.t56 17.2601
R259 gnd.n2 gnd.t75 17.2205
R260 gnd.n4 gnd.t72 17.2067
R261 gnd.t9 gnd.n41 17.1629
R262 gnd.n43 gnd.t9 17.1629
R263 gnd.n46 gnd.t11 17.1629
R264 gnd.n48 gnd.t78 17.1629
R265 gnd.n134 gnd.n133 17.0005
R266 gnd.t50 gnd.n109 16.3048
R267 gnd.t49 gnd.n118 15.3329
R268 gnd.t21 gnd.n14 15.3322
R269 gnd.n57 gnd.n46 14.2812
R270 gnd.n56 gnd.n48 14.2812
R271 gnd.n64 gnd.n41 14.2777
R272 gnd.n63 gnd.n43 14.2777
R273 gnd.t51 gnd.n110 13.5875
R274 gnd.t29 gnd.n75 12.6148
R275 gnd.t31 gnd.n36 12.6148
R276 gnd.n105 gnd.t68 12.6148
R277 gnd.t82 gnd.n106 12.6148
R278 gnd.n112 gnd.t27 10.8701
R279 gnd.t10 gnd.n100 9.89749
R280 gnd.n93 gnd.t15 9.89744
R281 gnd.n131 gnd.n13 8.52304
R282 gnd.n133 gnd.n8 8.501
R283 gnd.n133 gnd.n9 8.501
R284 gnd.n125 gnd.n124 8.501
R285 gnd.n133 gnd.n11 8.501
R286 gnd.n124 gnd.n123 8.501
R287 gnd.n124 gnd.n7 8.501
R288 gnd.n87 gnd.n86 8.5005
R289 gnd.n131 gnd.n20 8.5005
R290 gnd.n131 gnd.n15 8.5005
R291 gnd.n129 gnd.n128 8.5005
R292 gnd.n127 gnd.n126 8.5005
R293 gnd.n34 gnd.n33 8.5005
R294 gnd.n122 gnd.n121 8.5005
R295 gnd.n120 gnd.n119 8.5005
R296 gnd.n10 gnd.n6 8.5005
R297 gnd.n135 gnd.n134 8.5005
R298 gnd.n117 gnd.n1 8.5005
R299 gnd.n116 gnd.n1 8.5005
R300 gnd.n115 gnd.n1 8.5005
R301 gnd.n110 gnd.n1 8.5005
R302 gnd.n109 gnd.n1 8.5005
R303 gnd.n108 gnd.n1 8.5005
R304 gnd.n107 gnd.n1 8.5005
R305 gnd.n103 gnd.n1 8.5005
R306 gnd.n92 gnd.n1 8.5005
R307 gnd.n94 gnd.n1 8.5005
R308 gnd.n40 gnd.n1 8.5005
R309 gnd.n95 gnd.n1 8.5005
R310 gnd.n96 gnd.n1 8.5005
R311 gnd.n97 gnd.n1 8.5005
R312 gnd.n98 gnd.n1 8.5005
R313 gnd.n99 gnd.n1 8.5005
R314 gnd.n101 gnd.n1 8.5005
R315 gnd.n111 gnd.n1 8.5005
R316 gnd.n112 gnd.n1 8.5005
R317 gnd.n113 gnd.n1 8.5005
R318 gnd.t41 gnd.n95 8.15267
R319 gnd.n98 gnd.t6 8.15267
R320 gnd.t71 gnd.n116 8.15267
R321 gnd.n104 gnd.t58 7.83344
R322 gnd.n2 gnd.t73 7.5589
R323 gnd.n4 gnd.t70 7.5589
R324 gnd.n42 gnd.t79 7.53301
R325 gnd.n47 gnd.t76 7.53301
R326 gnd.t57 gnd.n39 7.47438
R327 gnd.n50 gnd.t54 7.47438
R328 gnd.t54 gnd.n5 7.47438
R329 gnd.n49 gnd.t57 7.46996
R330 gnd.t23 gnd.t43 5.43528
R331 gnd.n133 gnd.n132 4.91444
R332 gnd.n24 gnd.n21 4.6148
R333 gnd.n28 gnd.n27 4.5005
R334 gnd.n26 gnd.n25 4.5005
R335 gnd.n30 gnd.n29 4.5005
R336 gnd.n23 gnd.n13 4.5005
R337 gnd.n141 gnd.n140 4.5005
R338 gnd.n58 gnd.n57 4.5005
R339 gnd.n60 gnd.n44 4.5005
R340 gnd.n63 gnd.n62 4.5005
R341 gnd.n65 gnd.n64 4.5005
R342 gnd.n56 gnd.n55 4.5005
R343 gnd.n143 gnd.n142 4.5005
R344 gnd.n89 gnd.n35 4.25187
R345 gnd.n124 gnd.n12 4.251
R346 gnd.n131 gnd.n130 4.2357
R347 gnd.n131 gnd.n31 4.23547
R348 gnd.n45 gnd.n1 4.23547
R349 gnd.n146 gnd.n1 4.23547
R350 gnd.n51 gnd.n50 3.04791
R351 gnd.n136 gnd.n5 3.04791
R352 gnd.n53 gnd.n49 3.00855
R353 gnd.n67 gnd.n39 2.99291
R354 gnd.n85 gnd.n84 2.91432
R355 gnd.n89 gnd.n71 2.80696
R356 gnd.n86 gnd.n76 2.80696
R357 gnd.n86 gnd.n83 2.80696
R358 gnd.n89 gnd.n37 2.80696
R359 gnd.n89 gnd.n74 2.80696
R360 gnd.n131 gnd.n16 2.80696
R361 gnd.n131 gnd.n22 2.80696
R362 gnd.n139 gnd.n1 2.80696
R363 gnd.n68 gnd.n1 2.80696
R364 gnd.n61 gnd.n1 2.80696
R365 gnd.n59 gnd.n1 2.80696
R366 gnd.n54 gnd.n1 2.80696
R367 gnd.n52 gnd.n1 2.80696
R368 gnd.n1 gnd.n0 2.80696
R369 gnd.n3 gnd.n1 2.80696
R370 gnd.n137 gnd.n1 2.80691
R371 gnd.n116 gnd.t65 2.71789
R372 gnd.n86 gnd.n81 2.08786
R373 gnd.n144 gnd.n1 2.08777
R374 gnd.n131 gnd.n21 2.08773
R375 gnd.n66 gnd.n1 1.65246
R376 gnd.n69 gnd.n68 1.06185
R377 gnd.n138 gnd.n4 0.856437
R378 gnd.n145 gnd.n2 0.842688
R379 gnd.n90 gnd.n89 0.661721
R380 gnd.n118 gnd.n1 0.661721
R381 gnd.n100 gnd.n1 0.661721
R382 gnd.n114 gnd.n1 0.661721
R383 gnd.n86 gnd.n78 0.661473
R384 gnd.n86 gnd.n75 0.661473
R385 gnd.n89 gnd.n36 0.661473
R386 gnd.n131 gnd.n18 0.661473
R387 gnd.n131 gnd.n17 0.661473
R388 gnd.n131 gnd.n14 0.661473
R389 gnd.n106 gnd.n1 0.661473
R390 gnd.n105 gnd.n1 0.661473
R391 gnd.n93 gnd.n1 0.661473
R392 gnd.n102 gnd.n1 0.661473
R393 gnd.n132 gnd.n131 0.453347
R394 gnd.n131 gnd.n19 0.349794
R395 gnd.n137 gnd.n136 0.215375
R396 gnd.n136 gnd.n135 0.18475
R397 gnd.n142 gnd.n141 0.148843
R398 gnd.n67 gnd.n66 0.148432
R399 gnd.n29 gnd.n23 0.143814
R400 gnd.n29 gnd.n28 0.143814
R401 gnd.n28 gnd.n26 0.143814
R402 gnd.n26 gnd.n24 0.143814
R403 gnd.n43 gnd.n42 0.143238
R404 gnd.n48 gnd.n47 0.143238
R405 gnd.n42 gnd.n41 0.13931
R406 gnd.n47 gnd.n46 0.13931
R407 gnd.n57 gnd.n44 0.133757
R408 gnd.n63 gnd.n44 0.1325
R409 gnd.n66 gnd.n65 0.127026
R410 gnd.n143 gnd.n3 0.124963
R411 gnd.n145 gnd.n144 0.12316
R412 gnd.n25 gnd.n16 0.123129
R413 gnd.n139 gnd.n138 0.122789
R414 gnd.n79 gnd.n35 0.11777
R415 gnd.n74 gnd.n72 0.115796
R416 gnd.n70 gnd.n37 0.115796
R417 gnd.n83 gnd.n82 0.115796
R418 gnd.n80 gnd.n76 0.115796
R419 gnd.n51 gnd.n0 0.115796
R420 gnd.n81 gnd.n79 0.113931
R421 gnd.n59 gnd.n58 0.113623
R422 gnd.n54 gnd.n53 0.111789
R423 gnd.n30 gnd.n22 0.109956
R424 gnd gnd.n0 0.109039
R425 gnd.n61 gnd.n60 0.106289
R426 gnd.n81 gnd.n80 0.104032
R427 gnd.n55 gnd.n54 0.102963
R428 gnd.n68 gnd.n67 0.102623
R429 gnd.n27 gnd.n22 0.101129
R430 gnd.n25 gnd.n21 0.096904
R431 gnd.n140 gnd.n139 0.0956292
R432 gnd.n130 gnd.n129 0.0953079
R433 gnd.n144 gnd.n143 0.0948909
R434 gnd.n140 gnd.n3 0.093456
R435 gnd.n62 gnd.n61 0.0882959
R436 gnd.n27 gnd.n16 0.087956
R437 gnd.n60 gnd.n59 0.0827958
R438 gnd.n74 gnd.n73 0.0806227
R439 gnd.n84 gnd.n83 0.0806227
R440 gnd.n71 gnd.n69 0.0789607
R441 gnd.n53 gnd.n52 0.0772959
R442 gnd.n71 gnd.n70 0.0735339
R443 gnd.n72 gnd.n37 0.0732893
R444 gnd.n82 gnd.n76 0.0732893
R445 gnd.n52 gnd.n51 0.0732893
R446 gnd.n32 gnd.n31 0.0705528
R447 gnd.n64 gnd.n63 0.0671286
R448 gnd.n57 gnd.n56 0.0671286
R449 gnd.n73 gnd.n35 0.0664419
R450 gnd.n138 gnd.n137 0.0663661
R451 gnd.n146 gnd.n145 0.0659695
R452 gnd.n130 gnd.n32 0.0633784
R453 gnd.n129 gnd.n127 0.0628333
R454 gnd.n127 gnd.n33 0.0628333
R455 gnd.n121 gnd.n33 0.0628333
R456 gnd.n121 gnd.n120 0.0628333
R457 gnd.n120 gnd.n6 0.0628333
R458 gnd.n135 gnd.n6 0.0628333
R459 gnd.n65 gnd.n40 0.0600833
R460 gnd.n55 gnd.n45 0.0549695
R461 gnd.n89 gnd.n88 0.0526709
R462 gnd gnd.n146 0.0485528
R463 gnd.n31 gnd.n30 0.0476361
R464 gnd.n58 gnd.n45 0.0439695
R465 gnd.n62 gnd.n40 0.0380833
R466 gnd.n32 gnd.n13 0.00861475
R467 gnd.n91 gnd.n1 0.00507852
R468 gnd.n86 gnd.n77 0.00504252
R469 gnd.n89 gnd.n38 0.00504252
R470 gnd.n104 gnd.n1 0.00504252
R471 gnd.n128 gnd.n12 0.00175
R472 gnd.n131 gnd.n12 0.00124998
R473 gnd.n86 gnd.n85 0.00116605
R474 gnd.n128 gnd.n8 0.001
R475 gnd.n125 gnd.n34 0.001
R476 gnd.n34 gnd.n9 0.001
R477 gnd.n123 gnd.n119 0.001
R478 gnd.n119 gnd.n11 0.001
R479 gnd.n134 gnd.n7 0.001
R480 gnd.n126 gnd.n8 0.001
R481 gnd.n126 gnd.n125 0.001
R482 gnd.n122 gnd.n9 0.001
R483 gnd.n123 gnd.n122 0.001
R484 gnd.n11 gnd.n10 0.001
R485 gnd.n10 gnd.n7 0.001
R486 4.t3 4.n3 22.1723
R487 4 4.n3 0.557833
R488 4.n3 4.n0 11.4399
R489 4 4.n1 0.593528
R490 4.n1 4.n2 8.89047
R491 4.n2 4.t0 17.6419
R492 4.n2 4.t5 17.6669
R493 4.n1 4.t2 21.8846
R494 4.n0 4.t4 17.6217
R495 4.n0 4.t1 17.6427
R496 2.t0 2 26.9819
R497 2 2.n2 4.5005
R498 2.n2 2.n1 0.623833
R499 2.n2 2.n0 0.1545
R500 2.n1 2.t2 22.4872
R501 2.n1 2.t4 22.1117
R502 2.n0 2.t3 22.1117
R503 2.n0 2.t1 22.5004
R504 buf_in_up.t0 buf_in_up.n0 26.7185
R505 buf_in_up buf_in_up.n0 5.0021
R506 buf_in_up buf_in_up.n3 4.9405
R507 buf_in_up.n3 buf_in_up.n2 0.13669
R508 buf_in_up.n3 buf_in_up.n1 0.141929
R509 buf_in_up.n2 buf_in_up.t3 8.8888
R510 buf_in_up.n2 buf_in_up.t5 7.83692
R511 buf_in_up.n1 buf_in_up.t2 8.8888
R512 buf_in_up.n1 buf_in_up.t4 7.83692
R513 buf_in_up.n0 buf_in_up.t1 27.5045
R514 pre_up.t0 pre_up.n4 22.2011
R515 pre_up.n4 pre_up.t1 32.2641
R516 pre_up pre_up.n4 0.3833
R517 pre_up pre_up.n0 0.3085
R518 pre_up.n0 pre_up.n3 29.1885
R519 pre_up.n3 pre_up.n2 0.131452
R520 pre_up.n3 pre_up.n1 0.147167
R521 pre_up.n2 pre_up.t4 8.68255
R522 pre_up.n2 pre_up.t6 8.1463
R523 pre_up.n1 pre_up.t3 8.68255
R524 pre_up.n1 pre_up.t5 8.1463
R525 pre_up.n0 pre_up.t2 31.7706
R526 buf_in_down.t0 buf_in_down.n0 26.7185
R527 buf_in_down buf_in_down.n0 5.0263
R528 buf_in_down buf_in_down.n3 4.9163
R529 buf_in_down.n3 buf_in_down.n2 0.13669
R530 buf_in_down.n3 buf_in_down.n1 0.141929
R531 buf_in_down.n2 buf_in_down.t3 8.8888
R532 buf_in_down.n2 buf_in_down.t5 7.83692
R533 buf_in_down.n1 buf_in_down.t2 8.8888
R534 buf_in_down.n1 buf_in_down.t4 7.83692
R535 buf_in_down.n0 buf_in_down.t1 27.5045
R536 pre_down.t0 pre_down.n4 22.6686
R537 pre_down.n4 pre_down.t1 31.9693
R538 pre_down pre_down.n4 0.2953
R539 pre_down pre_down.n0 0.3613
R540 pre_down.n0 pre_down.n3 17.6893
R541 pre_down.n3 pre_down.n2 0.13669
R542 pre_down.n3 pre_down.n1 0.141929
R543 pre_down.n2 pre_down.t4 8.68255
R544 pre_down.n2 pre_down.t6 8.1463
R545 pre_down.n1 pre_down.t3 8.68255
R546 pre_down.n1 pre_down.t5 8.1463
R547 pre_down.n0 pre_down.t2 31.4714
R548 3.n4 3.t4 27.6717
R549 3.n4 3.t3 27.7773
R550 3.n0 3.n4 3.67484
R551 3.n1 3.n2 2.2505
R552 3 3.n1 0.314786
R553 3.n1 3.n0 1.29724
R554 3 3.n3 5.30696
R555 3.n3 3.t0 27.6578
R556 3.n3 3.t5 26.8975
R557 3.n2 3.t1 27.9049
R558 3.n2 3.t6 27.1665
R559 3.n0 3.t2 32.0038
R560 1.n0 1.t2 33.2861
R561 1.n1 1.n0 0.428588
R562 1.n2 1.n1 2.47019
R563 1 1.n2 0.608344
R564 1 1.n4 5.11714
R565 1.n4 1.t5 27.8301
R566 1.n4 1.t3 26.8585
R567 1.n2 1.n3 4.50214
R568 1.n3 1.t4 26.8337
R569 1.n3 1.t6 27.7362
R570 1.n1 1.t0 32.2553
R571 1.n0 1.t1 32.2245
R572 inv_out_up.t1 inv_out_up.n2 26.0948
R573 inv_out_up.n0 inv_out_up.n2 2.9573
R574 inv_out_up.n0 inv_out_up.n1 3.0365
R575 inv_out_up.n1 inv_out_up.t0 26.0948
R576 inv_out_up.n1 inv_out_up.t2 28.5129
R577 inv_out_up inv_out_up.n0 8.1553
R578 inv_out_up inv_out_up.t4 22.184
R579 inv_out_up.n2 inv_out_up.t3 28.5129
R580 inv_out_down.t1 inv_out_down.n2 26.0948
R581 inv_out_down.n1 inv_out_down.n2 7.45667
R582 inv_out_down.n1 inv_out_down.n0 8.9489
R583 inv_out_down inv_out_down.n1 4.7349
R584 inv_out_down inv_out_down.t4 22.3776
R585 inv_out_down.n0 inv_out_down.t0 26.0948
R586 inv_out_down.n0 inv_out_down.t2 28.5129
R587 inv_out_down.n2 inv_out_down.t3 28.5129
C0 UP 1 0.12649f
C1 cVco pre_up 0.059f
C2 inv_out_down cRef 0.09353f
C3 vp 3 1.64522f
C4 1 cVco 0.12526f
C5 pre_down cRef 0.15323f
C6 inv_out_down pre_up 0.02787f
C7 4 DOWN 0.043f
C8 UP vp 0.30253f
C9 vp buf_in_up 0.51886f
C10 4 2 1.21831f
C11 DOWN cRef 0.20837f
C12 2 cRef 0.21605f
C13 pre_down pre_up 1.32182f
C14 vp cVco 3.0475f
C15 pre_down buf_in_down 0.67429f
C16 DOWN pre_up 0.20992f
C17 pre_down 1 0.3782f
C18 buf_in_down DOWN 0.30051f
C19 inv_out_up cRef 0.28634f
C20 UP 3 0.36333f
C21 1 DOWN 0.2703f
C22 vp inv_out_down 1.35068f
C23 4 cRef 0.32234f
C24 1 2 0.16434f
C25 inv_out_up pre_up 0.07153f
C26 cVco 3 0.14535f
C27 pre_down vp 0.22493f
C28 UP buf_in_up 0.37186f
C29 vp DOWN 0.28586f
C30 pre_up cRef 0.15565f
C31 UP cVco 0.4404f
C32 1 cRef 0.64558f
C33 pre_down 3 1.10366f
C34 buf_in_down pre_up 0.66682f
C35 vp inv_out_up 1.34868f
C36 1 pre_up 1.24368f
C37 3 DOWN 0.26423f
C38 1 buf_in_down 0.01342f
C39 UP pre_down 0.11866f
C40 inv_out_down cVco 0.57865f
C41 vp cRef 1.60509f
C42 UP DOWN 4.03279f
C43 DOWN buf_in_up 0.18842f
C44 pre_down cVco 0.51147f
C45 vp pre_up 0.38135f
C46 vp buf_in_down 0.5034f
C47 4 3 0.28396f
C48 cVco DOWN 0.52248f
C49 vp 1 2.04249f
C50 3 cRef 1.02641f
C51 cVco 2 0.03249f
C52 pre_down inv_out_down 0.05284f
C53 UP 4 0.05375f
C54 3 pre_up 0.36921f
C55 cVco inv_out_up 0.27776f
C56 UP cRef 0.57433f
C57 4 cVco 0.04891f
C58 1 3 4.12578f
C59 pre_down DOWN 0.17332f
C60 cVco cRef 8.76896f
C61 UP pre_up 0.16441f
C62 pre_up buf_in_up 0.41886f
C63 inv_out_down inv_out_up 3.46692f
C64 UP buf_in_down 0.1188f
C65 buf_in_down buf_in_up 0.01452f
C66 2 DOWN 0.06369f
C67 UP gnd 1.3497f
C68 DOWN gnd 1.7569f
C69 cVco gnd 5.73524f
C70 cRef gnd 3.75258f
C71 vp gnd 1.19842f
C72 4 gnd 1.8602f
C73 2 gnd 1.69792f
C74 buf_in_up gnd 1.11764f
C75 pre_up gnd 1.72604f
C76 buf_in_down gnd 1.07521f
C77 pre_down gnd 1.51841f
C78 3 gnd 1.17975f
C79 1 gnd 1.18146f
C80 inv_out_up gnd 6.51442f
C81 inv_out_down gnd 6.05461f
C82 inv_out_down.t1 gnd 0.09746f
C83 inv_out_down.t3 gnd 0.13431f
C84 inv_out_down.t2 gnd 0.13431f
C85 inv_out_down.t0 gnd 0.09746f
C86 inv_out_down.n0 gnd 1.39609f
C87 inv_out_down.t4 gnd 0.37399f
C88 inv_out_down.n1 gnd 1.07123f
C89 inv_out_down.n2 gnd 1.3438f
C90 inv_out_up.t1 gnd 0.09723f
C91 inv_out_up.t3 gnd 0.134f
C92 inv_out_up.t4 gnd 0.36226f
C93 inv_out_up.n0 gnd 1.16483f
C94 inv_out_up.t2 gnd 0.134f
C95 inv_out_up.t0 gnd 0.09723f
C96 inv_out_up.n1 gnd 1.12453f
C97 inv_out_up.n2 gnd 1.11715f
C98 1.t2 gnd 0.3646f
C99 1.n0 gnd 2.05534f
C100 1.t1 gnd 0.33265f
C101 1.n1 gnd 1.32922f
C102 1.t0 gnd 0.33335f
C103 1.n2 gnd 0.55141f
C104 1.n3 gnd 1.58311f
C105 1.t4 gnd 0.17763f
C106 1.t6 gnd 0.20361f
C107 1.t3 gnd 0.17817f
C108 1.t5 gnd 0.20438f
C109 1.n4 gnd 1.52901f
C110 3.t4 gnd 0.2155f
C111 3.n0 gnd 1.5919f
C112 3.t2 gnd 0.34366f
C113 3.n1 gnd 0.32585f
C114 3.t6 gnd 0.19977f
C115 3.t1 gnd 0.22325f
C116 3.n2 gnd 1.74366f
C117 3.t5 gnd 0.19293f
C118 3.t0 gnd 0.21468f
C119 3.n3 gnd 1.64621f
C120 3.n4 gnd 2.06045f
C121 3.t3 gnd 0.21879f
C122 pre_down.t0 gnd 0.12591f
C123 pre_down.t1 gnd 0.2259f
C124 pre_down.n0 gnd 1.46478f
C125 pre_down.t2 gnd 0.21722f
C126 pre_down.t3 gnd 0.15034f
C127 pre_down.t5 gnd 0.14327f
C128 pre_down.n1 gnd 0.33404f
C129 pre_down.t4 gnd 0.15034f
C130 pre_down.t6 gnd 0.14327f
C131 pre_down.n2 gnd 0.33467f
C132 pre_down.n3 gnd 0.4708f
C133 pre_down.n4 gnd 0.8705f
C134 buf_in_down.t0 gnd 0.10389f
C135 buf_in_down.t1 gnd 0.1157f
C136 buf_in_down.n0 gnd 0.84735f
C137 buf_in_down.t2 gnd 0.12612f
C138 buf_in_down.t4 gnd 0.11197f
C139 buf_in_down.n1 gnd 0.24587f
C140 buf_in_down.t3 gnd 0.12612f
C141 buf_in_down.t5 gnd 0.11197f
C142 buf_in_down.n2 gnd 0.24635f
C143 buf_in_down.n3 gnd 0.03225f
C144 pre_up.t0 gnd 0.09721f
C145 pre_up.t1 gnd 0.21231f
C146 pre_up.n0 gnd 1.85233f
C147 pre_up.t2 gnd 0.20427f
C148 pre_up.t3 gnd 0.13191f
C149 pre_up.t5 gnd 0.1257f
C150 pre_up.n1 gnd 0.29363f
C151 pre_up.t4 gnd 0.13191f
C152 pre_up.t6 gnd 0.1257f
C153 pre_up.n2 gnd 0.29419f
C154 pre_up.n3 gnd 0.76592f
C155 pre_up.n4 gnd 0.77409f
C156 buf_in_up.t0 gnd 0.06846f
C157 buf_in_up.t1 gnd 0.07624f
C158 buf_in_up.n0 gnd 0.55799f
C159 buf_in_up.t2 gnd 0.0831f
C160 buf_in_up.t4 gnd 0.07378f
C161 buf_in_up.n1 gnd 0.16201f
C162 buf_in_up.t3 gnd 0.0831f
C163 buf_in_up.t5 gnd 0.07378f
C164 buf_in_up.n2 gnd 0.16233f
C165 buf_in_up.n3 gnd 0.02162f
C166 2.t0 gnd 0.09569f
C167 2.t1 gnd 0.074f
C168 2.t3 gnd 0.0707f
C169 2.n0 gnd 0.38802f
C170 2.t4 gnd 0.0707f
C171 2.n1 gnd 0.44965f
C172 2.t2 gnd 0.07396f
C173 2.n2 gnd 0.10638f
C174 4.t3 gnd 0.05243f
C175 4.t1 gnd 0.03997f
C176 4.t4 gnd 0.03988f
C177 4.n0 gnd 0.29848f
C178 4.t2 gnd 0.04931f
C179 4.n1 gnd 0.41522f
C180 4.t5 gnd 0.04006f
C181 4.t0 gnd 0.03988f
C182 4.n2 gnd 0.28797f
C183 4.n3 gnd 0.56873f
C184 vp.n0 gnd 0.17627f
C185 vp.n1 gnd 0.05359f
C186 vp.n2 gnd 0.04623f
C187 vp.n3 gnd 0.01285f
C188 vp.n4 gnd 0.01717f
C189 vp.n5 gnd 0.11595f
C190 vp.n6 gnd 0.0172f
C191 vp.n7 gnd 0.04135f
C192 vp.n8 gnd 0.013f
C193 vp.n9 gnd 0.04507f
C194 vp.n10 gnd 0.04522f
C195 vp.n12 gnd 0.04088f
C196 vp.n13 gnd 0.04151f
C197 vp.n14 gnd 0.01716f
C198 vp.n15 gnd 0.78922f
C199 vp.t0 gnd 9.35361f
C200 vp.n16 gnd 0.5891f
C201 vp.n17 gnd 0.0144f
C202 vp.t25 gnd 0.01577f
C203 vp.n18 gnd 0.05102f
C204 vp.t13 gnd 0.02328f
C205 vp.t10 gnd 0.02328f
C206 vp.n19 gnd 0.09699f
C207 vp.n20 gnd 0.01434f
C208 vp.t9 gnd 0.02328f
C209 vp.t23 gnd 0.0155f
C210 vp.n21 gnd 0.05485f
C211 vp.n22 gnd 0.01186f
C212 vp.t20 gnd 0.02248f
C213 vp.t12 gnd 0.02314f
C214 vp.t8 gnd 0.02314f
C215 vp.n23 gnd 0.10056f
C216 vp.n24 gnd 0.03805f
C217 vp.t7 gnd 0.02314f
C218 vp.t18 gnd 0.02248f
C219 vp.n25 gnd 0.08038f
C220 vp.n26 gnd 0.10056f
C221 vp.n27 gnd 0.02998f
C222 vp.n28 gnd 0.01632f
C223 vp.n29 gnd 0.02371f
C224 vp.n30 gnd 0.01617f
C225 vp.n31 gnd 0.02857f
C226 vp.n32 gnd 0.10056f
C227 vp.n33 gnd 0.07988f
C228 vp.n34 gnd 0.03668f
C229 vp.n35 gnd 0.02107f
C230 vp.n36 gnd 0.03245f
C231 vp.n37 gnd 0.05942f
C232 vp.n38 gnd 0.09699f
C233 vp.n39 gnd 0.02373f
C234 vp.n40 gnd 0.01442f
C235 vp.n41 gnd 0.02368f
C236 vp.n42 gnd 0.01444f
C237 vp.n43 gnd 0.02369f
C238 vp.n44 gnd 0.09699f
C239 vp.n45 gnd 0.08054f
C240 vp.n46 gnd 0.02249f
C241 vp.n47 gnd 0.01027f
C242 cRef.t6 gnd 0.31997f
C243 cRef.t7 gnd 0.24221f
C244 cRef.t8 gnd 0.24213f
C245 cRef.n0 gnd 0.20973f
C246 cRef.n1 gnd 1.39466f
C247 cRef.t0 gnd 0.16759f
C248 cRef.t1 gnd 0.16782f
C249 cRef.n2 gnd 0.16549f
C250 cRef.n3 gnd 1.26875f
C251 cRef.t11 gnd 0.23266f
C252 cRef.t10 gnd 0.23266f
C253 cRef.t9 gnd 0.23535f
C254 cRef.n4 gnd 0.60007f
C255 cRef.n5 gnd 0.3683f
C256 cRef.t13 gnd 0.32166f
C257 cRef.t12 gnd 0.30323f
C258 cRef.n6 gnd 0.88337f
C259 cRef.n7 gnd 0.46756f
C260 cRef.t2 gnd 0.49515f
C261 cRef.t3 gnd 0.43747f
C262 cRef.n8 gnd 1.4306f
C263 cRef.n9 gnd 0.82343f
C264 cRef.t5 gnd 0.31695f
C265 cRef.t4 gnd 0.29852f
C266 cRef.n10 gnd 0.98817f
C267 cRef.n11 gnd 0.89845f
C268 cVco.t6 gnd 0.23791f
C269 cVco.t7 gnd 0.23878f
C270 cVco.n0 gnd 0.40674f
C271 cVco.t8 gnd 0.30126f
C272 cVco.n1 gnd 1.11617f
C273 cVco.t0 gnd 0.24087f
C274 cVco.n2 gnd 1.27553f
C275 cVco.t1 gnd 0.24087f
C276 cVco.n3 gnd 0.36224f
C277 cVco.t9 gnd 0.28755f
C278 cVco.t10 gnd 0.18409f
C279 cVco.t11 gnd 0.18401f
C280 cVco.n4 gnd 0.47171f
C281 cVco.n5 gnd 0.66025f
C282 cVco.t13 gnd 0.36594f
C283 cVco.t12 gnd 0.30044f
C284 cVco.n6 gnd 0.93988f
C285 cVco.n7 gnd 0.42043f
C286 cVco.t2 gnd 0.48191f
C287 cVco.t3 gnd 0.40713f
C288 cVco.n8 gnd 1.28263f
C289 cVco.n9 gnd 0.98649f
C290 cVco.t5 gnd 0.39792f
C291 cVco.t4 gnd 0.33918f
C292 cVco.n10 gnd 1.18435f
C293 cVco.n11 gnd 0.83105f
C294 DOWN.t3 gnd 0.4241f
C295 DOWN.t2 gnd 0.39609f
C296 DOWN.n0 gnd 1.85199f
C297 DOWN.t0 gnd 0.20763f
C298 DOWN.t1 gnd 0.17552f
C299 DOWN.n1 gnd 1.41965f
C300 DOWN.n2 gnd 1.60331f
C301 UP.t3 gnd 0.46736f
C302 UP.t2 gnd 0.43526f
C303 UP.n0 gnd 2.23561f
C304 UP.t0 gnd 0.20954f
C305 UP.t1 gnd 0.18609f
C306 UP.n1 gnd 1.4769f
C307 UP.n2 gnd 1.53058f
.ends
