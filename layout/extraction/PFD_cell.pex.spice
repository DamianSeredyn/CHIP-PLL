* PEX produced on Wed May 20 07:34:59 PM CEST 2026 using /foss/tools/sak/sak-pex.sh with m=3 and s=1
* NGSPICE file created from PFD_cell.ext - technology: ihp-sg13g2

.subckt PFD_cell DOWN UP cVco cRef gnd vp
X0 3.t0 cVco.t11 vp.t4 vp.t0 sg13_lv_pmos ad=55.5f pd=0.74u as=55.5f ps=0.74u w=0.15u l=0.15u
X1 1.t5 gnd.t32 pre_down.t0 gnd.t48 sg13_lv_nmos ad=55.5f pd=0.74u as=55.5f ps=0.74u w=0.15u l=0.15u
X2 4.t1 cVco.t0 gnd.t3 gnd.t2 sg13_lv_nmos ad=55.5f pd=0.74u as=55.5f ps=0.74u w=0.15u l=0.15u
X3 vp.t9 cVco.t12 inv_out_down.t1 vp.t0 sg13_lv_pmos ad=0.1005p pd=1.34u as=55.5f ps=0.74u w=0.15u l=0.13u
X4 vp.t10 cVco.t10 3.t0 vp.t0 sg13_lv_pmos ad=55.5f pd=0.74u as=55.5f ps=0.74u w=0.15u l=0.15u
X5 2.t0 gnd.t40 gnd.t42 gnd.t41 sg13_lv_nmos ad=57f pd=0.68u as=0.102p ps=1.28u w=0.3u l=0.15u
X6 DOWN.t1 buf_in_down.t3 gnd.t22 gnd.t21 sg13_lv_nmos ad=0.114p pd=0.98u as=0.204p ps=1.88u w=0.6u l=0.15u
X7 gnd.t28 pre_up.t3 buf_in_up.t1 gnd.t27 sg13_lv_nmos ad=0.102p pd=1.28u as=57f ps=0.68u w=0.3u l=0.15u
X8 3.t2 gnd.t32 gnd.t34 gnd.t33 sg13_lv_nmos ad=55.5f pd=0.74u as=0.1005p ps=1.34u w=0.15u l=0.15u
X9 1.t1 DOWN.t2 2.t3 gnd.t60 sg13_lv_nmos ad=57f pd=0.68u as=57f ps=0.68u w=0.3u l=0.15u
X10 gnd.t47 gnd.t40 4.t5 gnd.t46 sg13_lv_nmos ad=0.102p pd=1.28u as=57f ps=0.68u w=0.3u l=0.15u
X11 pre_up.t1 gnd.t32 3.t4 gnd.t50 sg13_lv_nmos ad=55.5f pd=0.74u as=55.5f ps=0.74u w=0.15u l=0.15u
X12 vp.t18 pre_up.t5 buf_in_up.t0 vp.t0 sg13_lv_pmos ad=0.102p pd=1.28u as=57f ps=0.68u w=0.3u l=0.15u
X13 inv_out_up.t3 cRef.t7 gnd.t73 gnd.t74 sg13_lv_nmos ad=55.5f pd=0.74u as=55.5f ps=0.74u w=0.15u l=0.13u
X14 vp.t6 cRef.t9 1.t6 vp.t0 sg13_lv_pmos ad=55.5f pd=0.74u as=55.5f ps=0.74u w=0.15u l=0.15u
X15 pre_down.t0 cVco.t4 3.t2 gnd.t16 sg13_lv_nmos ad=55.5f pd=0.74u as=55.5f ps=0.74u w=0.15u l=0.15u
X16 vp.t5 cRef.t12 inv_out_up.t1 vp.t0 sg13_lv_pmos ad=55.5f pd=0.74u as=55.5f ps=0.74u w=0.15u l=0.13u
X17 gnd.t73 cRef.t8 inv_out_up.t2 gnd.t72 sg13_lv_nmos ad=55.5f pd=0.74u as=55.5f ps=0.74u w=0.15u l=0.13u
X18 3.t5 cRef.t6 4.t4 gnd.t76 sg13_lv_nmos ad=57f pd=0.68u as=57f ps=0.68u w=0.3u l=0.15u
X19 vp.t15 vp.t14 3.t1 vp.t0 sg13_lv_pmos ad=0.1005p pd=1.34u as=55.5f ps=0.74u w=0.15u l=0.15u
X20 gnd.t37 gnd.t35 4.t1 gnd.t36 sg13_lv_nmos ad=0.1005p pd=1.34u as=55.5f ps=0.74u w=0.15u l=0.15u
X21 pre_up.t0 inv_out_up.t4 gnd.t24 gnd.t23 sg13_lv_nmos ad=57f pd=0.68u as=57f ps=0.68u w=0.3u l=0.15u
X22 vp.t8 cVco.t13 inv_out_down.t0 vp.t0 sg13_lv_pmos ad=55.5f pd=0.74u as=55.5f ps=0.74u w=0.15u l=0.13u
X23 3.t4 cVco.t2 pre_down.t1 gnd.t18 sg13_lv_nmos ad=55.5f pd=0.74u as=55.5f ps=0.74u w=0.15u l=0.15u
X24 1.t2 vp.t12 vp.t13 vp.t0 sg13_lv_pmos ad=55.5f pd=0.74u as=0.1005p ps=1.34u w=0.15u l=0.15u
X25 2.t4 cRef.t1 gnd.t7 gnd.t81 sg13_lv_nmos ad=55.5f pd=0.74u as=55.5f ps=0.74u w=0.15u l=0.15u
X26 gnd.t26 inv_out_up.t4 pre_up.t0 gnd.t25 sg13_lv_nmos ad=57f pd=0.68u as=57f ps=0.68u w=0.3u l=0.15u
X27 1.t0 cVco.t6 2.t0 gnd.t14 sg13_lv_nmos ad=57f pd=0.68u as=57f ps=0.68u w=0.3u l=0.15u
X28 buf_in_up.t1 pre_up.t4 gnd.t64 gnd.t63 sg13_lv_nmos ad=57f pd=0.68u as=0.102p ps=1.28u w=0.3u l=0.15u
X29 inv_out_up.t2 cRef.t8 gnd.t11 gnd.t71 sg13_lv_nmos ad=55.5f pd=0.74u as=55.5f ps=0.74u w=0.15u l=0.13u
X30 2.t3 gnd.t40 4.t3 gnd.t44 sg13_lv_nmos ad=57f pd=0.68u as=57f ps=0.68u w=0.3u l=0.15u
X31 4.t5 cRef.t5 3.t6 gnd.t77 sg13_lv_nmos ad=57f pd=0.68u as=57f ps=0.68u w=0.3u l=0.15u
X32 gnd.t68 pre_down.t3 buf_in_down.t1 gnd.t67 sg13_lv_nmos ad=0.102p pd=1.28u as=57f ps=0.68u w=0.3u l=0.15u
X33 vp.t22 cRef.t13 inv_out_up.t0 vp.t0 sg13_lv_pmos ad=55.5f pd=0.74u as=55.5f ps=0.74u w=0.15u l=0.13u
X34 UP.t0 buf_in_up.t5 vp.t17 vp.t0 sg13_lv_pmos ad=0.114p pd=0.98u as=0.204p ps=1.88u w=0.6u l=0.15u
X35 buf_in_down.t1 pre_down.t4 gnd.t1 gnd.t0 sg13_lv_nmos ad=57f pd=0.68u as=0.102p ps=1.28u w=0.3u l=0.15u
X36 4.t0 gnd.t51 gnd.t53 gnd.t52 sg13_lv_nmos ad=55.5f pd=0.74u as=0.1005p ps=1.34u w=0.15u l=0.15u
X37 gnd.t7 cVco.t1 4.t0 gnd.t6 sg13_lv_nmos ad=55.5f pd=0.74u as=55.5f ps=0.74u w=0.15u l=0.15u
X38 DOWN.t0 buf_in_down.t5 vp.t16 vp.t0 sg13_lv_pmos ad=0.114p pd=0.98u as=0.204p ps=1.88u w=0.6u l=0.15u
X39 gnd.t3 cRef.t0 2.t4 gnd.t82 sg13_lv_nmos ad=55.5f pd=0.74u as=55.5f ps=0.74u w=0.15u l=0.15u
X40 1.t6 cRef.t10 vp.t10 vp.t0 sg13_lv_pmos ad=55.5f pd=0.74u as=55.5f ps=0.74u w=0.15u l=0.15u
X41 2.t2 DOWN.t3 1.t0 gnd.t59 sg13_lv_nmos ad=57f pd=0.68u as=57f ps=0.68u w=0.3u l=0.15u
X42 3.t3 gnd.t32 1.t3 gnd.t49 sg13_lv_nmos ad=55.5f pd=0.74u as=55.5f ps=0.74u w=0.15u l=0.15u
X43 3.t1 cVco.t9 vp.t6 vp.t0 sg13_lv_pmos ad=55.5f pd=0.74u as=55.5f ps=0.74u w=0.15u l=0.15u
X44 gnd.t56 gnd.t54 gnd.t30 gnd.t55 sg13_lv_nmos ad=0.102p pd=1.28u as=0 ps=0 w=0.3u l=0.15u
X45 vp.t3 buf_in_up.t4 UP.t0 vp.t0 sg13_lv_pmos ad=0.204p pd=1.88u as=0.114p ps=0.98u w=0.6u l=0.15u
X46 4.t3 UP.t3 3.t5 gnd.t19 sg13_lv_nmos ad=57f pd=0.68u as=57f ps=0.68u w=0.3u l=0.15u
X47 3.t6 UP.t2 4.t2 gnd.t20 sg13_lv_nmos ad=57f pd=0.68u as=57f ps=0.68u w=0.3u l=0.15u
X48 inv_out_up.t1 cRef.t12 vp.t22 vp.t0 sg13_lv_pmos ad=55.5f pd=0.74u as=55.5f ps=0.74u w=0.15u l=0.13u
X49 buf_in_up.t0 pre_up.t6 vp.t19 vp.t0 sg13_lv_pmos ad=57f pd=0.68u as=0.102p ps=1.28u w=0.3u l=0.15u
X50 pre_down.t1 cVco.t3 3.t3 gnd.t17 sg13_lv_nmos ad=55.5f pd=0.74u as=55.5f ps=0.74u w=0.15u l=0.15u
X51 pre_down.t2 inv_out_down.t4 gnd.t30 gnd.t29 sg13_lv_nmos ad=57f pd=0.68u as=57f ps=0.68u w=0.3u l=0.15u
X52 4.t4 gnd.t40 2.t2 gnd.t43 sg13_lv_nmos ad=57f pd=0.68u as=57f ps=0.68u w=0.3u l=0.15u
X53 inv_out_down.t0 cVco.t13 vp.t7 vp.t0 sg13_lv_pmos ad=55.5f pd=0.74u as=0.1005p ps=1.34u w=0.15u l=0.13u
X54 vp.t4 cRef.t11 1.t2 vp.t0 sg13_lv_pmos ad=55.5f pd=0.74u as=55.5f ps=0.74u w=0.15u l=0.15u
X55 buf_in_down.t0 pre_down.t6 vp.t1 vp.t0 sg13_lv_pmos ad=57f pd=0.68u as=0.102p ps=1.28u w=0.3u l=0.15u
X56 gnd.t13 cVco.t7 inv_out_down.t3 gnd.t12 sg13_lv_nmos ad=0.1005p pd=1.34u as=55.5f ps=0.74u w=0.15u l=0.13u
X57 gnd.t24 inv_out_down.t4 pre_down.t2 gnd.t31 sg13_lv_nmos ad=57f pd=0.68u as=57f ps=0.68u w=0.3u l=0.15u
X58 gnd.t11 cVco.t8 inv_out_down.t2 gnd.t10 sg13_lv_nmos ad=55.5f pd=0.74u as=55.5f ps=0.74u w=0.15u l=0.13u
X59 1.t3 cRef.t3 pre_up.t2 gnd.t79 sg13_lv_nmos ad=55.5f pd=0.74u as=55.5f ps=0.74u w=0.15u l=0.15u
X60 inv_out_down.t1 cVco.t12 vp.t5 vp.t0 sg13_lv_pmos ad=55.5f pd=0.74u as=55.5f ps=0.74u w=0.15u l=0.13u
X61 gnd.t39 gnd.t32 1.t4 gnd.t38 sg13_lv_nmos ad=0.1005p pd=1.34u as=55.5f ps=0.74u w=0.15u l=0.15u
X62 gnd.t66 buf_in_down.t2 DOWN.t1 gnd.t65 sg13_lv_nmos ad=0.204p pd=1.88u as=0.114p ps=0.98u w=0.6u l=0.15u
X63 gnd.t62 buf_in_up.t2 UP.t1 gnd.t61 sg13_lv_nmos ad=0.204p pd=1.88u as=0.114p ps=0.98u w=0.6u l=0.15u
X64 inv_out_up.t0 cRef.t13 vp.t8 vp.t0 sg13_lv_pmos ad=55.5f pd=0.74u as=55.5f ps=0.74u w=0.15u l=0.13u
X65 inv_out_down.t3 cVco.t7 gnd.t5 gnd.t4 sg13_lv_nmos ad=55.5f pd=0.74u as=55.5f ps=0.74u w=0.15u l=0.13u
X66 gnd.t26 gnd.t57 gnd.t26 gnd.t58 sg13_lv_nmos ad=57f pd=0.68u as=0 ps=0 w=0.3u l=0.15u
X67 2.t1 cVco.t5 1.t1 gnd.t15 sg13_lv_nmos ad=57f pd=0.68u as=57f ps=0.68u w=0.3u l=0.15u
X68 4.t2 gnd.t40 2.t1 gnd.t45 sg13_lv_nmos ad=57f pd=0.68u as=57f ps=0.68u w=0.3u l=0.15u
X69 vp.t2 buf_in_down.t4 DOWN.t0 vp.t0 sg13_lv_pmos ad=0.204p pd=1.88u as=0.114p ps=0.98u w=0.6u l=0.15u
X70 inv_out_down.t2 cVco.t8 gnd.t9 gnd.t8 sg13_lv_nmos ad=55.5f pd=0.74u as=0.1005p ps=1.34u w=0.15u l=0.13u
X71 pre_up.t2 cRef.t4 1.t5 gnd.t78 sg13_lv_nmos ad=55.5f pd=0.74u as=55.5f ps=0.74u w=0.15u l=0.15u
X72 vp.t11 pre_down.t5 buf_in_down.t0 vp.t0 sg13_lv_pmos ad=0.102p pd=1.28u as=57f ps=0.68u w=0.3u l=0.15u
X73 1.t4 cRef.t2 pre_up.t1 gnd.t80 sg13_lv_nmos ad=55.5f pd=0.74u as=55.5f ps=0.74u w=0.15u l=0.15u
X74 gnd.t5 cRef.t7 inv_out_up.t3 gnd.t75 sg13_lv_nmos ad=55.5f pd=0.74u as=55.5f ps=0.74u w=0.15u l=0.13u
X75 UP.t1 buf_in_up.t3 gnd.t70 gnd.t69 sg13_lv_nmos ad=0.114p pd=0.98u as=0.204p ps=1.88u w=0.6u l=0.15u
R0 UP.n1 UP.t0 27.3291
R1 UP.n1 UP.t1 26.6559
R2 UP.n0 UP.t3 13.8556
R3 UP.n0 UP.t2 12.9062
R4 UP.n2 UP.n0 7.3925
R5 UP.n2 UP.n1 4.6105
R6 UP UP.n2 0.4955
R7 DOWN.n1 DOWN.t0 27.5271
R8 DOWN.n1 DOWN.t1 26.4579
R9 DOWN.n0 DOWN.t3 13.5517
R10 DOWN.n0 DOWN.t2 12.5864
R11 DOWN.n2 DOWN.n0 6.1297
R12 DOWN.n2 DOWN.n1 4.6105
R13 DOWN DOWN.n2 2.4535
R14 cRef.n8 cRef.t5 15.068
R15 cRef.n8 cRef.t6 13.4603
R16 cRef.n1 cRef.t2 13.4369
R17 cRef.n3 cRef.n1 13.1243
R18 cRef.n10 cRef.t8 12.5186
R19 cRef.n6 cRef.t13 12.5184
R20 cRef.n4 cRef.t9 12.3574
R21 cRef.n4 cRef.t10 12.0934
R22 cRef.n5 cRef.t11 12.0934
R23 cRef.n10 cRef.t7 12.017
R24 cRef.n6 cRef.t12 12.0168
R25 cRef.n0 cRef.t4 7.68601
R26 cRef.n2 cRef.t1 7.6859
R27 cRef.n0 cRef.t3 7.67554
R28 cRef.n2 cRef.t0 7.67542
R29 cRef cRef.n11 6.4442
R30 cRef.n9 cRef.n7 5.8425
R31 cRef.n11 cRef.n10 5.6357
R32 cRef.n9 cRef.n8 5.5961
R33 cRef.n3 cRef.n2 4.5005
R34 cRef.n1 cRef.n0 3.0005
R35 cRef.n11 cRef.n9 1.9717
R36 cRef.n7 cRef.n6 1.1445
R37 cRef.n5 cRef.n4 0.7749
R38 cRef.n7 cRef.n5 0.7397
R39 cRef cRef.n3 0.625667
R40 cVco.n8 cVco.t5 15.1154
R41 cVco.n6 cVco.t13 13.7764
R42 cVco.n10 cVco.t8 13.7033
R43 cVco.n5 cVco.t9 13.3435
R44 cVco.n8 cVco.t6 13.1647
R45 cVco.n3 cVco.t1 12.319
R46 cVco.n2 cVco.t0 12.319
R47 cVco.n6 cVco.t12 12.2628
R48 cVco.n10 cVco.t7 12.1985
R49 cVco.n2 cVco.n1 12.1786
R50 cVco.n1 cVco.t4 12.1334
R51 cVco.n0 cVco.t3 7.7793
R52 cVco.n0 cVco.t2 7.76883
R53 cVco.n4 cVco.t10 7.65296
R54 cVco.n4 cVco.t11 7.65119
R55 cVco.n9 cVco.n7 6.5993
R56 cVco cVco.n11 6.53293
R57 cVco.n9 cVco.n8 5.0373
R58 cVco.n11 cVco.n10 5.0109
R59 cVco.n5 cVco.n4 4.5005
R60 cVco.n1 cVco.n0 4.4349
R61 cVco.n11 cVco.n9 1.8925
R62 cVco.n7 cVco.n5 1.2105
R63 cVco.n3 cVco.n2 0.664167
R64 cVco.n7 cVco.n6 0.5461
R65 cVco cVco.n3 0.281
R66 vp.n10 vp.t6 31.6973
R67 vp.n12 vp.t10 31.6973
R68 vp.n14 vp.t4 31.6973
R69 vp.n23 vp.t9 31.6973
R70 vp.n28 vp.t8 31.6973
R71 vp.n25 vp.t5 31.6973
R72 vp.n27 vp.t22 31.6973
R73 vp.n29 vp.t7 31.6973
R74 vp.n35 vp.t1 17.9767
R75 vp.n37 vp.t11 17.9767
R76 vp.n42 vp.t19 17.9767
R77 vp.n43 vp.t18 17.9767
R78 vp.n31 vp.t3 17.9627
R79 vp.n39 vp.t16 17.8736
R80 vp.n40 vp.t2 17.8736
R81 vp.n32 vp.t17 17.8534
R82 vp.n7 vp.t15 17.0005
R83 vp.n15 vp.t13 17.0005
R84 vp.n47 vp.n46 17.0005
R85 vp.n8 vp.n7 14.6973
R86 vp.n16 vp.n15 14.6973
R87 vp.n7 vp.t14 9.30844
R88 vp.n15 vp.t12 7.72833
R89 vp.n30 vp.n29 4.58055
R90 vp.n28 vp.n21 4.5005
R91 vp.n23 vp.n22 4.5005
R92 vp.n17 vp.n16 4.5005
R93 vp.n12 vp.n11 4.5005
R94 vp.n8 vp.n1 4.5005
R95 vp.n10 vp.n9 4.5005
R96 vp.n14 vp.n13 4.5005
R97 vp.n25 vp.n24 4.5005
R98 vp.n27 vp.n26 4.5005
R99 vp.n45 vp.n36 2.80696
R100 vp.n45 vp.n38 2.80696
R101 vp.n45 vp.n34 2.80696
R102 vp.n45 vp.n44 2.80696
R103 vp.n45 vp.n33 2.80696
R104 vp.n46 vp.n5 2.80696
R105 vp.n46 vp.n3 2.80696
R106 vp.n46 vp.n2 2.80696
R107 vp.n46 vp.n20 2.80696
R108 vp.n45 vp.n41 2.08777
R109 vp.n46 vp.n4 2.08777
R110 vp.n46 vp.n6 2.08777
R111 vp.n46 vp.n19 2.08777
R112 vp.n45 vp.n31 1.85103
R113 vp.n46 vp.n30 1.66333
R114 vp.n46 vp.n18 1.65246
R115 vp vp.n0 0.935452
R116 vp.n35 vp.n0 0.561549
R117 vp.n46 vp.t0 0.247877
R118 vp.n45 vp.n0 0.210867
R119 vp.t0 vp.n45 0.184296
R120 vp.n22 vp.n18 0.167359
R121 vp.n10 vp.n8 0.148843
R122 vp.n12 vp.n10 0.148843
R123 vp.n14 vp.n12 0.148843
R124 vp.n16 vp.n14 0.148843
R125 vp.n25 vp.n23 0.143814
R126 vp.n27 vp.n25 0.143814
R127 vp.n28 vp.n27 0.143814
R128 vp.n29 vp.n28 0.143814
R129 vp.n18 vp.n17 0.139265
R130 vp.n30 vp.n21 0.130234
R131 vp.n33 vp.n32 0.124623
R132 vp.n40 vp.n34 0.123129
R133 vp.n24 vp.n2 0.123129
R134 vp.n39 vp.n38 0.120956
R135 vp.n9 vp.n4 0.116891
R136 vp.n11 vp.n5 0.115456
R137 vp.n22 vp.n19 0.113993
R138 vp.n44 vp.n43 0.113623
R139 vp.n13 vp.n6 0.113224
R140 vp.n17 vp.n3 0.111789
R141 vp.n37 vp.n36 0.109956
R142 vp.n21 vp.n20 0.109956
R143 vp.n32 vp.n31 0.106995
R144 vp.n13 vp.n3 0.106629
R145 vp.n42 vp.n34 0.106289
R146 vp.n11 vp.n6 0.104827
R147 vp.n9 vp.n5 0.102963
R148 vp.n4 vp.n1 0.10116
R149 vp.n26 vp.n20 0.101129
R150 vp.n41 vp.n39 0.0993266
R151 vp.n41 vp.n40 0.0967242
R152 vp.n24 vp.n19 0.0967242
R153 vp.n26 vp.n2 0.087956
R154 vp.n36 vp.n35 0.0864625
R155 vp.n44 vp.n42 0.0827958
R156 vp.n38 vp.n37 0.0791292
R157 vp.n43 vp.n33 0.0754625
R158 vp.n47 vp.n1 0.0564167
R159 vp vp.n47 0.0133333
R160 gnd.n91 gnd.t0 303.375
R161 gnd.n126 gnd.t41 293.478
R162 gnd.n88 gnd.n87 198.002
R163 gnd.t41 gnd.t14 144.023
R164 gnd.n77 gnd.t69 94.79
R165 gnd.n38 gnd.t21 94.79
R166 gnd.t46 gnd.n106 94.79
R167 gnd.n94 gnd.t50 89.6744
R168 gnd.t79 gnd.n99 89.6744
R169 gnd.n103 gnd.t29 89.6744
R170 gnd.t43 gnd.n117 89.6744
R171 gnd.n109 gnd.t20 86.957
R172 gnd.t33 gnd.n105 84.2396
R173 gnd.n119 gnd.t52 84.2396
R174 gnd.n15 gnd.t75 84.2396
R175 gnd.t82 gnd.n113 81.5222
R176 gnd.n20 gnd.t71 81.5222
R177 gnd.t27 gnd.n77 81.203
R178 gnd.n38 gnd.t67 81.203
R179 gnd.n105 gnd.t16 76.0875
R180 gnd.n112 gnd.t15 76.0875
R181 gnd.t58 gnd.n95 73.3701
R182 gnd.n20 gnd.t10 73.3701
R183 gnd.n93 gnd.t80 72.3974
R184 gnd.t18 gnd.n94 70.6527
R185 gnd.t74 gnd.n15 70.6527
R186 gnd.n126 gnd.t12 67.9353
R187 gnd.t78 gnd.n101 65.2179
R188 gnd.n115 gnd.t44 65.2179
R189 gnd.t23 gnd.t49 62.5005
R190 gnd.n14 gnd.t4 61.5279
R191 gnd.n87 gnd.t63 59.7831
R192 gnd.n98 gnd.t25 59.7831
R193 gnd.t38 gnd.n91 58.8105
R194 gnd.n18 gnd.t72 58.8105
R195 gnd.t45 gnd.n109 57.0657
R196 gnd.t81 gnd.n115 57.0657
R197 gnd.n111 gnd.t36 54.3483
R198 gnd.t60 gnd.t2 54.3483
R199 gnd.n117 gnd.t76 54.3483
R200 gnd.n85 gnd.t61 54.034
R201 gnd.n88 gnd.t65 53.9815
R202 gnd.t61 gnd.n75 53.3757
R203 gnd.t65 gnd.n36 53.3757
R204 gnd.t77 gnd.n107 53.3757
R205 gnd.n108 gnd.t77 53.3757
R206 gnd.n120 gnd.t59 50.6584
R207 gnd.n101 gnd.t31 48.9135
R208 gnd.t59 gnd.n119 48.9135
R209 gnd.n92 gnd.t38 47.9409
R210 gnd.t72 gnd.n17 47.9409
R211 gnd.t17 gnd.n96 46.1962
R212 gnd.n97 gnd.t17 46.1962
R213 gnd.n134 gnd.t4 45.4151
R214 gnd.n104 gnd.t55 45.2235
R215 gnd.t31 gnd.n100 43.4788
R216 gnd.t48 gnd.n103 40.7614
R217 gnd.t0 gnd.n90 39.7895
R218 gnd.t6 gnd.n116 39.7888
R219 gnd.n81 gnd.t63 39.7887
R220 gnd.t36 gnd.n110 38.044
R221 gnd.n110 gnd.t45 35.3266
R222 gnd.t80 gnd.n92 34.354
R223 gnd.t25 gnd.n97 32.6092
R224 gnd.n29 gnd.t5 31.642
R225 gnd.n23 gnd.t13 31.642
R226 gnd.n24 gnd.t9 31.642
R227 gnd.n26 gnd.t11 31.642
R228 gnd.n28 gnd.t73 31.642
R229 gnd.n144 gnd.t3 31.5749
R230 gnd.n143 gnd.t7 31.5749
R231 gnd.n45 gnd.t24 31.4436
R232 gnd.n17 gnd.t74 28.9192
R233 gnd.n102 gnd.t78 27.1744
R234 gnd.t44 gnd.n114 27.1744
R235 gnd.n19 gnd.t8 26.7512
R236 gnd.t10 gnd.n19 26.5095
R237 gnd.n90 gnd.t67 26.2018
R238 gnd.n81 gnd.t27 26.2018
R239 gnd.n113 gnd.t60 24.457
R240 gnd.n135 gnd.t12 24.457
R241 gnd.t16 gnd.n104 23.4844
R242 gnd.n95 gnd.t18 21.7396
R243 gnd.t49 gnd.n98 21.7396
R244 gnd.t19 gnd.t81 21.7396
R245 gnd.n116 gnd.t19 20.7677
R246 gnd.n96 gnd.t58 19.0222
R247 gnd.t71 gnd.n18 18.0496
R248 gnd.n50 gnd.t34 17.8464
R249 gnd.n40 gnd.t39 17.8233
R250 gnd.n73 gnd.t66 17.6089
R251 gnd.n72 gnd.t22 17.6089
R252 gnd.n84 gnd.t62 17.6089
R253 gnd.n82 gnd.t70 17.6089
R254 gnd.n70 gnd.t1 17.5524
R255 gnd.n39 gnd.t68 17.5058
R256 gnd.n79 gnd.t28 17.5058
R257 gnd.n78 gnd.t64 17.5058
R258 gnd.n51 gnd.t47 17.2601
R259 gnd.n5 gnd.t42 17.2601
R260 gnd.n2 gnd.t37 17.2205
R261 gnd.n4 gnd.t53 17.2067
R262 gnd.t26 gnd.n42 17.1629
R263 gnd.n44 gnd.t26 17.1629
R264 gnd.n47 gnd.t30 17.1629
R265 gnd.n49 gnd.t56 17.1629
R266 gnd.n136 gnd.n135 17.0005
R267 gnd.t15 gnd.n111 16.3048
R268 gnd.n106 gnd.t33 15.9856
R269 gnd.t14 gnd.n120 15.3329
R270 gnd.t75 gnd.n14 15.3322
R271 gnd.n58 gnd.n47 14.2812
R272 gnd.n57 gnd.n49 14.2812
R273 gnd.n65 gnd.n42 14.2777
R274 gnd.n64 gnd.n44 14.2777
R275 gnd.t55 gnd.t48 13.5875
R276 gnd.t2 gnd.n112 13.5875
R277 gnd.t69 gnd.n75 12.6148
R278 gnd.t21 gnd.n36 12.6148
R279 gnd.n107 gnd.t46 12.6148
R280 gnd.t20 gnd.n108 12.6148
R281 gnd.n114 gnd.t82 10.8701
R282 gnd.t50 gnd.n93 9.89744
R283 gnd.n133 gnd.n13 8.52304
R284 gnd.n135 gnd.n8 8.501
R285 gnd.n135 gnd.n9 8.501
R286 gnd.n127 gnd.n126 8.501
R287 gnd.n135 gnd.n11 8.501
R288 gnd.n126 gnd.n125 8.501
R289 gnd.n126 gnd.n7 8.501
R290 gnd.n87 gnd.n86 8.5005
R291 gnd.n133 gnd.n20 8.5005
R292 gnd.n133 gnd.n15 8.5005
R293 gnd.n131 gnd.n130 8.5005
R294 gnd.n129 gnd.n128 8.5005
R295 gnd.n34 gnd.n33 8.5005
R296 gnd.n124 gnd.n123 8.5005
R297 gnd.n122 gnd.n121 8.5005
R298 gnd.n10 gnd.n6 8.5005
R299 gnd.n137 gnd.n136 8.5005
R300 gnd.n119 gnd.n1 8.5005
R301 gnd.n118 gnd.n1 8.5005
R302 gnd.n117 gnd.n1 8.5005
R303 gnd.n112 gnd.n1 8.5005
R304 gnd.n111 gnd.n1 8.5005
R305 gnd.n110 gnd.n1 8.5005
R306 gnd.n109 gnd.n1 8.5005
R307 gnd.n105 gnd.n1 8.5005
R308 gnd.n94 gnd.n1 8.5005
R309 gnd.n69 gnd.n1 8.5005
R310 gnd.n95 gnd.n1 8.5005
R311 gnd.n41 gnd.n1 8.5005
R312 gnd.n96 gnd.n1 8.5005
R313 gnd.n97 gnd.n1 8.5005
R314 gnd.n98 gnd.n1 8.5005
R315 gnd.n99 gnd.n1 8.5005
R316 gnd.n100 gnd.n1 8.5005
R317 gnd.n101 gnd.n1 8.5005
R318 gnd.n102 gnd.n1 8.5005
R319 gnd.n103 gnd.n1 8.5005
R320 gnd.n113 gnd.n1 8.5005
R321 gnd.n114 gnd.n1 8.5005
R322 gnd.n115 gnd.n1 8.5005
R323 gnd.n99 gnd.t23 8.15267
R324 gnd.t52 gnd.n118 8.15267
R325 gnd.n2 gnd.t35 7.5589
R326 gnd.n4 gnd.t51 7.5589
R327 gnd.n43 gnd.t57 7.53301
R328 gnd.n48 gnd.t54 7.53301
R329 gnd.t32 gnd.n40 7.47647
R330 gnd.n51 gnd.t40 7.47438
R331 gnd.t40 gnd.n5 7.47438
R332 gnd.n50 gnd.t32 7.46996
R333 gnd.t76 gnd.t6 5.43528
R334 gnd.n135 gnd.n134 4.91444
R335 gnd.n24 gnd.n21 4.6148
R336 gnd.n28 gnd.n27 4.5005
R337 gnd.n26 gnd.n25 4.5005
R338 gnd.n30 gnd.n29 4.5005
R339 gnd.n23 gnd.n13 4.5005
R340 gnd.n143 gnd.n142 4.5005
R341 gnd.n59 gnd.n58 4.5005
R342 gnd.n61 gnd.n45 4.5005
R343 gnd.n64 gnd.n63 4.5005
R344 gnd.n66 gnd.n65 4.5005
R345 gnd.n57 gnd.n56 4.5005
R346 gnd.n145 gnd.n144 4.5005
R347 gnd.n89 gnd.n35 4.25187
R348 gnd.n126 gnd.n12 4.251
R349 gnd.n133 gnd.n132 4.2357
R350 gnd.n89 gnd.n71 4.23566
R351 gnd.n133 gnd.n31 4.23547
R352 gnd.n46 gnd.n1 4.23547
R353 gnd.n148 gnd.n1 4.23547
R354 gnd.n52 gnd.n51 3.04791
R355 gnd.n138 gnd.n5 3.04791
R356 gnd.n54 gnd.n50 3.00855
R357 gnd.n68 gnd.n40 2.98549
R358 gnd.n85 gnd.n84 2.91432
R359 gnd.n86 gnd.n80 2.80711
R360 gnd.n86 gnd.n83 2.80696
R361 gnd.n89 gnd.n74 2.80696
R362 gnd.n133 gnd.n16 2.80696
R363 gnd.n133 gnd.n22 2.80696
R364 gnd.n141 gnd.n1 2.80696
R365 gnd.n62 gnd.n1 2.80696
R366 gnd.n60 gnd.n1 2.80696
R367 gnd.n55 gnd.n1 2.80696
R368 gnd.n53 gnd.n1 2.80696
R369 gnd.n1 gnd.n0 2.80696
R370 gnd.n3 gnd.n1 2.80696
R371 gnd.n139 gnd.n1 2.80691
R372 gnd.n100 gnd.t79 2.71789
R373 gnd.t29 gnd.n102 2.71789
R374 gnd.n118 gnd.t43 2.71789
R375 gnd.n86 gnd.n76 2.08777
R376 gnd.n89 gnd.n37 2.08777
R377 gnd.n146 gnd.n1 2.08777
R378 gnd.n133 gnd.n21 2.08773
R379 gnd.n67 gnd.n1 1.14739
R380 gnd.n70 gnd.n69 0.998804
R381 gnd.n140 gnd.n4 0.856437
R382 gnd.n147 gnd.n2 0.842688
R383 gnd.n90 gnd.n89 0.661721
R384 gnd.n120 gnd.n1 0.661721
R385 gnd.n116 gnd.n1 0.661721
R386 gnd.n86 gnd.n81 0.661473
R387 gnd.n86 gnd.n75 0.661473
R388 gnd.n89 gnd.n36 0.661473
R389 gnd.n133 gnd.n18 0.661473
R390 gnd.n133 gnd.n17 0.661473
R391 gnd.n133 gnd.n14 0.661473
R392 gnd.n108 gnd.n1 0.661473
R393 gnd.n107 gnd.n1 0.661473
R394 gnd.n93 gnd.n1 0.661473
R395 gnd.n92 gnd.n1 0.661473
R396 gnd.n91 gnd.n1 0.661473
R397 gnd.n104 gnd.n1 0.661473
R398 gnd.n134 gnd.n133 0.453347
R399 gnd.n133 gnd.n19 0.349794
R400 gnd.n139 gnd.n138 0.215375
R401 gnd.n68 gnd.n67 0.204616
R402 gnd.n67 gnd.n66 0.185866
R403 gnd.n138 gnd.n137 0.18475
R404 gnd.n144 gnd.n143 0.148843
R405 gnd.n29 gnd.n23 0.143814
R406 gnd.n29 gnd.n28 0.143814
R407 gnd.n28 gnd.n26 0.143814
R408 gnd.n26 gnd.n24 0.143814
R409 gnd.n44 gnd.n43 0.143238
R410 gnd.n49 gnd.n48 0.143238
R411 gnd.n43 gnd.n42 0.13931
R412 gnd.n48 gnd.n47 0.13931
R413 gnd.n58 gnd.n45 0.133757
R414 gnd.n64 gnd.n45 0.1325
R415 gnd.n78 gnd.n35 0.12877
R416 gnd.n145 gnd.n3 0.124963
R417 gnd.n80 gnd.n79 0.12459
R418 gnd.n147 gnd.n146 0.12316
R419 gnd.n25 gnd.n16 0.123129
R420 gnd.n141 gnd.n140 0.122789
R421 gnd.n74 gnd.n72 0.115796
R422 gnd.n83 gnd.n82 0.115796
R423 gnd.n52 gnd.n0 0.115796
R424 gnd.n60 gnd.n59 0.113623
R425 gnd.n55 gnd.n54 0.111789
R426 gnd.n30 gnd.n22 0.109956
R427 gnd gnd.n0 0.109039
R428 gnd.n62 gnd.n61 0.106289
R429 gnd.n72 gnd.n37 0.104058
R430 gnd.n82 gnd.n76 0.104058
R431 gnd.n56 gnd.n55 0.102963
R432 gnd.n27 gnd.n22 0.101129
R433 gnd.n25 gnd.n21 0.096904
R434 gnd.n39 gnd.n37 0.09566
R435 gnd.n79 gnd.n76 0.09566
R436 gnd.n142 gnd.n141 0.0956292
R437 gnd.n132 gnd.n131 0.0953079
R438 gnd.n146 gnd.n145 0.0948909
R439 gnd.n71 gnd.n39 0.0938426
R440 gnd.n142 gnd.n3 0.093456
R441 gnd.n63 gnd.n62 0.0882959
R442 gnd.n27 gnd.n16 0.087956
R443 gnd.n61 gnd.n60 0.0827958
R444 gnd.n74 gnd.n73 0.0806227
R445 gnd.n84 gnd.n83 0.0806227
R446 gnd.n54 gnd.n53 0.0772959
R447 gnd.n53 gnd.n52 0.0732893
R448 gnd.n80 gnd.n78 0.0718311
R449 gnd.n32 gnd.n31 0.0705528
R450 gnd.n65 gnd.n64 0.0671286
R451 gnd.n58 gnd.n57 0.0671286
R452 gnd.n73 gnd.n35 0.0664419
R453 gnd.n140 gnd.n139 0.0663661
R454 gnd.n148 gnd.n147 0.0659695
R455 gnd.n132 gnd.n32 0.0633784
R456 gnd.n131 gnd.n129 0.0628333
R457 gnd.n129 gnd.n33 0.0628333
R458 gnd.n123 gnd.n33 0.0628333
R459 gnd.n123 gnd.n122 0.0628333
R460 gnd.n122 gnd.n6 0.0628333
R461 gnd.n137 gnd.n6 0.0628333
R462 gnd.n66 gnd.n41 0.0600833
R463 gnd.n56 gnd.n46 0.0549695
R464 gnd.n89 gnd.n88 0.0526709
R465 gnd gnd.n148 0.0485528
R466 gnd.n31 gnd.n30 0.0476361
R467 gnd.n71 gnd.n70 0.0473445
R468 gnd.n59 gnd.n46 0.0439695
R469 gnd.n69 gnd.n68 0.0435833
R470 gnd.n63 gnd.n41 0.0380833
R471 gnd.n32 gnd.n13 0.00861475
R472 gnd.n86 gnd.n77 0.00504252
R473 gnd.n89 gnd.n38 0.00504252
R474 gnd.n106 gnd.n1 0.00504252
R475 gnd.n130 gnd.n12 0.00175
R476 gnd.n133 gnd.n12 0.00124998
R477 gnd.n86 gnd.n85 0.00116605
R478 gnd.n130 gnd.n8 0.001
R479 gnd.n127 gnd.n34 0.001
R480 gnd.n34 gnd.n9 0.001
R481 gnd.n125 gnd.n121 0.001
R482 gnd.n121 gnd.n11 0.001
R483 gnd.n136 gnd.n7 0.001
R484 gnd.n128 gnd.n8 0.001
R485 gnd.n128 gnd.n127 0.001
R486 gnd.n124 gnd.n9 0.001
R487 gnd.n125 gnd.n124 0.001
R488 gnd.n11 gnd.n10 0.001
R489 gnd.n10 gnd.n7 0.001
R490 4.t1 4.n3 22.1723
R491 4 4.n3 0.557833
R492 4.n3 4.n0 11.4399
R493 4 4.n1 0.593528
R494 4.n1 4.n2 8.89047
R495 4.n2 4.t4 17.6419
R496 4.n2 4.t3 17.6669
R497 4.n1 4.t0 21.8846
R498 4.n0 4.t2 17.6217
R499 4.n0 4.t5 17.6427
R500 2.t4 2 26.9819
R501 2 2.n2 4.5005
R502 2.n2 2.n1 0.623833
R503 2.n2 2.n0 0.1545
R504 2.n1 2.t0 22.4872
R505 2.n1 2.t2 22.1117
R506 2.n0 2.t3 22.1117
R507 2.n0 2.t1 22.5004
R508 pre_up.t0 pre_up.n4 22.2011
R509 pre_up.n4 pre_up.t2 32.1585
R510 pre_up pre_up.n4 0.3833
R511 pre_up pre_up.n0 0.4097
R512 pre_up.n0 pre_up.n3 29.0873
R513 pre_up.n3 pre_up.n2 0.131452
R514 pre_up.n3 pre_up.n1 0.147167
R515 pre_up.n2 pre_up.t4 8.7238
R516 pre_up.n2 pre_up.t6 8.20817
R517 pre_up.n1 pre_up.t3 8.7238
R518 pre_up.n1 pre_up.t5 8.20817
R519 pre_up.n0 pre_up.t1 31.8637
R520 pre_down.n0 pre_down.t0 31.9246
R521 pre_down pre_down.n0 0.2953
R522 pre_down pre_down.n1 0.5461
R523 pre_down.n1 pre_down.n4 17.5045
R524 pre_down.n4 pre_down.n3 0.13669
R525 pre_down.n4 pre_down.n2 0.141929
R526 pre_down.n3 pre_down.t4 8.7238
R527 pre_down.n3 pre_down.t6 8.20817
R528 pre_down.n2 pre_down.t3 8.7238
R529 pre_down.n2 pre_down.t5 8.20817
R530 pre_down.n1 pre_down.t1 31.4714
R531 pre_down.n0 pre_down.t2 22.6686
R532 buf_in_up.t0 buf_in_up.n0 26.7345
R533 buf_in_up buf_in_up.n0 5.0021
R534 buf_in_up buf_in_up.n3 4.9405
R535 buf_in_up.n3 buf_in_up.n2 0.13669
R536 buf_in_up.n3 buf_in_up.n1 0.141929
R537 buf_in_up.n2 buf_in_up.t3 8.8888
R538 buf_in_up.n2 buf_in_up.t5 7.83692
R539 buf_in_up.n1 buf_in_up.t2 8.8888
R540 buf_in_up.n1 buf_in_up.t4 7.83692
R541 buf_in_up.n0 buf_in_up.t1 27.5397
R542 buf_in_down.t0 buf_in_down.n0 26.7345
R543 buf_in_down buf_in_down.n0 5.0263
R544 buf_in_down buf_in_down.n3 4.9163
R545 buf_in_down.n3 buf_in_down.n2 0.13669
R546 buf_in_down.n3 buf_in_down.n1 0.141929
R547 buf_in_down.n2 buf_in_down.t3 8.8888
R548 buf_in_down.n2 buf_in_down.t5 7.83692
R549 buf_in_down.n1 buf_in_down.t2 8.8888
R550 buf_in_down.n1 buf_in_down.t4 7.83692
R551 buf_in_down.n0 buf_in_down.t1 27.5397
R552 3.n4 3.t1 27.0829
R553 3.n3 3.n4 3.0005
R554 3.n4 3.t6 27.8037
R555 3.n3 3.n1 1.22674
R556 3.n1 3.n2 3.77604
R557 3.n2 3.t4 27.7553
R558 3.n2 3.t3 27.7465
R559 3.n1 3.t2 32.0038
R560 3 3.n3 0.235271
R561 3 3.n0 5.49197
R562 3.n0 3.t5 27.6718
R563 3.n0 3.t0 26.9268
R564 1.n4 1.t6 26.8292
R565 1.n3 1.n4 4.50198
R566 1.n4 1.t1 27.7963
R567 1.n3 1.n1 2.29698
R568 1.n1 1.n2 0.512188
R569 1.n2 1.t4 33.4672
R570 1.n2 1.t3 32.1886
R571 1.n1 1.t5 32.1886
R572 1 1.n3 0.784988
R573 1 1.n0 5.11714
R574 1.n0 1.t0 27.8301
R575 1.n0 1.t2 26.8849
R576 inv_out_up.n0 inv_out_up.t1 28.5129
R577 inv_out_up.n1 inv_out_up.n0 2.9573
R578 inv_out_up.n1 inv_out_up.n2 3.0365
R579 inv_out_up.n2 inv_out_up.t2 26.0948
R580 inv_out_up.n2 inv_out_up.t0 28.5129
R581 inv_out_up inv_out_up.n1 8.1553
R582 inv_out_up inv_out_up.t4 22.184
R583 inv_out_up.n0 inv_out_up.t3 26.0948
R584 inv_out_down.n0 inv_out_down.t1 28.5129
R585 inv_out_down.n2 inv_out_down.n0 7.45667
R586 inv_out_down.n2 inv_out_down.n1 8.9489
R587 inv_out_down inv_out_down.n2 4.7349
R588 inv_out_down inv_out_down.t4 22.3776
R589 inv_out_down.n1 inv_out_down.t2 26.0948
R590 inv_out_down.n1 inv_out_down.t0 28.5129
R591 inv_out_down.n0 inv_out_down.t3 26.0948
C0 UP DOWN 4.0335f
C1 4 DOWN 0.043f
C2 UP vp 0.29931f
C3 inv_out_up pre_up 0.07201f
C4 4 UP 0.05375f
C5 1 3 3.96373f
C6 pre_up 1 1.2096f
C7 cVco 3 0.12818f
C8 pre_up buf_in_down 0.66817f
C9 inv_out_down cRef 0.09403f
C10 1 2 0.16234f
C11 pre_up cVco 0.04416f
C12 pre_down inv_out_down 0.0594f
C13 cVco 2 0.03252f
C14 DOWN buf_in_up 0.19237f
C15 vp inv_out_down 1.35065f
C16 vp buf_in_up 0.55456f
C17 UP buf_in_up 0.3853f
C18 inv_out_up cVco 0.27771f
C19 3 cRef 1.00887f
C20 1 buf_in_down 0.01602f
C21 pre_down 3 0.92057f
C22 cVco 1 0.12496f
C23 pre_up cRef 0.15336f
C24 pre_down pre_up 1.25666f
C25 DOWN 3 0.26577f
C26 vp 3 1.40691f
C27 2 cRef 0.21594f
C28 pre_up DOWN 0.20954f
C29 vp pre_up 0.39078f
C30 UP 3 0.37475f
C31 4 3 0.28352f
C32 2 DOWN 0.06369f
C33 UP pre_up 0.16301f
C34 inv_out_up cRef 0.28638f
C35 4 2 1.21831f
C36 1 cRef 0.66819f
C37 inv_out_up vp 1.34866f
C38 pre_down 1 0.31372f
C39 pre_down buf_in_down 0.68849f
C40 cVco cRef 8.68413f
C41 1 DOWN 0.2712f
C42 pre_down cVco 0.49553f
C43 vp 1 1.80921f
C44 buf_in_down DOWN 0.31366f
C45 vp buf_in_down 0.53675f
C46 pre_up inv_out_down 0.01204f
C47 cVco DOWN 0.52216f
C48 UP 1 0.12726f
C49 pre_up buf_in_up 0.42422f
C50 4 1 0.01071f
C51 vp cVco 3.05571f
C52 UP buf_in_down 0.11881f
C53 UP cVco 0.44237f
C54 4 cVco 0.04854f
C55 inv_out_up inv_out_down 3.46692f
C56 pre_down cRef 0.18807f
C57 pre_up 3 0.30963f
C58 DOWN cRef 0.22009f
C59 vp cRef 1.59105f
C60 pre_down DOWN 0.16673f
C61 buf_in_down buf_in_up 0.01311f
C62 pre_down vp 0.23629f
C63 cVco inv_out_down 0.57874f
C64 UP cRef 0.57348f
C65 4 cRef 0.32225f
C66 UP pre_down 0.11868f
C67 vp DOWN 0.28572f
C68 UP gnd 1.36141f
C69 DOWN gnd 1.75486f
C70 cRef gnd 3.77782f
C71 cVco gnd 5.73978f
C72 vp gnd 1.15642f
C73 4 gnd 1.85885f
C74 2 gnd 1.69774f
C75 pre_up gnd 1.74181f
C76 pre_down gnd 1.53664f
C77 buf_in_up gnd 1.16897f
C78 buf_in_down gnd 1.12498f
C79 3 gnd 1.19413f
C80 1 gnd 1.19666f
C81 inv_out_up gnd 6.51624f
C82 inv_out_down gnd 6.05741f
C83 inv_out_down.t1 gnd 0.1341f
C84 inv_out_down.t3 gnd 0.09731f
C85 inv_out_down.n0 gnd 1.34173f
C86 inv_out_down.t0 gnd 0.1341f
C87 inv_out_down.t2 gnd 0.09731f
C88 inv_out_down.n1 gnd 1.39394f
C89 inv_out_down.t4 gnd 0.37342f
C90 inv_out_down.n2 gnd 1.06958f
C91 inv_out_up.t1 gnd 0.13395f
C92 inv_out_up.t3 gnd 0.09719f
C93 inv_out_up.n0 gnd 1.11672f
C94 inv_out_up.t4 gnd 0.36212f
C95 inv_out_up.n1 gnd 1.16438f
C96 inv_out_up.t0 gnd 0.13395f
C97 inv_out_up.t2 gnd 0.09719f
C98 inv_out_up.n2 gnd 1.12409f
C99 1.t6 gnd 0.16646f
C100 1.t2 gnd 0.1676f
C101 1.t0 gnd 0.19369f
C102 1.n0 gnd 1.45806f
C103 1.n1 gnd 1.24598f
C104 1.t5 gnd 0.31222f
C105 1.n2 gnd 2.04285f
C106 1.t3 gnd 0.31222f
C107 1.t4 gnd 0.35036f
C108 1.n3 gnd 0.52089f
C109 1.t1 gnd 0.19368f
C110 1.n4 gnd 1.3982f
C111 3.t1 gnd 0.18536f
C112 3.n0 gnd 1.42043f
C113 3.t0 gnd 0.18163f
C114 3.t5 gnd 0.20404f
C115 3.n1 gnd 1.51908f
C116 3.t2 gnd 0.32344f
C117 3.t3 gnd 0.20415f
C118 3.t4 gnd 0.20441f
C119 3.n2 gnd 1.96551f
C120 3.n3 gnd 0.2777f
C121 3.n4 gnd 1.59404f
C122 3.t6 gnd 0.20829f
C123 buf_in_down.t0 gnd 0.10359f
C124 buf_in_down.t1 gnd 0.11504f
C125 buf_in_down.n0 gnd 0.84141f
C126 buf_in_down.t2 gnd 0.14565f
C127 buf_in_down.t4 gnd 0.13163f
C128 buf_in_down.n1 gnd 0.24364f
C129 buf_in_down.t3 gnd 0.14565f
C130 buf_in_down.t5 gnd 0.13163f
C131 buf_in_down.n2 gnd 0.24413f
C132 buf_in_down.n3 gnd 0.03196f
C133 buf_in_up.t0 gnd 0.06889f
C134 buf_in_up.t1 gnd 0.07651f
C135 buf_in_up.n0 gnd 0.55922f
C136 buf_in_up.t2 gnd 0.09686f
C137 buf_in_up.t4 gnd 0.08754f
C138 buf_in_up.n1 gnd 0.16203f
C139 buf_in_up.t3 gnd 0.09686f
C140 buf_in_up.t5 gnd 0.08754f
C141 buf_in_up.n2 gnd 0.16235f
C142 buf_in_up.n3 gnd 0.02163f
C143 pre_down.t0 gnd 0.20827f
C144 pre_down.t2 gnd 0.11732f
C145 pre_down.n0 gnd 0.81164f
C146 pre_down.n1 gnd 1.35039f
C147 pre_down.t1 gnd 0.20072f
C148 pre_down.t3 gnd 0.1489f
C149 pre_down.t5 gnd 0.13984f
C150 pre_down.n2 gnd 0.32298f
C151 pre_down.t4 gnd 0.1489f
C152 pre_down.t6 gnd 0.13984f
C153 pre_down.n3 gnd 0.32357f
C154 pre_down.n4 gnd 0.42959f
C155 pre_up.t0 gnd 0.09343f
C156 pre_up.t2 gnd 0.20069f
C157 pre_up.n0 gnd 1.7718f
C158 pre_up.t1 gnd 0.19597f
C159 pre_up.t3 gnd 0.13475f
C160 pre_up.t5 gnd 0.12654f
C161 pre_up.n1 gnd 0.29281f
C162 pre_up.t4 gnd 0.13475f
C163 pre_up.t6 gnd 0.12654f
C164 pre_up.n2 gnd 0.29335f
C165 pre_up.n3 gnd 0.73161f
C166 pre_up.n4 gnd 0.72143f
C167 2.t4 gnd 0.09559f
C168 2.t1 gnd 0.07392f
C169 2.t3 gnd 0.07062f
C170 2.n0 gnd 0.38762f
C171 2.t2 gnd 0.07062f
C172 2.n1 gnd 0.44919f
C173 2.t0 gnd 0.07389f
C174 2.n2 gnd 0.10627f
C175 4.t1 gnd 0.05244f
C176 4.t5 gnd 0.03997f
C177 4.t2 gnd 0.03988f
C178 4.n0 gnd 0.29853f
C179 4.t0 gnd 0.04932f
C180 4.n1 gnd 0.41529f
C181 4.t3 gnd 0.04007f
C182 4.t4 gnd 0.03988f
C183 4.n2 gnd 0.28802f
C184 4.n3 gnd 0.56882f
C185 vp.n0 gnd 0.17248f
C186 vp.n1 gnd 0.01905f
C187 vp.n2 gnd 0.01567f
C188 vp.n3 gnd 0.01672f
C189 vp.n4 gnd 0.01257f
C190 vp.n5 gnd 0.0167f
C191 vp.n6 gnd 0.0126f
C192 vp.t14 gnd 0.0167f
C193 vp.n7 gnd 0.04793f
C194 vp.n8 gnd 0.06014f
C195 vp.t6 gnd 0.02243f
C196 vp.n9 gnd 0.02722f
C197 vp.n10 gnd 0.09915f
C198 vp.t10 gnd 0.02243f
C199 vp.n11 gnd 0.02739f
C200 vp.n12 gnd 0.09915f
C201 vp.t4 gnd 0.02243f
C202 vp.n13 gnd 0.02727f
C203 vp.n14 gnd 0.09915f
C204 vp.t12 gnd 0.01421f
C205 vp.n15 gnd 0.05315f
C206 vp.n16 gnd 0.06014f
C207 vp.n17 gnd 0.03144f
C208 vp.n18 gnd 0.02041f
C209 vp.n19 gnd 0.0115f
C210 vp.n20 gnd 0.01581f
C211 vp.n21 gnd 0.02905f
C212 vp.t9 gnd 0.02179f
C213 vp.n22 gnd 0.03555f
C214 vp.n23 gnd 0.07741f
C215 vp.t5 gnd 0.02243f
C216 vp.n24 gnd 0.02769f
C217 vp.n25 gnd 0.09744f
C218 vp.t22 gnd 0.02243f
C219 vp.n26 gnd 0.02297f
C220 vp.n27 gnd 0.09744f
C221 vp.t8 gnd 0.02243f
C222 vp.n28 gnd 0.09744f
C223 vp.t7 gnd 0.02179f
C224 vp.n29 gnd 0.07789f
C225 vp.n30 gnd 0.03687f
C226 vp.t3 gnd 0.01309f
C227 vp.n31 gnd 0.05193f
C228 vp.t17 gnd 0.01286f
C229 vp.n32 gnd 0.0451f
C230 vp.n33 gnd 0.01413f
C231 vp.n34 gnd 0.01801f
C232 vp.n35 gnd 0.11155f
C233 vp.n36 gnd 0.01392f
C234 vp.n37 gnd 0.03921f
C235 vp.n38 gnd 0.01422f
C236 vp.t16 gnd 0.01287f
C237 vp.n39 gnd 0.04368f
C238 vp.t2 gnd 0.01287f
C239 vp.n40 gnd 0.04382f
C240 vp.n42 gnd 0.03915f
C241 vp.n43 gnd 0.03929f
C242 vp.n44 gnd 0.01386f
C243 vp.n45 gnd 0.76475f
C244 vp.t0 gnd 9.06353f
C245 vp.n46 gnd 0.57083f
C246 cVco.t2 gnd 0.2289f
C247 cVco.t3 gnd 0.22904f
C248 cVco.n0 gnd 0.40439f
C249 cVco.t4 gnd 0.29133f
C250 cVco.n1 gnd 1.1103f
C251 cVco.t0 gnd 0.23964f
C252 cVco.n2 gnd 1.26902f
C253 cVco.t1 gnd 0.23964f
C254 cVco.n3 gnd 0.36039f
C255 cVco.t9 gnd 0.27331f
C256 cVco.t10 gnd 0.17484f
C257 cVco.t11 gnd 0.17564f
C258 cVco.n4 gnd 0.46913f
C259 cVco.n5 gnd 0.64807f
C260 cVco.t13 gnd 0.36407f
C261 cVco.t12 gnd 0.29891f
C262 cVco.n6 gnd 0.93509f
C263 cVco.n7 gnd 0.43171f
C264 cVco.t5 gnd 0.47945f
C265 cVco.t6 gnd 0.40505f
C266 cVco.n8 gnd 1.2761f
C267 cVco.n9 gnd 0.98147f
C268 cVco.t8 gnd 0.39589f
C269 cVco.t7 gnd 0.33745f
C270 cVco.n10 gnd 1.17832f
C271 cVco.n11 gnd 0.82681f
C272 cRef.t2 gnd 0.31724f
C273 cRef.t3 gnd 0.23156f
C274 cRef.t4 gnd 0.23163f
C275 cRef.n0 gnd 0.20764f
C276 cRef.n1 gnd 1.47249f
C277 cRef.t0 gnd 0.16611f
C278 cRef.t1 gnd 0.16633f
C279 cRef.n2 gnd 0.16403f
C280 cRef.n3 gnd 1.26515f
C281 cRef.t11 gnd 0.21877f
C282 cRef.t10 gnd 0.21877f
C283 cRef.t9 gnd 0.22473f
C284 cRef.n4 gnd 0.58547f
C285 cRef.n5 gnd 0.39454f
C286 cRef.t13 gnd 0.31881f
C287 cRef.t12 gnd 0.30055f
C288 cRef.n6 gnd 0.87556f
C289 cRef.n7 gnd 0.47027f
C290 cRef.t5 gnd 0.49077f
C291 cRef.t6 gnd 0.4336f
C292 cRef.n8 gnd 1.41795f
C293 cRef.n9 gnd 0.81615f
C294 cRef.t8 gnd 0.31414f
C295 cRef.t7 gnd 0.29588f
C296 cRef.n10 gnd 0.97943f
C297 cRef.n11 gnd 0.8905f
C298 DOWN.t3 gnd 0.41198f
C299 DOWN.t2 gnd 0.38477f
C300 DOWN.n0 gnd 1.79905f
C301 DOWN.t0 gnd 0.29283f
C302 DOWN.t1 gnd 0.2672f
C303 DOWN.n1 gnd 1.4034f
C304 DOWN.n2 gnd 1.55749f
C305 UP.t3 gnd 0.45354f
C306 UP.t2 gnd 0.42239f
C307 UP.n0 gnd 2.16948f
C308 UP.t0 gnd 0.29789f
C309 UP.t1 gnd 0.28112f
C310 UP.n1 gnd 1.45827f
C311 UP.n2 gnd 1.48531f
.ends
