* PEX produced on Sun May 24 05:55:07 PM CEST 2026 using /foss/tools/sak/sak-pex.sh with m=3 and s=1
* NGSPICE file created from PFD_cell_nomatch.ext - technology: ihp-sg13g2

.subckt PFD_cell_nomatch cVco UP cRef DOWN gnd vp
X0 3.t3 cVco vp.t3 vp.t0 sg13_lv_pmos ad=0.153p pd=1.58u as=0.153p ps=1.58u w=0.45u l=0.15u
X1 1.t0 DOWN.t0 2.t0 gnd.t4 sg13_lv_nmos ad=0.204p pd=1.88u as=0.114p ps=0.98u w=0.6u l=0.15u
X2 inv_out_down.t1 cRef vp.t1 vp.t0 sg13_lv_pmos ad=0.204p pd=1.88u as=0.204p ps=1.88u w=0.6u l=0.15u
X3 inv_out_up.t1 cVco vp.t4 vp.t0 sg13_lv_pmos ad=0.204p pd=1.88u as=0.204p ps=1.88u w=0.6u l=0.15u
X4 pre_down.t0 inv_out_up.t2 gnd.t3 gnd.t2 sg13_lv_nmos ad=0.204p pd=1.88u as=0.204p ps=1.88u w=0.6u l=0.15u
X5 2.t1 cRef gnd.t11 gnd.t10 sg13_lv_nmos ad=0.102p pd=1.28u as=0.102p ps=1.28u w=0.3u l=0.15u
X6 1.t2 cRef vp.t2 vp.t0 sg13_lv_pmos ad=0.153p pd=1.58u as=0.153p ps=1.58u w=0.45u l=0.15u
X7 2.t0 cVco.t0 1.t3 gnd.t10 sg13_lv_nmos ad=0.114p pd=0.98u as=0.204p ps=1.88u w=0.6u l=0.15u
X8 pre_up.t0 inv_out_down.t2 gnd.t1 gnd.t0 sg13_lv_nmos ad=0.204p pd=1.88u as=0.204p ps=1.88u w=0.6u l=0.15u
X9 4.t0 cRef 3.t1 gnd.t6 sg13_lv_nmos ad=0.114p pd=0.98u as=0.204p ps=1.88u w=0.6u l=0.15u
X10 inv_out_up.t0 cVco gnd.t13 gnd.t12 sg13_lv_nmos ad=0.204p pd=1.88u as=0.204p ps=1.88u w=0.6u l=0.15u
X11 pre_up.t1 cRef 1.t1 gnd.t9 sg13_lv_nmos ad=0.153p pd=1.58u as=0.153p ps=1.58u w=0.45u l=0.15u
X12 4.t1 cVco gnd.t15 gnd.t6 sg13_lv_nmos ad=0.102p pd=1.28u as=0.102p ps=1.28u w=0.3u l=0.15u
X13 inv_out_down.t0 cRef.t0 gnd.t8 gnd.t7 sg13_lv_nmos ad=0.204p pd=1.88u as=0.204p ps=1.88u w=0.6u l=0.15u
X14 pre_down.t1 cVco 3.t2 gnd.t14 sg13_lv_nmos ad=0.153p pd=1.58u as=0.153p ps=1.58u w=0.45u l=0.15u
X15 3.t0 UP.t0 4.t0 gnd.t5 sg13_lv_nmos ad=0.204p pd=1.88u as=0.114p ps=0.98u w=0.6u l=0.15u
R0 cRef cRef.t0 12.2077
R1 DOWN DOWN.t0 12.234
R2 cVco cVco.t0 12.5404
R3 pre_up.n0 pre_up.t0 33.3515
R4 pre_up.n0 pre_up.t1 31.644
R5 pre_up pre_up.n0 0.2799
R6 UP UP.t0 12.234
R7 pre_down.n0 pre_down.t0 33.3515
R8 pre_down.n0 pre_down.t1 31.644
R9 pre_down pre_down.n0 0.2799
R10 vp.n0 vp.t3 36.2293
R11 vp.n20 vp.t4 36.2167
R12 vp.n10 vp.t2 36.1264
R13 vp.n17 vp.t1 36.1063
R14 vp.n12 vp.n11 8.5005
R15 vp.t0 vp.n5 4.251
R16 vp.t0 vp.n4 4.251
R17 vp.t0 vp.n3 4.251
R18 vp.t0 vp.n2 4.251
R19 vp.n16 vp.n6 4.23547
R20 vp.n15 vp.n7 4.23547
R21 vp.n14 vp.n8 4.23547
R22 vp.n13 vp.n9 4.23547
R23 vp.n18 vp.n17 3.39839
R24 vp.t0 vp.n18 2.42957
R25 vp.n10 vp.n1 2.18184
R26 vp.t0 vp.n1 2.12707
R27 vp.n20 vp.n19 1.25216
R28 vp.n19 vp.n0 0.898215
R29 vp.n19 vp.t0 0.549887
R30 vp vp.n0 0.24431
R31 vp vp.n20 0.181851
R32 vp.n14 vp.n13 0.125939
R33 vp.n16 vp.n15 0.125939
R34 vp.n17 vp.n16 0.1228
R35 vp.n13 vp.n12 0.0943861
R36 vp vp.n14 0.0760528
R37 vp.n12 vp.n10 0.0619167
R38 vp.n15 vp 0.0503861
R39 vp.n11 vp.n1 0.00217635
R40 vp.n11 vp.n2 0.001
R41 vp.n9 vp.n3 0.001
R42 vp.n8 vp.n4 0.001
R43 vp.n7 vp.n5 0.001
R44 vp.n18 vp.n6 0.001
R45 vp.n6 vp.n5 0.001
R46 vp.n7 vp.n4 0.001
R47 vp.n8 vp.n3 0.001
R48 vp.n9 vp.n2 0.001
R49 gnd.t14 gnd.n15 858.278
R50 gnd.n13 gnd.t9 354.531
R51 gnd.n16 gnd.t14 354.531
R52 gnd.n13 gnd.t4 111.424
R53 gnd.n16 gnd.t5 111.424
R54 gnd.n15 gnd.t7 91.8166
R55 gnd.n4 gnd.t2 75.481
R56 gnd.n9 gnd.t0 75.4809
R57 gnd.t10 gnd.n6 68.1812
R58 gnd.t6 gnd.n2 68.1812
R59 gnd.n8 gnd.t10 61.9751
R60 gnd.n3 gnd.t6 61.9751
R61 gnd.t0 gnd.n8 55.2232
R62 gnd.t2 gnd.n3 55.2232
R63 gnd.n9 gnd.t7 38.3397
R64 gnd.n5 gnd.t13 37.1008
R65 gnd.n11 gnd.t8 37.0785
R66 gnd.n10 gnd.t1 36.9275
R67 gnd.n1 gnd.t3 36.9275
R68 gnd.n0 gnd.t15 35.9961
R69 gnd.n12 gnd.t11 35.9961
R70 gnd.n4 gnd.t12 27.6642
R71 gnd.t4 gnd.n6 10.7811
R72 gnd.t5 gnd.n2 10.7811
R73 gnd.n17 gnd.n16 8.5005
R74 gnd.n14 gnd.n13 8.5005
R75 gnd.n18 gnd.n17 2.80696
R76 gnd.n14 gnd.n7 2.80696
R77 gnd.n17 gnd.n5 1.6527
R78 gnd.n14 gnd.n11 1.36876
R79 gnd.n17 gnd.n0 1.20866
R80 gnd.n14 gnd.n12 1.20866
R81 gnd.n15 gnd.n14 0.549427
R82 gnd.n17 gnd.n2 0.549178
R83 gnd.n14 gnd.n6 0.549178
R84 gnd.n11 gnd.n10 0.194923
R85 gnd.n5 gnd.n1 0.174226
R86 gnd gnd.n0 0.123957
R87 gnd.n12 gnd 0.123957
R88 gnd gnd.n18 0.123706
R89 gnd gnd.n7 0.123706
R90 gnd.n18 gnd.n1 0.0754625
R91 gnd.n10 gnd.n7 0.0754625
R92 gnd.n14 gnd.n9 0.00115126
R93 gnd.n17 gnd.n4 0.00110654
R94 gnd.n17 gnd.n3 0.00101177
R95 gnd.n14 gnd.n8 0.00101177
R96 2.t1 2.n0 21.6053
R97 2 2.n0 0.2821
R98 2.n0 2.t0 31.5431
R99 4.t1 4.n0 21.6053
R100 4 4.n0 0.2821
R101 4.n0 4.t0 31.5431
R102 1.t1 1.n2 27.0912
R103 1.n0 1.n1 0.1369
R104 1.n0 1.n2 0.0929
R105 1.n2 1.t0 26.7395
R106 1.n1 1.t3 26.9727
R107 1.n1 1.t2 27.7292
R108 1 1.n0 1.6685
R109 inv_out_down.t0 inv_out_down.n0 17.0267
R110 inv_out_down inv_out_down.n0 0.93108
R111 inv_out_down inv_out_down.t2 8.11825
R112 inv_out_down.n0 inv_out_down.t1 37.4071
R113 3.t2 3.n2 27.0912
R114 3.n0 3.n1 0.1369
R115 3.n0 3.n2 0.0929
R116 3.n2 3.t0 26.7395
R117 3.n1 3.t1 26.9727
R118 3.n1 3.t3 27.7292
R119 3 3.n0 1.6685
R120 inv_out_up.t0 inv_out_up.n0 17.0267
R121 inv_out_up.n0 inv_out_up.t2 9.04883
R122 inv_out_up.n0 inv_out_up.t1 37.4071
C0 cVco pre_up 0.01216f
C1 cVco pre_down 0.03392f
C2 1 2 0.73514f
C3 1 DOWN 0.08089f
C4 vp cRef 0.76438f
C5 3 cRef 0.08137f
C6 1 inv_out_down 0.03313f
C7 4 UP 0.01512f
C8 pre_up cRef 0.03392f
C9 cRef pre_down 0.01231f
C10 3 vp 0.52956f
C11 cVco 2 0.02533f
C12 cVco 4 0.09699f
C13 pre_up vp 0.05596f
C14 vp pre_down 0.09011f
C15 cVco DOWN 0.13971f
C16 3 pre_down 0.91116f
C17 cVco 1 0.08119f
C18 cRef 2 0.09699f
C19 4 cRef 0.02531f
C20 cVco UP 0.06277f
C21 DOWN cRef 0.06255f
C22 cRef inv_out_down 0.07138f
C23 4 3 0.73514f
C24 vp inv_out_down 0.51127f
C25 1 cRef 0.03064f
C26 3 inv_out_down 0.0219f
C27 1 vp 0.46304f
C28 pre_up inv_out_down 0.07556f
C29 inv_out_down pre_down 0.02808f
C30 UP cRef 0.13978f
C31 pre_up 1 0.91116f
C32 cVco cRef 0.13838f
C33 UP 3 0.08089f
C34 cVco vp 0.76164f
C35 cVco 3 0.03064f
C36 DOWN 2 0.01512f
C37 cRef gnd 2.7065f
C38 DOWN gnd 0.30426f
C39 cVco gnd 2.64405f
C40 pre_up gnd 0.95293f
C41 UP gnd 0.30409f
C42 pre_down gnd 0.87428f
C43 vp gnd 0.27254f
C44 2 gnd 0.59809f
C45 4 gnd 0.59186f
C46 1 gnd 0.74984f
C47 inv_out_down gnd 1.03965f
C48 3 gnd 0.64113f
C49 inv_out_up.t0 gnd 0.04319f
C50 inv_out_up.n0 gnd 0.41019f
C51 inv_out_up.t1 gnd 0.16008f
C52 inv_out_up.t2 gnd 0.07111f
C53 3.t2 gnd 0.12433f
C54 3.n0 gnd 0.03822f
C55 3.t3 gnd 0.13438f
C56 3.n1 gnd 0.90308f
C57 3.t1 gnd 0.14678f
C58 3.t0 gnd 0.14359f
C59 3.n2 gnd 0.70933f
C60 inv_out_down.t0 gnd 0.047f
C61 inv_out_down.n0 gnd 0.36483f
C62 inv_out_down.t1 gnd 0.1742f
C63 inv_out_down.t2 gnd 0.06804f
C64 1.t1 gnd 0.11979f
C65 1.n0 gnd 0.03683f
C66 1.t2 gnd 0.12947f
C67 1.n1 gnd 0.8701f
C68 1.t3 gnd 0.14142f
C69 1.t0 gnd 0.13835f
C70 1.n2 gnd 0.68343f
C71 4.t1 gnd 0.06679f
C72 4.n0 gnd 0.50795f
C73 4.t0 gnd 0.23754f
C74 2.t1 gnd 0.06678f
C75 2.n0 gnd 0.50792f
C76 2.t0 gnd 0.23753f
C77 vp.t3 gnd 0.01743f
C78 vp.n0 gnd 0.07011f
C79 vp.n1 gnd 0.02161f
C80 vp.n6 gnd 0.01777f
C81 vp.t1 gnd 0.019f
C82 vp.n7 gnd 0.01777f
C83 vp.n8 gnd 0.01777f
C84 vp.n9 gnd 0.01777f
C85 vp.t2 gnd 0.01726f
C86 vp.n10 gnd 0.05115f
C87 vp.n11 gnd 0.0247f
C88 vp.n13 gnd 0.01137f
C89 vp.n14 gnd 0.01023f
C90 vp.n16 gnd 0.01329f
C91 vp.n17 gnd 0.04517f
C92 vp.n18 gnd 0.028f
C93 vp.t0 gnd 3.0032f
C94 vp.n19 gnd 0.14563f
C95 vp.t4 gnd 0.01915f
C96 vp.n20 gnd 0.05733f
C97 pre_down.t0 gnd 0.17323f
C98 pre_down.t1 gnd 0.13394f
C99 pre_down.n0 gnd 0.81228f
C100 UP.t0 gnd 0.17535f
C101 pre_up.t0 gnd 0.16386f
C102 pre_up.t1 gnd 0.1267f
C103 pre_up.n0 gnd 0.76837f
C104 cVco.t0 gnd 0.63849f
C105 DOWN.t0 gnd 0.17518f
C106 cRef.t0 gnd 0.59012f
.ends
