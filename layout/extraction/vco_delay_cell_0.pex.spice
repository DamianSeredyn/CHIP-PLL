* PEX produced on Mon Aug 10 05:16:37 PM CEST 2026 using /foss/tools/sak/sak-pex.sh with m=2 and s=1
* NGSPICE file created from vco_delay_cell_0.ext - technology: ihp-sg13cmos5l

.subckt vco_delay_cell_0 ngt pgt out in gnd vp
X0 a_n14_206# in out vp sg13_lv_pmos ad=0.204p pd=1.88u as=0.114p ps=0.98u w=0.6u l=0.36u
X1 out in a_n14_206# vp sg13_lv_pmos ad=0.114p pd=0.98u as=0.204p ps=1.88u w=0.6u l=0.36u
X2 a_n16_n222# ngt gnd gnd sg13_lv_nmos ad=76f pd=0.78u as=0.136p ps=1.48u w=0.4u l=0.76u
X3 a_n16_n222# in out gnd sg13_lv_nmos ad=0.136p pd=1.48u as=76f ps=0.78u w=0.4u l=0.36u
X4 gnd ngt a_n16_n222# gnd sg13_lv_nmos ad=0.136p pd=1.48u as=76f ps=0.78u w=0.4u l=0.76u
X5 out in a_n16_n222# gnd sg13_lv_nmos ad=76f pd=0.78u as=0.136p ps=1.48u w=0.4u l=0.36u
X6 vp pgt a_n14_206# vp sg13_lv_pmos ad=0.204p pd=1.88u as=0.114p ps=0.98u w=0.6u l=0.72u
X7 a_n14_206# pgt vp vp sg13_lv_pmos ad=0.114p pd=0.98u as=0.204p ps=1.88u w=0.6u l=0.72u
C0 pgt out 0.03565f
C1 a_n16_n222# out 0.17336f
C2 out in 0.31805f
C3 vp pgt 1.0433f
C4 vp in 0.30783f
C5 vp out 0.05866f
C6 a_n14_206# pgt 0.17965f
C7 a_n14_206# in 0.09397f
C8 a_n14_206# out 0.18615f
C9 vp a_n14_206# 0.16858f
C10 ngt a_n16_n222# 0.19936f
C11 ngt in 0.0797f
C12 ngt out 0.03799f
C13 pgt in 0.08351f
C14 a_n16_n222# in 0.07764f
C15 out gnd 0.4424f
C16 vp gnd 0.19656f
C17 a_n16_n222# gnd 0.74363f
C18 a_n14_206# gnd 0.35068f
.ends
