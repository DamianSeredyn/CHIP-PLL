* PEX produced on Mon Aug 10 09:56:54 PM CEST 2026 using /foss/tools/sak/sak-pex.sh with m=2 and s=1
* NGSPICE file created from vco_delay_cell_0.ext - technology: ihp-sg13g2

.subckt vco_delay_cell_0 ngt pgt out in gnd vp
X0 gnd ngt a_n16_n222# gnd sg13_lv_nmos ad=0.136p pd=1.48u as=76f ps=0.78u w=0.4u l=0.64u
X1 out in a_n14_206# vp sg13_lv_pmos ad=0.114p pd=0.98u as=0.204p ps=1.88u w=0.6u l=0.32u
X2 a_n16_n222# ngt gnd gnd sg13_lv_nmos ad=76f pd=0.78u as=0.136p ps=1.48u w=0.4u l=0.64u
X3 a_n16_n222# in out gnd sg13_lv_nmos ad=0.136p pd=1.48u as=76f ps=0.78u w=0.4u l=0.32u
X4 a_n14_206# in out vp sg13_lv_pmos ad=0.204p pd=1.88u as=0.114p ps=0.98u w=0.6u l=0.32u
X5 vp pgt a_n14_206# vp sg13_lv_pmos ad=0.204p pd=1.88u as=0.114p ps=0.98u w=0.6u l=0.64u
X6 out in a_n16_n222# gnd sg13_lv_nmos ad=76f pd=0.78u as=0.136p ps=1.48u w=0.4u l=0.32u
X7 a_n14_206# pgt vp vp sg13_lv_pmos ad=0.114p pd=0.98u as=0.204p ps=1.88u w=0.6u l=0.64u
C0 vp in 0.30301f
C1 pgt in 0.04109f
C2 out a_n16_n222# 0.14545f
C3 a_n16_n222# ngt 0.16201f
C4 out a_n14_206# 0.1574f
C5 out ngt 0.02665f
C6 out vp 0.06147f
C7 vp a_n14_206# 0.15567f
C8 out pgt 0.02781f
C9 a_n14_206# pgt 0.15311f
C10 in a_n16_n222# 0.06874f
C11 out in 0.26417f
C12 vp pgt 0.96491f
C13 a_n14_206# in 0.08442f
C14 in ngt 0.04086f
C15 out gnd 0.43966f
C16 vp gnd 0.19058f
C17 a_n16_n222# gnd 0.71528f
C18 a_n14_206# gnd 0.34319f
.ends
