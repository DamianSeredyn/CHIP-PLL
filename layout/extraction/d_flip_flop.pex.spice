* PEX produced on Thu Aug  6 05:35:24 PM CEST 2026 using /foss/tools/sak/sak-pex.sh with m=2 and s=1
* NGSPICE file created from d_flip_flop.ext - technology: ihp-sg13g2

.subckt d_flip_flop VP GND q d q_ clk
X0 q_ NAND_3in_nmosx3_0.y VP VP sg13_lv_pmos ad=55.5f pd=0.74u as=0.1005p ps=1.34u w=0.15u l=0.13u
X1 NAND_2in_nmosx2_2.y NAND_2in_nmosx2_2.b ntap1$3_2.well ntap1$3_2.well sg13_lv_pmos ad=55.5f pd=0.74u as=0.1005p ps=1.34u w=0.15u l=0.13u
X2 a_295_487# NAND_2in_nmosx2_2.b GND GND sg13_lv_nmos ad=57f pd=0.68u as=0.102p ps=1.28u w=0.3u l=0.13u
X3 NAND_2in_nmosx2_2.y NAND_2in_nmosx2_0.y a_295_487# GND sg13_lv_nmos ad=0.102p pd=1.28u as=57f ps=0.68u w=0.3u l=0.13u
X4 ntap1$3_2.well NAND_2in_nmosx2_3.a q ntap1$3_2.well sg13_lv_pmos ad=0.1005p pd=1.34u as=55.5f ps=0.74u w=0.15u l=0.13u
X5 NAND_3in_nmosx3_0.y NAND_2in_nmosx2_2.y a_425_49# GND sg13_lv_nmos ad=0.102p pd=1.28u as=57f ps=0.68u w=0.3u l=0.13u
X6 NAND_3in_nmosx3_0.y NAND_2in_nmosx2_2.y VP VP sg13_lv_pmos ad=0.1005p pd=1.34u as=55.5f ps=0.74u w=0.15u l=0.13u
X7 ntap1$3_2.well NAND_2in_nmosx2_0.a NAND_2in_nmosx2_0.y ntap1$3_2.well sg13_lv_pmos ad=0.1005p pd=1.34u as=55.5f ps=0.74u w=0.15u l=0.13u
X8 NAND_3in_nmosx3_0.y NAND_2in_nmosx2_0.a VP VP sg13_lv_pmos ad=55.5f pd=0.74u as=0.1005p ps=1.34u w=0.15u l=0.13u
X9 a_323_49# NAND_2in_nmosx2_0.a GND GND sg13_lv_nmos ad=57f pd=0.68u as=0.102p ps=1.28u w=0.3u l=0.13u
X10 a_1179_49# d GND GND sg13_lv_nmos ad=57f pd=0.68u as=0.102p ps=1.28u w=0.3u l=0.13u
X11 a_907_487# NAND_2in_nmosx2_0.b GND GND sg13_lv_nmos ad=57f pd=0.68u as=0.102p ps=1.28u w=0.3u l=0.13u
X12 NAND_2in_nmosx2_0.y NAND_2in_nmosx2_0.a a_907_487# GND sg13_lv_nmos ad=0.102p pd=1.28u as=57f ps=0.68u w=0.3u l=0.13u
X13 q_ q a_1927_49# GND sg13_lv_nmos ad=0.102p pd=1.28u as=57f ps=0.68u w=0.3u l=0.13u
X14 VP NAND_2in_nmosx2_4.a NAND_2in_nmosx2_0.a VP sg13_lv_pmos ad=0.1005p pd=1.34u as=55.5f ps=0.74u w=0.15u l=0.13u
X15 a_1927_49# NAND_3in_nmosx3_0.y GND GND sg13_lv_nmos ad=57f pd=0.68u as=0.102p ps=1.28u w=0.3u l=0.13u
X16 ntap1$3_2.well NAND_2in_nmosx2_0.y NAND_2in_nmosx2_2.y ntap1$3_2.well sg13_lv_pmos ad=0.1005p pd=1.34u as=55.5f ps=0.74u w=0.15u l=0.13u
X17 VP q q_ VP sg13_lv_pmos ad=0.1005p pd=1.34u as=55.5f ps=0.74u w=0.15u l=0.13u
X18 q q_ ntap1$3_2.well ntap1$3_2.well sg13_lv_pmos ad=55.5f pd=0.74u as=0.1005p ps=1.34u w=0.15u l=0.13u
X19 VP clk NAND_3in_nmosx3_0.y VP sg13_lv_pmos ad=55.5f pd=0.74u as=55.5f ps=0.74u w=0.15u l=0.13u
X20 NAND_2in_nmosx2_0.a d VP VP sg13_lv_pmos ad=55.5f pd=0.74u as=0.1005p ps=1.34u w=0.15u l=0.13u
X21 NAND_2in_nmosx2_0.y NAND_2in_nmosx2_0.b ntap1$3_2.well ntap1$3_2.well sg13_lv_pmos ad=55.5f pd=0.74u as=0.1005p ps=1.34u w=0.15u l=0.13u
X22 a_1587_487# q_ GND GND sg13_lv_nmos ad=57f pd=0.68u as=0.102p ps=1.28u w=0.3u l=0.13u
X23 q NAND_2in_nmosx2_3.a a_1587_487# GND sg13_lv_nmos ad=0.102p pd=1.28u as=57f ps=0.68u w=0.3u l=0.13u
X24 a_425_49# clk a_323_49# GND sg13_lv_nmos ad=57f pd=0.68u as=57f ps=0.68u w=0.3u l=0.13u
X25 NAND_2in_nmosx2_0.a NAND_2in_nmosx2_4.a a_1179_49# GND sg13_lv_nmos ad=0.102p pd=1.28u as=57f ps=0.68u w=0.3u l=0.13u
C0 a_1587_487# q 0.07824f
C1 NAND_2in_nmosx2_0.a a_1179_49# 0.07954f
C2 clk NAND_2in_nmosx2_2.y 0.9827f
C3 NAND_2in_nmosx2_3.a NAND_2in_nmosx2_2.y 0.04749f
C4 NAND_2in_nmosx2_4.a VP 0.13325f
C5 NAND_2in_nmosx2_3.a q 0.08053f
C6 ntap1$3_2.well clk 0.03404f
C7 ntap1$3_2.well NAND_2in_nmosx2_3.a 0.12261f
C8 NAND_2in_nmosx2_0.b q_ 0.01003f
C9 NAND_2in_nmosx2_0.y NAND_2in_nmosx2_2.y 0.60257f
C10 q NAND_2in_nmosx2_0.y 0.04208f
C11 ntap1$3_2.well NAND_2in_nmosx2_0.y 0.38341f
C12 NAND_2in_nmosx2_0.a clk 0.51815f
C13 NAND_2in_nmosx2_0.b NAND_2in_nmosx2_2.b 0.01051f
C14 NAND_2in_nmosx2_0.a NAND_2in_nmosx2_0.y 0.36593f
C15 a_907_487# NAND_2in_nmosx2_0.a 0.01292f
C16 NAND_3in_nmosx3_0.y clk 0.14302f
C17 q NAND_2in_nmosx2_2.y 0.06217f
C18 NAND_2in_nmosx2_3.a q_ 0.41327f
C19 ntap1$3_2.well NAND_2in_nmosx2_2.y 0.33665f
C20 a_323_49# a_425_49# 0.07705f
C21 ntap1$3_2.well q 0.28151f
C22 clk VP 0.16254f
C23 clk NAND_2in_nmosx2_2.b 0.05051f
C24 NAND_3in_nmosx3_0.y NAND_2in_nmosx2_0.y 0.02394f
C25 NAND_2in_nmosx2_0.y q_ 0.08114f
C26 NAND_2in_nmosx2_0.a NAND_2in_nmosx2_2.y 0.14678f
C27 ntap1$3_2.well NAND_2in_nmosx2_0.a 0.13793f
C28 NAND_2in_nmosx2_0.y NAND_2in_nmosx2_2.b 0.40148f
C29 NAND_2in_nmosx2_2.y d 0.04419f
C30 a_1927_49# q 0.01327f
C31 NAND_3in_nmosx3_0.y NAND_2in_nmosx2_2.y 0.18719f
C32 NAND_2in_nmosx2_2.y q_ 0.12331f
C33 a_295_487# NAND_2in_nmosx2_2.y 0.08176f
C34 NAND_3in_nmosx3_0.y q 0.41259f
C35 q q_ 0.71f
C36 ntap1$3_2.well q_ 0.19474f
C37 NAND_2in_nmosx2_2.y VP 0.14179f
C38 NAND_2in_nmosx2_0.a d 0.08724f
C39 NAND_2in_nmosx2_2.b NAND_2in_nmosx2_2.y 0.07024f
C40 q VP 0.1243f
C41 NAND_2in_nmosx2_0.b NAND_2in_nmosx2_0.y 0.1105f
C42 ntap1$3_2.well NAND_2in_nmosx2_2.b 0.14418f
C43 NAND_3in_nmosx3_0.y NAND_2in_nmosx2_0.a 1.08786f
C44 NAND_2in_nmosx2_4.a NAND_2in_nmosx2_2.y 0.01062f
C45 NAND_2in_nmosx2_0.a q_ 0.26038f
C46 a_1927_49# q_ 0.07616f
C47 NAND_3in_nmosx3_0.y d 0.03621f
C48 NAND_3in_nmosx3_0.y a_425_49# 0.07878f
C49 NAND_2in_nmosx2_0.a VP 0.45704f
C50 d VP 0.1695f
C51 NAND_2in_nmosx2_0.b NAND_2in_nmosx2_2.y 0.06366f
C52 NAND_3in_nmosx3_0.y q_ 0.34924f
C53 NAND_2in_nmosx2_4.a NAND_2in_nmosx2_0.a 0.07718f
C54 ntap1$3_2.well NAND_2in_nmosx2_0.b 0.15541f
C55 NAND_3in_nmosx3_0.y VP 0.60024f
C56 VP q_ 0.26964f
C57 NAND_2in_nmosx2_4.a d 0.40087f
C58 a_907_487# NAND_2in_nmosx2_0.y 0.07602f
C59 NAND_2in_nmosx2_0.a NAND_2in_nmosx2_0.b 0.42743f
C60 NAND_2in_nmosx2_4.a NAND_3in_nmosx3_0.y 0.12614f
C61 NAND_2in_nmosx2_4.a q_ 0.02672f
C62 q GND 1.00348f
C63 VP GND 1.32185f
C64 a_1927_49# GND 1.05364f
C65 a_1179_49# GND 0.22886f
C66 a_425_49# GND 0.80104f
C67 a_323_49# GND 0.101f
C68 NAND_3in_nmosx3_0.y GND 0.33337f
C69 a_1587_487# GND 0.10128f
C70 a_907_487# GND 0.21982f
C71 a_295_487# GND 0.4126f
C72 NAND_2in_nmosx2_0.a GND 0.1318f
C73 NAND_2in_nmosx2_2.y GND 0.28168f
C74 ntap1$3_2.well GND 2.54747f
.ends
