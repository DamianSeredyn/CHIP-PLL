* PEX produced on Sun Jul 26 02:47:21 PM CEST 2026 using /foss/tools/sak/sak-pex.sh with m=3 and s=1
* NGSPICE file created from d_flip_flop.ext - technology: ihp-sg13g2

.subckt d_flip_flop VP GND q q_ d clk
X0 NAND_2in_nmosx2_0.y.t0 NAND_2in_nmosx2_0.b.t7 VP VP sg13_lv_pmos ad=55.5f pd=0.74u as=0.1005p ps=1.34u w=0.15u l=0.13u
X1 a_1926_n50.t0 NAND_3in_nmosx3_0.y.t5 GND.t1 GND.t0 sg13_lv_nmos ad=57f pd=0.68u as=0.102p ps=1.28u w=0.3u l=0.13u
X2 VP.t7 NAND_3in_nmosx3_0.y.t4 NAND_2in_nmosx2_0.a.t1 VP.t0 sg13_lv_pmos ad=0.1005p pd=1.34u as=55.5f ps=0.74u w=0.15u l=0.13u
X3 NAND_3in_nmosx3_0.y.t1 NAND_2in_nmosx2_0.b.t3 a_424_n50.t0 GND.t16 sg13_lv_nmos ad=0.102p pd=1.28u as=57f ps=0.68u w=0.3u l=0.13u
X4 VP.t15 q.t2 q_.t0 VP.t0 sg13_lv_pmos ad=0.1005p pd=1.34u as=55.5f ps=0.74u w=0.15u l=0.13u
X5 a_1586_388.t0 q_.t2 GND.t8 GND.t7 sg13_lv_nmos ad=57f pd=0.68u as=0.102p ps=1.28u w=0.3u l=0.13u
X6 NAND_2in_nmosx2_0.b.t1 clk.t3 VP VP sg13_lv_pmos ad=55.5f pd=0.74u as=0.1005p ps=1.34u w=0.15u l=0.13u
X7 VP NAND_2in_nmosx2_0.b.t6 q.t0 VP sg13_lv_pmos ad=0.1005p pd=1.34u as=55.5f ps=0.74u w=0.15u l=0.13u
X8 q.t1 NAND_2in_nmosx2_0.b.t4 a_1586_388.t0 GND.t15 sg13_lv_nmos ad=0.102p pd=1.28u as=57f ps=0.68u w=0.3u l=0.13u
X9 VP.t12 clk.t0 NAND_3in_nmosx3_0.y.t0 VP.t0 sg13_lv_pmos ad=55.5f pd=0.74u as=55.5f ps=0.74u w=0.15u l=0.13u
X10 NAND_2in_nmosx2_0.a.t1 d.t0 VP.t16 VP.t0 sg13_lv_pmos ad=55.5f pd=0.74u as=0.1005p ps=1.34u w=0.15u l=0.13u
X11 VP NAND_2in_nmosx2_0.a.t5 NAND_2in_nmosx2_0.y.t0 VP sg13_lv_pmos ad=0.1005p pd=1.34u as=55.5f ps=0.74u w=0.15u l=0.13u
X12 a_294_388.t0 clk.t2 GND.t10 GND.t9 sg13_lv_nmos ad=57f pd=0.68u as=0.102p ps=1.28u w=0.3u l=0.13u
X13 NAND_2in_nmosx2_0.b.t0 NAND_2in_nmosx2_0.y.t2 a_294_388.t0 GND.t5 sg13_lv_nmos ad=0.102p pd=1.28u as=57f ps=0.68u w=0.3u l=0.13u
X14 a_1178_n50.t0 d.t1 GND.t14 GND.t13 sg13_lv_nmos ad=57f pd=0.68u as=0.102p ps=1.28u w=0.3u l=0.13u
X15 NAND_2in_nmosx2_0.a.t0 NAND_3in_nmosx3_0.y.t6 a_1178_n50.t0 GND.t6 sg13_lv_nmos ad=0.102p pd=1.28u as=57f ps=0.68u w=0.3u l=0.13u
X16 q_.t0 NAND_3in_nmosx3_0.y.t3 VP.t1 VP.t0 sg13_lv_pmos ad=55.5f pd=0.74u as=0.1005p ps=1.34u w=0.15u l=0.13u
X17 VP NAND_2in_nmosx2_0.y.t3 NAND_2in_nmosx2_0.b.t1 VP sg13_lv_pmos ad=0.1005p pd=1.34u as=55.5f ps=0.74u w=0.15u l=0.13u
X18 a_906_388.t0 NAND_2in_nmosx2_0.b.t5 GND.t18 GND.t17 sg13_lv_nmos ad=57f pd=0.68u as=0.102p ps=1.28u w=0.3u l=0.13u
X19 NAND_3in_nmosx3_0.y.t2 NAND_2in_nmosx2_0.b.t2 VP.t12 VP.t0 sg13_lv_pmos ad=0.1005p pd=1.34u as=55.5f ps=0.74u w=0.15u l=0.13u
X20 a_322_n50.t0 NAND_2in_nmosx2_0.a.t3 GND.t3 GND.t2 sg13_lv_nmos ad=57f pd=0.68u as=0.102p ps=1.28u w=0.3u l=0.13u
X21 NAND_2in_nmosx2_0.y.t1 NAND_2in_nmosx2_0.a.t4 a_906_388.t0 GND.t4 sg13_lv_nmos ad=0.102p pd=1.28u as=57f ps=0.68u w=0.3u l=0.13u
X22 q_.t1 q.t3 a_1926_n50.t0 GND.t12 sg13_lv_nmos ad=0.102p pd=1.28u as=57f ps=0.68u w=0.3u l=0.13u
X23 a_424_n50.t0 clk.t1 a_322_n50.t0 GND.t11 sg13_lv_nmos ad=57f pd=0.68u as=57f ps=0.68u w=0.3u l=0.13u
X24 q.t0 q_.t3 VP VP sg13_lv_pmos ad=55.5f pd=0.74u as=0.1005p ps=1.34u w=0.15u l=0.13u
X25 NAND_3in_nmosx3_0.y.t0 NAND_2in_nmosx2_0.a.t2 VP.t2 VP.t0 sg13_lv_pmos ad=55.5f pd=0.74u as=0.1005p ps=1.34u w=0.15u l=0.13u
R0 d.n0 d.t1 8.57008
R1 d.n0 d.t0 7.51402
R2 d d.n0 4.58528
R3 q.n3 q.t1 26.9853
R4 q.n3 q.t0 26.9107
R5 q.n2 q.n1 9.5333
R6 q.n0 q.t2 8.57008
R7 q.n0 q.t3 7.51402
R8 q q.n3 4.7799
R9 q.n1 q.n0 4.53248
R10 q q.n2 0.3019
R11 q.n2 q 0.1743
R12 q.n1 q 0.0585426
R13 q_.n0 q_.t1 26.9853
R14 q_.n0 q_.t0 26.9107
R15 q_.n3 q_.n1 12.1671
R16 q_.n2 q_.t2 8.57008
R17 q_.n2 q_.t3 7.51402
R18 q_.n3 q_.n2 4.53248
R19 q_.n1 q_.n0 4.5005
R20 q_.n1 q_ 0.2799
R21 q_ q_.n3 0.0914333
R22 clk.n0 clk.t2 8.57008
R23 clk.n2 clk.t1 8.57008
R24 clk.n0 clk.t3 7.51402
R25 clk.n2 clk.t0 7.51402
R26 clk clk.n1 5.81233
R27 clk.n1 clk.n0 4.60582
R28 clk clk.n2 4.57648
R29 clk.n1 clk 0.0181
R30 VP.n1 VP.t2 17.6412
R31 VP.n45 VP.t15 17.633
R32 VP.n16 VP.t1 17.633
R33 VP.n17 VP.t7 17.633
R34 VP.n29 VP.t16 17.633
R35 VP.n18 VP.t12 17.633
R36 VP.n3 VP.n0 8.5005
R37 VP.n19 VP.n3 8.5005
R38 VP.n27 VP.n26 8.5005
R39 VP.n28 VP.n27 8.5005
R40 VP.n33 VP.n32 8.5005
R41 VP.n34 VP.n33 8.5005
R42 VP.n42 VP.n41 8.5005
R43 VP.n43 VP.n42 8.5005
R44 VP.n46 VP.n45 4.28428
R45 VP.n47 VP.t0 4.251
R46 VP.t0 VP.n14 4.251
R47 VP.t0 VP.n13 4.251
R48 VP.t0 VP.n12 4.251
R49 VP.t0 VP.n11 4.251
R50 VP.t0 VP.n10 4.251
R51 VP.t0 VP.n9 4.251
R52 VP.t0 VP.n8 4.251
R53 VP.t0 VP.n7 4.251
R54 VP.t0 VP.n6 4.251
R55 VP.t0 VP.n5 4.251
R56 VP.t0 VP.n4 4.251
R57 VP.n49 VP.n48 4.23547
R58 VP.n21 VP.n20 4.23547
R59 VP.n23 VP.n22 4.23547
R60 VP.n25 VP.n24 4.23547
R61 VP.n31 VP.n30 4.23547
R62 VP.n36 VP.n35 4.23547
R63 VP.n38 VP.n37 4.23547
R64 VP.n40 VP.n39 4.23547
R65 VP.n44 VP.n15 4.23547
R66 VP.n2 VP.n1 3.4151
R67 VP.t0 VP.n46 2.83444
R68 VP.t0 VP.n2 2.42961
R69 VP.n40 VP.n38 0.125939
R70 VP.n38 VP.n36 0.125939
R71 VP.n25 VP.n23 0.125939
R72 VP.n23 VP.n21 0.125939
R73 VP.n49 VP.n1 0.10638
R74 VP.n44 VP.n43 0.0943861
R75 VP.n41 VP.n40 0.0943861
R76 VP.n36 VP.n34 0.0943861
R77 VP.n32 VP.n31 0.0943861
R78 VP.n26 VP.n25 0.0943861
R79 VP.n21 VP.n19 0.0943861
R80 VP.n45 VP.n44 0.0769695
R81 VP.n31 VP.n29 0.0714695
R82 VP.n19 VP.n18 0.0600833
R83 VP VP.n0 0.0509167
R84 VP.n26 VP 0.0481667
R85 VP.n32 VP.n17 0.0454167
R86 VP VP.n49 0.0439695
R87 VP.n43 VP.n16 0.0399167
R88 VP.n34 VP.n17 0.0179167
R89 VP.n28 VP 0.0151667
R90 VP.n41 VP 0.0124167
R91 VP VP.n28 0.0124167
R92 VP VP.n16 0.0115
R93 VP.n29 VP 0.0115
R94 VP.n18 VP.n0 0.00325
R95 VP.n48 VP.n2 0.00171429
R96 VP.n46 VP.n15 0.00166667
R97 VP.n15 VP.n4 0.001
R98 VP.n42 VP.n5 0.001
R99 VP.n39 VP.n6 0.001
R100 VP.n37 VP.n7 0.001
R101 VP.n35 VP.n8 0.001
R102 VP.n33 VP.n9 0.001
R103 VP.n30 VP.n10 0.001
R104 VP.n27 VP.n11 0.001
R105 VP.n24 VP.n12 0.001
R106 VP.n22 VP.n13 0.001
R107 VP.n20 VP.n14 0.001
R108 VP.n47 VP.n3 0.001
R109 VP.n48 VP.n47 0.001
R110 VP.n14 VP.n3 0.001
R111 VP.n20 VP.n13 0.001
R112 VP.n22 VP.n12 0.001
R113 VP.n24 VP.n11 0.001
R114 VP.n27 VP.n10 0.001
R115 VP.n30 VP.n9 0.001
R116 VP.n33 VP.n8 0.001
R117 VP.n35 VP.n7 0.001
R118 VP.n37 VP.n6 0.001
R119 VP.n39 VP.n5 0.001
R120 VP.n42 VP.n4 0.001
R121 GND.n18 GND.t11 130.233
R122 GND.n23 GND.t12 120.93
R123 GND.n3 GND.t15 120.93
R124 GND.n6 GND.t6 120.93
R125 GND.t4 GND.n10 120.93
R126 GND.n14 GND.t5 120.93
R127 GND.n23 GND.t0 116.279
R128 GND.t7 GND.n3 116.279
R129 GND.t13 GND.n6 116.279
R130 GND.t17 GND.n10 116.279
R131 GND.n18 GND.t16 106.978
R132 GND.t2 GND.t9 65.1168
R133 GND.t16 GND.n11 59.2513
R134 GND.n14 GND.t2 51.1633
R135 GND.n11 GND.t17 49.949
R136 GND.n5 GND.t7 49.9489
R137 GND.t0 GND.n2 49.948
R138 GND.t9 GND.n13 49.948
R139 GND.n19 GND.t13 49.9279
R140 GND.t6 GND.n5 45.2977
R141 GND.t12 GND.n1 45.2977
R142 GND.t15 GND.n2 45.2968
R143 GND.n19 GND.t4 45.2777
R144 GND.t5 GND.n12 37.2098
R145 GND.t11 GND.n12 27.9075
R146 GND.n20 GND.t8 17.5471
R147 GND.n0 GND.t18 17.5471
R148 GND.n15 GND.t10 17.5471
R149 GND.n16 GND.t3 17.5471
R150 GND.n7 GND.t14 17.5471
R151 GND.n21 GND.t1 17.5471
R152 GND.n24 GND.n14 8.5005
R153 GND.n24 GND.n12 8.5005
R154 GND.n24 GND.n18 8.5005
R155 GND.n24 GND.n10 8.5005
R156 GND.n24 GND.n6 8.5005
R157 GND.n24 GND.n3 8.5005
R158 GND.n24 GND.n23 8.5005
R159 GND GND.n13 4.28303
R160 GND.n24 GND.n17 4.23547
R161 GND.n24 GND.n9 4.23547
R162 GND.n24 GND.n8 4.23547
R163 GND.n21 GND.n1 1.8072
R164 GND.n24 GND.n22 1.65246
R165 GND.n24 GND.n4 1.35925
R166 GND.n25 GND.n24 1.14739
R167 GND.n25 GND 0.2312
R168 GND GND.n25 0.199616
R169 GND.n7 GND.n4 0.186004
R170 GND GND.n4 0.17052
R171 GND.n22 GND.n20 0.155765
R172 GND.n22 GND 0.140776
R173 GND.n9 GND 0.0833861
R174 GND.n9 GND.n0 0.0623028
R175 GND.n8 GND 0.0485528
R176 GND.n17 GND 0.0485528
R177 GND GND.n8 0.0430528
R178 GND.n17 GND.n16 0.0366361
R179 GND.n16 GND.n15 0.0261667
R180 GND.n24 GND.n19 0.0210926
R181 GND GND.n21 0.0160833
R182 GND.n20 GND 0.0160833
R183 GND GND.n7 0.0160833
R184 GND GND.n0 0.0160833
R185 GND.n15 GND 0.0160833
R186 GND.n24 GND.n2 0.00197864
R187 GND.n24 GND.n1 0.00110185
R188 GND.n24 GND.n5 0.00104879
R189 GND.n24 GND.n11 0.00100243
R190 GND.n24 GND.n13 0.001
R191 NAND_3in_nmosx3_0.y.n3 NAND_3in_nmosx3_0.y.t0 27.0955
R192 NAND_3in_nmosx3_0.y.n3 NAND_3in_nmosx3_0.y.n4 0.1765
R193 NAND_3in_nmosx3_0.y.n4 NAND_3in_nmosx3_0.y.t2 26.8403
R194 NAND_3in_nmosx3_0.y.n4 NAND_3in_nmosx3_0.y.t1 26.8577
R195 NAND_3in_nmosx3_0.y NAND_3in_nmosx3_0.y.n3 3.3459
R196 NAND_3in_nmosx3_0.y NAND_3in_nmosx3_0.y.n1 1.5427
R197 NAND_3in_nmosx3_0.y NAND_3in_nmosx3_0.y.n1 0.0386333
R198 NAND_3in_nmosx3_0.y.n2 NAND_3in_nmosx3_0.y.t6 7.51402
R199 NAND_3in_nmosx3_0.y.n2 NAND_3in_nmosx3_0.y.t4 8.57008
R200 NAND_3in_nmosx3_0.y.n1 NAND_3in_nmosx3_0.y.n2 4.58528
R201 NAND_3in_nmosx3_0.y NAND_3in_nmosx3_0.y.n1 1.76783
R202 NAND_3in_nmosx3_0.y.t3 NAND_3in_nmosx3_0.y.n0 7.51402
R203 NAND_3in_nmosx3_0.y NAND_3in_nmosx3_0.y.n0 4.58528
R204 NAND_3in_nmosx3_0.y.n0 NAND_3in_nmosx3_0.y.t5 8.57008
R205 NAND_2in_nmosx2_0.a.n5 NAND_2in_nmosx2_0.a.t1 26.9107
R206 NAND_2in_nmosx2_0.a.n4 NAND_2in_nmosx2_0.a.n5 4.5005
R207 NAND_2in_nmosx2_0.a.n5 NAND_2in_nmosx2_0.a.t0 26.9853
R208 NAND_2in_nmosx2_0.a.n4 NAND_2in_nmosx2_0.a.n0 0.7001
R209 NAND_2in_nmosx2_0.a NAND_2in_nmosx2_0.a.n4 0.2799
R210 NAND_2in_nmosx2_0.a NAND_2in_nmosx2_0.a.n0 12.474
R211 NAND_2in_nmosx2_0.a NAND_2in_nmosx2_0.a.n3 4.5093
R212 NAND_2in_nmosx2_0.a.t2 NAND_2in_nmosx2_0.a.n3 8.00307
R213 NAND_2in_nmosx2_0.a.n3 NAND_2in_nmosx2_0.a.t3 8.01682
R214 NAND_2in_nmosx2_0.a.n0 NAND_2in_nmosx2_0.a.n2 10.5434
R215 NAND_2in_nmosx2_0.a.n2 NAND_2in_nmosx2_0.a 0.0533
R216 NAND_2in_nmosx2_0.a.n1 NAND_2in_nmosx2_0.a.t4 7.51402
R217 NAND_2in_nmosx2_0.a.n2 NAND_2in_nmosx2_0.a.n1 4.53248
R218 NAND_2in_nmosx2_0.a.n1 NAND_2in_nmosx2_0.a.t5 8.57008
R219 NAND_2in_nmosx2_0.y.t0 NAND_2in_nmosx2_0.y.n2 26.9107
R220 NAND_2in_nmosx2_0.y.n1 NAND_2in_nmosx2_0.y.n2 4.5005
R221 NAND_2in_nmosx2_0.y.n2 NAND_2in_nmosx2_0.y.t1 26.9853
R222 NAND_2in_nmosx2_0.y NAND_2in_nmosx2_0.y.n1 0.2799
R223 NAND_2in_nmosx2_0.y NAND_2in_nmosx2_0.y.n1 1.4745
R224 NAND_2in_nmosx2_0.y.t2 NAND_2in_nmosx2_0.y.n0 7.51402
R225 NAND_2in_nmosx2_0.y NAND_2in_nmosx2_0.y.n0 4.58528
R226 NAND_2in_nmosx2_0.y.n0 NAND_2in_nmosx2_0.y.t3 8.57008
R227 NAND_2in_nmosx2_0.b.t1 NAND_2in_nmosx2_0.b.n6 26.8051
R228 NAND_2in_nmosx2_0.b.n3 NAND_2in_nmosx2_0.b.n6 0.0753
R229 NAND_2in_nmosx2_0.b.n6 NAND_2in_nmosx2_0.b.t0 27.0909
R230 NAND_2in_nmosx2_0.b NAND_2in_nmosx2_0.b.n5 0.0797
R231 NAND_2in_nmosx2_0.b.n5 NAND_2in_nmosx2_0.b.n3 6.56153
R232 NAND_2in_nmosx2_0.b.n4 NAND_2in_nmosx2_0.b.t3 7.51402
R233 NAND_2in_nmosx2_0.b.n4 NAND_2in_nmosx2_0.b.t2 8.57008
R234 NAND_2in_nmosx2_0.b.n5 NAND_2in_nmosx2_0.b.n4 4.53248
R235 NAND_2in_nmosx2_0.b.n3 NAND_2in_nmosx2_0.b 2.7103
R236 NAND_2in_nmosx2_0.b NAND_2in_nmosx2_0.b.n1 0.9399
R237 NAND_2in_nmosx2_0.b NAND_2in_nmosx2_0.b.n1 0.0181
R238 NAND_2in_nmosx2_0.b.t7 NAND_2in_nmosx2_0.b.n2 7.51402
R239 NAND_2in_nmosx2_0.b.t5 NAND_2in_nmosx2_0.b.n2 8.57008
R240 NAND_2in_nmosx2_0.b.n1 NAND_2in_nmosx2_0.b.n2 4.60582
R241 NAND_2in_nmosx2_0.b NAND_2in_nmosx2_0.b.n1 1.95263
R242 NAND_2in_nmosx2_0.b.t4 NAND_2in_nmosx2_0.b.n0 7.51402
R243 NAND_2in_nmosx2_0.b NAND_2in_nmosx2_0.b.n0 4.58528
R244 NAND_2in_nmosx2_0.b.n0 NAND_2in_nmosx2_0.b.t6 8.57008
C0 VP q 0.41264f
C1 clk NAND_2in_nmosx2_0.y 0.32058f
C2 NAND_3in_nmosx3_0.y NAND_2in_nmosx2_0.y 0.02701f
C3 NAND_2in_nmosx2_0.a NAND_2in_nmosx2_0.y 0.29468f
C4 VP NAND_2in_nmosx2_0.b 0.77462f
C5 q_ NAND_2in_nmosx2_0.y 0.06942f
C6 NAND_2in_nmosx2_0.b d 0.03356f
C7 VP d 0.16309f
C8 q NAND_3in_nmosx3_0.y 0.33026f
C9 q NAND_2in_nmosx2_0.a 0.01099f
C10 q_ q 0.72714f
C11 clk NAND_2in_nmosx2_0.b 0.8935f
C12 clk VP 0.33796f
C13 NAND_3in_nmosx3_0.y NAND_2in_nmosx2_0.b 0.21816f
C14 NAND_2in_nmosx2_0.a NAND_2in_nmosx2_0.b 0.52073f
C15 q_ NAND_2in_nmosx2_0.b 0.47536f
C16 VP NAND_3in_nmosx3_0.y 0.74513f
C17 VP NAND_2in_nmosx2_0.a 0.90902f
C18 q_ VP 0.48116f
C19 NAND_3in_nmosx3_0.y d 0.35023f
C20 NAND_2in_nmosx2_0.a d 0.15649f
C21 clk NAND_3in_nmosx3_0.y 0.14397f
C22 clk NAND_2in_nmosx2_0.a 0.59705f
C23 NAND_2in_nmosx2_0.a NAND_3in_nmosx3_0.y 0.92961f
C24 q NAND_2in_nmosx2_0.y 0.03617f
C25 q_ NAND_3in_nmosx3_0.y 0.45789f
C26 q_ NAND_2in_nmosx2_0.a 0.20002f
C27 NAND_2in_nmosx2_0.y NAND_2in_nmosx2_0.b 0.78157f
C28 VP NAND_2in_nmosx2_0.y 0.38308f
C29 q NAND_2in_nmosx2_0.b 0.14164f
C30 d GND 0.37149f
C31 q GND 1.02543f
C32 q_ GND 0.9434f
C33 clk GND 2.09912f
C34 VP GND 0.83288f
C35 NAND_3in_nmosx3_0.y GND 1.51582f
C36 NAND_2in_nmosx2_0.a GND 1.65944f
C37 NAND_2in_nmosx2_0.y GND 0.84746f
C38 NAND_2in_nmosx2_0.b GND 2.00172f
C39 NAND_2in_nmosx2_0.b.t1 GND 0.09456f
C40 NAND_2in_nmosx2_0.b.t4 GND 0.10775f
C41 NAND_2in_nmosx2_0.b.n0 GND 0.17017f
C42 NAND_2in_nmosx2_0.b.t6 GND 0.1192f
C43 NAND_2in_nmosx2_0.b.n1 GND 0.39582f
C44 NAND_2in_nmosx2_0.b.t7 GND 0.10926f
C45 NAND_2in_nmosx2_0.b.n2 GND 0.17049f
C46 NAND_2in_nmosx2_0.b.t5 GND 0.11768f
C47 NAND_2in_nmosx2_0.b.n3 GND 0.64028f
C48 NAND_2in_nmosx2_0.b.t3 GND 0.10775f
C49 NAND_2in_nmosx2_0.b.n4 GND 0.16952f
C50 NAND_2in_nmosx2_0.b.t2 GND 0.1192f
C51 NAND_2in_nmosx2_0.b.n5 GND 0.293f
C52 NAND_2in_nmosx2_0.b.t0 GND 0.09385f
C53 NAND_2in_nmosx2_0.b.n6 GND 0.65676f
C54 NAND_2in_nmosx2_0.y.t0 GND 0.1124f
C55 NAND_2in_nmosx2_0.y.t2 GND 0.12641f
C56 NAND_2in_nmosx2_0.y.n0 GND 0.19965f
C57 NAND_2in_nmosx2_0.y.t3 GND 0.13984f
C58 NAND_2in_nmosx2_0.y.n1 GND 0.21207f
C59 NAND_2in_nmosx2_0.y.n2 GND 0.77313f
C60 NAND_2in_nmosx2_0.y.t1 GND 0.10854f
C61 NAND_2in_nmosx2_0.a.t1 GND 0.09719f
C62 NAND_2in_nmosx2_0.a.n0 GND 1.1051f
C63 NAND_2in_nmosx2_0.a.t4 GND 0.10931f
C64 NAND_2in_nmosx2_0.a.n1 GND 0.17197f
C65 NAND_2in_nmosx2_0.a.t5 GND 0.12092f
C66 NAND_2in_nmosx2_0.a.n2 GND 0.36739f
C67 NAND_2in_nmosx2_0.a.t3 GND 0.11329f
C68 NAND_2in_nmosx2_0.a.t2 GND 0.11418f
C69 NAND_2in_nmosx2_0.a.n3 GND 0.17561f
C70 NAND_2in_nmosx2_0.a.n4 GND 0.09625f
C71 NAND_2in_nmosx2_0.a.n5 GND 0.66852f
C72 NAND_2in_nmosx2_0.a.t0 GND 0.09385f
C73 a_294_388.t0 GND 0.09318f
C74 a_906_388.t0 GND 0.09852f
C75 a_1586_388.t0 GND 0.09461f
C76 NAND_3in_nmosx3_0.y.t0 GND 0.10643f
C77 NAND_3in_nmosx3_0.y.t3 GND 0.1185f
C78 NAND_3in_nmosx3_0.y.n0 GND 0.18455f
C79 NAND_3in_nmosx3_0.y.t5 GND 0.12762f
C80 NAND_3in_nmosx3_0.y.n1 GND 0.44492f
C81 NAND_3in_nmosx3_0.y.t6 GND 0.11685f
C82 NAND_3in_nmosx3_0.y.n2 GND 0.18455f
C83 NAND_3in_nmosx3_0.y.t4 GND 0.12926f
C84 NAND_3in_nmosx3_0.y.n3 GND 0.4164f
C85 NAND_3in_nmosx3_0.y.t1 GND 0.09868f
C86 NAND_3in_nmosx3_0.y.n4 GND 0.68485f
C87 NAND_3in_nmosx3_0.y.t2 GND 0.09814f
C88 a_322_n50.t0 GND 0.10389f
C89 a_424_n50.t0 GND 0.17675f
C90 a_1178_n50.t0 GND 0.09373f
C91 a_1926_n50.t0 GND 0.09612f
C92 VP.n1 GND 0.05853f
C93 VP.n2 GND 0.06405f
C94 VP.n3 GND 0.04057f
C95 VP.n15 GND 0.04057f
C96 VP.n16 GND 0.0189f
C97 VP.n17 GND 0.02039f
C98 VP.n18 GND 0.02039f
C99 VP.n19 GND 0.0205f
C100 VP.n20 GND 0.04057f
C101 VP.n21 GND 0.02596f
C102 VP.n22 GND 0.04057f
C103 VP.n23 GND 0.03121f
C104 VP.n24 GND 0.04057f
C105 VP.n25 GND 0.02596f
C106 VP.n26 GND 0.01901f
C107 VP.n27 GND 0.04057f
C108 VP.n29 GND 0.02456f
C109 VP.n30 GND 0.04057f
C110 VP.n31 GND 0.01743f
C111 VP.n32 GND 0.01867f
C112 VP.n33 GND 0.04057f
C113 VP.n34 GND 0.01523f
C114 VP.n35 GND 0.04057f
C115 VP.n36 GND 0.02596f
C116 VP.n37 GND 0.04057f
C117 VP.n38 GND 0.03121f
C118 VP.n39 GND 0.04057f
C119 VP.n40 GND 0.02596f
C120 VP.n41 GND 0.01454f
C121 VP.n42 GND 0.04057f
C122 VP.n43 GND 0.01798f
C123 VP.n44 GND 0.01824f
C124 VP.n45 GND 0.04722f
C125 VP.n46 GND 0.04371f
C126 VP.t0 GND 2.98377f
C127 VP.n48 GND 0.04057f
C128 VP.n49 GND 0.01466f
C129 clk.t3 GND 0.1075f
C130 clk.t2 GND 0.11579f
C131 clk.n0 GND 0.16774f
C132 clk.n1 GND 0.23228f
C133 clk.t1 GND 0.11579f
C134 clk.t0 GND 0.1075f
C135 clk.n2 GND 0.1673f
C136 q_.t1 GND 0.08985f
C137 q_.t0 GND 0.09305f
C138 q_.n0 GND 0.63999f
C139 q_.n1 GND 0.67968f
C140 q_.t3 GND 0.10611f
C141 q_.t2 GND 0.11429f
C142 q_.n2 GND 0.16463f
C143 q_.n3 GND 0.54493f
C144 q.t3 GND 0.09091f
C145 q.t2 GND 0.10057f
C146 q.n0 GND 0.14303f
C147 q.n1 GND 0.25982f
C148 q.n2 GND 0.28776f
C149 q.t1 GND 0.07806f
C150 q.t0 GND 0.08083f
C151 q.n3 GND 0.55881f
C152 d.t1 GND 0.16137f
C153 d.t0 GND 0.14983f
C154 d.n0 GND 0.23334f
.ends
