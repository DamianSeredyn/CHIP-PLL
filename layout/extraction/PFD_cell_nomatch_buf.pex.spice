* PEX produced on Sun May 24 06:08:46 PM CEST 2026 using /foss/tools/sak/sak-pex.sh with m=3 and s=1
* NGSPICE file created from PFD_cell_nomatch_buf.ext - technology: ihp-sg13g2

.subckt PFD_cell_nomatch_buf vp cVco pre_down UP cRef pre_up DOWN gnd
X0 3.t1 cVco vp.t3 vp.t0 sg13_lv_pmos ad=0.153p pd=1.58u as=0.153p ps=1.58u w=0.45u l=0.15u
X1 1.t0 DOWN 2.t0 gnd.t1 sg13_lv_nmos ad=0.204p pd=1.88u as=0.114p ps=0.98u w=0.6u l=0.15u
X2 inv_out_down.t0 cRef vp.t8 vp.t0 sg13_lv_pmos ad=0.204p pd=1.88u as=0.204p ps=1.88u w=0.6u l=0.15u
X3 inv_out_up.t0 cVco vp.t2 vp.t0 sg13_lv_pmos ad=0.204p pd=1.88u as=0.204p ps=1.88u w=0.6u l=0.15u
X4 pre_down inv_out_up.t2 gnd.t3 gnd.t2 sg13_lv_nmos ad=0.204p pd=1.88u as=0.204p ps=1.88u w=0.6u l=0.15u
X5 2.t1 cRef gnd.t23 gnd.t9 sg13_lv_nmos ad=0.102p pd=1.28u as=0.102p ps=1.28u w=0.3u l=0.15u
X6 1.t2 cRef vp.t7 vp.t0 sg13_lv_pmos ad=0.153p pd=1.58u as=0.153p ps=1.58u w=0.45u l=0.15u
X7 2.t0 cVco.t0 1.t1 gnd.t9 sg13_lv_nmos ad=0.114p pd=0.98u as=0.204p ps=1.88u w=0.6u l=0.15u
X8 pre_up inv_out_down.t2 gnd.t17 gnd.t16 sg13_lv_nmos ad=0.204p pd=1.88u as=0.204p ps=1.88u w=0.6u l=0.15u
X9 buf_in_up pre_up vp.t5 vp.t0 sg13_lv_pmos ad=0.204p pd=1.88u as=0.204p ps=1.88u w=0.6u l=0.15u
X10 DOWN.t0 buf_in_down vp.t4 vp.t0 sg13_lv_pmos ad=0.408p pd=3.08u as=0.408p ps=3.08u w=1.2u l=0.15u
X11 4.t0 cRef 3.t3 gnd.t10 sg13_lv_nmos ad=0.114p pd=0.98u as=0.204p ps=1.88u w=0.6u l=0.15u
X12 UP.t1 buf_in_up gnd.t5 gnd.t4 sg13_lv_nmos ad=0.408p pd=3.08u as=0.408p ps=3.08u w=1.2u l=0.15u
X13 inv_out_up.t1 cVco gnd.t7 gnd.t6 sg13_lv_nmos ad=0.204p pd=1.88u as=0.204p ps=1.88u w=0.6u l=0.15u
X14 pre_up cRef 1.t3 gnd.t22 sg13_lv_nmos ad=0.153p pd=1.58u as=0.153p ps=1.58u w=0.45u l=0.15u
X15 DOWN.t1 buf_in_down gnd.t13 gnd.t12 sg13_lv_nmos ad=0.408p pd=3.08u as=0.408p ps=3.08u w=1.2u l=0.15u
X16 UP.t0 buf_in_up vp.t1 vp.t0 sg13_lv_pmos ad=0.408p pd=3.08u as=0.408p ps=3.08u w=1.2u l=0.15u
X17 4.t1 cVco gnd.t11 gnd.t10 sg13_lv_nmos ad=0.102p pd=1.28u as=0.102p ps=1.28u w=0.3u l=0.15u
X18 inv_out_down.t1 cRef.t0 gnd.t21 gnd.t20 sg13_lv_nmos ad=0.204p pd=1.88u as=0.204p ps=1.88u w=0.6u l=0.15u
X19 buf_in_down pre_down gnd.t19 gnd.t18 sg13_lv_nmos ad=0.204p pd=1.88u as=0.204p ps=1.88u w=0.6u l=0.15u
X20 buf_in_down pre_down vp.t6 vp.t0 sg13_lv_pmos ad=0.204p pd=1.88u as=0.204p ps=1.88u w=0.6u l=0.15u
X21 pre_down cVco 3.t2 gnd.t8 sg13_lv_nmos ad=0.153p pd=1.58u as=0.153p ps=1.58u w=0.45u l=0.15u
X22 3.t0 UP 4.t0 gnd.t0 sg13_lv_nmos ad=0.204p pd=1.88u as=0.114p ps=0.98u w=0.6u l=0.15u
X23 buf_in_up pre_up gnd.t15 gnd.t14 sg13_lv_nmos ad=0.204p pd=1.88u as=0.204p ps=1.88u w=0.6u l=0.15u
R0 cRef cRef.t0 12.2077
R1 cVco cVco.t0 12.5404
R2 DOWN.n0 DOWN.t1 16.0566
R3 DOWN.n0 DOWN.t0 15.8445
R4 DOWN DOWN.n0 4.6963
R5 UP.n0 UP.t1 16.0566
R6 UP.n0 UP.t0 15.8445
R7 UP UP.n0 4.6963
R8 vp.n6 vp.t3 36.2293
R9 vp.n11 vp.t7 36.2274
R10 vp.n7 vp.t2 36.2167
R11 vp vp.t5 36.1179
R12 vp vp.t6 36.1177
R13 vp.n9 vp.t8 36.0871
R14 vp.n0 vp.t4 24.8611
R15 vp vp.t1 24.8609
R16 vp.n13 vp.n9 5.69492
R17 vp.t0 vp.n2 4.251
R18 vp.n3 vp.n1 4.23547
R19 vp.n18 vp.n17 4.23547
R20 vp.n5 vp.n4 3.38116
R21 vp.t0 vp.n5 2.42957
R22 vp.n12 vp.n10 1.65246
R23 vp.n8 vp.n7 1.25216
R24 vp.n15 vp.n14 1.24541
R25 vp.n15 vp 1.14558
R26 vp.n16 vp 1.13087
R27 vp.n8 vp.n6 0.898215
R28 vp.n12 vp.n11 0.897744
R29 vp.n16 vp.t0 0.852098
R30 vp.t0 vp.n8 0.549887
R31 vp.t0 vp.n13 0.549203
R32 vp.t0 vp.n15 0.548887
R33 vp.n11 vp 0.246144
R34 vp vp.n6 0.24431
R35 vp.n14 vp 0.185572
R36 vp vp.n14 0.1845
R37 vp.n7 vp 0.181851
R38 vp.n10 vp.n9 0.172265
R39 vp vp.n10 0.142609
R40 vp.n4 vp.n1 0.141392
R41 vp.n18 vp.n1 0.125939
R42 vp.n4 vp 0.0595954
R43 vp vp.n18 0.0494695
R44 vp vp.n0 0.0115
R45 vp.n17 vp.n16 0.00405508
R46 vp vp.n0 0.00233333
R47 vp.n13 vp.n12 0.00124178
R48 vp.n17 vp.n2 0.001
R49 vp.n5 vp.n3 0.001
R50 vp.n3 vp.n2 0.001
R51 gnd.n28 gnd.t22 1145.28
R52 gnd.n22 gnd.t8 858.278
R53 gnd.n7 gnd.n6 700.782
R54 gnd.t22 gnd.n27 354.531
R55 gnd.t8 gnd.n21 354.531
R56 gnd.n27 gnd.t1 111.424
R57 gnd.n21 gnd.t0 111.424
R58 gnd.n22 gnd.t20 91.8166
R59 gnd.t12 gnd.n1 78.8595
R60 gnd.t4 gnd.n7 78.8586
R61 gnd.n2 gnd.t18 75.482
R62 gnd.t14 gnd.n8 75.4811
R63 gnd.n16 gnd.t2 75.481
R64 gnd.n12 gnd.t16 75.4809
R65 gnd.t9 gnd.n9 68.1812
R66 gnd.t10 gnd.n13 68.1812
R67 gnd.n11 gnd.t9 61.9751
R68 gnd.n15 gnd.t10 61.9751
R69 gnd.t16 gnd.n11 55.2232
R70 gnd.t2 gnd.n15 55.2232
R71 gnd.n6 gnd.t18 54.6754
R72 gnd.n28 gnd.t14 54.6754
R73 gnd.n8 gnd.t4 51.8457
R74 gnd.n2 gnd.t12 51.8457
R75 gnd.t20 gnd.n12 38.3397
R76 gnd.n18 gnd.t7 37.1008
R77 gnd.n24 gnd.t21 37.0778
R78 gnd.n17 gnd.t3 36.9275
R79 gnd.n23 gnd.t17 36.9275
R80 gnd gnd.t15 36.1047
R81 gnd gnd.t19 36.1009
R82 gnd.n19 gnd.t11 35.9961
R83 gnd.n25 gnd.t23 35.9961
R84 gnd.n16 gnd.t6 27.6642
R85 gnd gnd.t13 24.8479
R86 gnd gnd.t5 24.8441
R87 gnd.n9 gnd.t1 10.7811
R88 gnd.n13 gnd.t0 10.7811
R89 gnd.n27 gnd.n26 8.5005
R90 gnd.n21 gnd.n20 8.5005
R91 gnd.n5 gnd.n4 4.23547
R92 gnd.n26 gnd.n10 2.80696
R93 gnd.n20 gnd.n14 2.80696
R94 gnd.n20 gnd.n18 1.6527
R95 gnd.n26 gnd.n24 1.36861
R96 gnd gnd.n1 1.33449
R97 gnd.n26 gnd.n25 1.20866
R98 gnd.n20 gnd.n19 1.20866
R99 gnd.n30 gnd.n29 1.15269
R100 gnd.n5 gnd.n3 1.1525
R101 gnd.n29 gnd.n0 0.998832
R102 gnd.n26 gnd.n22 0.549427
R103 gnd.n6 gnd.n5 0.549427
R104 gnd.n29 gnd.n28 0.549427
R105 gnd.n26 gnd.n9 0.549178
R106 gnd.n20 gnd.n13 0.549178
R107 gnd gnd.n3 0.216129
R108 gnd gnd.n30 0.21539
R109 gnd.n24 gnd.n23 0.195606
R110 gnd.n18 gnd.n17 0.174226
R111 gnd.n30 gnd 0.152791
R112 gnd.n3 gnd 0.151995
R113 gnd gnd.n0 0.125498
R114 gnd.n19 gnd 0.123957
R115 gnd.n25 gnd 0.123957
R116 gnd gnd.n14 0.123706
R117 gnd gnd.n10 0.123706
R118 gnd.n4 gnd 0.0916361
R119 gnd.n17 gnd.n14 0.0754625
R120 gnd.n23 gnd.n10 0.0754625
R121 gnd.n4 gnd 0.0568028
R122 gnd.n0 gnd 0.0224732
R123 gnd.n26 gnd.n12 0.00115126
R124 gnd.n20 gnd.n16 0.00110654
R125 gnd.n5 gnd.n1 0.00106742
R126 gnd.n26 gnd.n11 0.00101177
R127 gnd.n20 gnd.n15 0.00101177
R128 gnd.n5 gnd.n2 0.00101177
R129 gnd.n29 gnd.n8 0.00100993
R130 gnd.n29 gnd.n7 0.00100018
R131 2.t1 2.n0 21.6053
R132 2 2.n0 0.2821
R133 2.n0 2.t0 31.5431
R134 4.t1 4.n0 21.6053
R135 4 4.n0 0.2821
R136 4.n0 4.t0 31.5431
R137 1.n2 1.t2 27.7292
R138 1.n0 1.n2 0.1369
R139 1.n0 1.n1 0.0929
R140 1.n1 1.t3 27.0912
R141 1.n1 1.t0 26.7395
R142 1.n2 1.t1 26.9727
R143 1 1.n0 1.6685
R144 inv_out_down.n0 inv_out_down.t0 37.4071
R145 inv_out_down.n0 inv_out_down.t1 17.0267
R146 inv_out_down inv_out_down.n0 0.93108
R147 inv_out_down inv_out_down.t2 8.11825
R148 3.n2 3.t1 27.7292
R149 3.n0 3.n2 0.1369
R150 3.n0 3.n1 0.0929
R151 3.n1 3.t2 27.0912
R152 3.n1 3.t0 26.7395
R153 3.n2 3.t3 26.9727
R154 3 3.n0 1.6685
R155 inv_out_up.t0 inv_out_up.n0 37.4071
R156 inv_out_up.n0 inv_out_up.t1 17.0267
R157 inv_out_up.n0 inv_out_up.t2 9.04883
C0 4 cRef 0.02531f
C1 buf_in_down pre_down 0.08735f
C2 cVco cRef 0.13838f
C3 cVco pre_up 0.01216f
C4 pre_down 3 0.91116f
C5 inv_out_down cRef 0.07138f
C6 vp UP 0.68096f
C7 pre_up inv_out_down 0.07577f
C8 4 3 0.73514f
C9 cVco 3 0.03064f
C10 inv_out_down 3 0.0219f
C11 pre_down vp 0.47073f
C12 cVco 2 0.02533f
C13 1 cVco 0.08119f
C14 1 inv_out_down 0.03313f
C15 cVco vp 0.76164f
C16 4 UP 0.01512f
C17 vp inv_out_down 0.51127f
C18 DOWN cRef 0.06255f
C19 cVco UP 0.06277f
C20 buf_in_down DOWN 0.13964f
C21 pre_up cRef 0.0502f
C22 cVco pre_down 0.03392f
C23 buf_in_up pre_up 0.10951f
C24 pre_down inv_out_down 0.02808f
C25 2 DOWN 0.01512f
C26 cVco 4 0.09699f
C27 1 DOWN 0.08089f
C28 cRef 3 0.08137f
C29 DOWN vp 0.65115f
C30 2 cRef 0.09699f
C31 1 cRef 0.03064f
C32 1 pre_up 0.91129f
C33 1 buf_in_up 0.01849f
C34 vp cRef 0.78503f
C35 pre_up vp 0.47303f
C36 buf_in_up vp 1.04368f
C37 cRef UP 0.13978f
C38 buf_in_down vp 1.04248f
C39 buf_in_up UP 0.13966f
C40 vp 3 0.52956f
C41 buf_in_down UP 0.03922f
C42 cVco DOWN 0.13971f
C43 UP 3 0.08089f
C44 1 2 0.73514f
C45 pre_down cRef 0.01231f
C46 buf_in_up pre_down 0.02231f
C47 1 vp 0.5315f
C48 cRef gnd 2.67713f
C49 cVco gnd 2.64405f
C50 pre_up gnd 1.27268f
C51 pre_down gnd 1.26798f
C52 DOWN gnd 1.05738f
C53 UP gnd 0.94945f
C54 vp gnd 0.48235f
C55 2 gnd 0.59012f
C56 4 gnd 0.59186f
C57 buf_in_down gnd 1.13755f
C58 buf_in_up gnd 1.10843f
C59 1 gnd 0.64369f
C60 inv_out_down gnd 1.03944f
C61 3 gnd 0.64113f
C62 inv_out_up.t0 gnd 0.16008f
C63 inv_out_up.t1 gnd 0.04319f
C64 inv_out_up.t2 gnd 0.07111f
C65 inv_out_up.n0 gnd 0.41019f
C66 3.t1 gnd 0.13438f
C67 3.n0 gnd 0.03822f
C68 3.t3 gnd 0.14678f
C69 3.t0 gnd 0.14359f
C70 3.n1 gnd 0.70933f
C71 3.t2 gnd 0.12433f
C72 3.n2 gnd 0.90308f
C73 inv_out_down.t0 gnd 0.17426f
C74 inv_out_down.t1 gnd 0.04702f
C75 inv_out_down.t2 gnd 0.06806f
C76 inv_out_down.n0 gnd 0.36497f
C77 1.t2 gnd 0.1343f
C78 1.n0 gnd 0.0382f
C79 1.t1 gnd 0.14669f
C80 1.t0 gnd 0.1435f
C81 1.n1 gnd 0.70889f
C82 1.t3 gnd 0.12426f
C83 1.n2 gnd 0.90252f
C84 4.t1 gnd 0.06679f
C85 4.n0 gnd 0.50795f
C86 4.t0 gnd 0.23754f
C87 2.t1 gnd 0.06692f
C88 2.n0 gnd 0.50895f
C89 2.t0 gnd 0.23801f
C90 vp.t4 gnd 0.03621f
C91 vp.n0 gnd 0.02408f
C92 vp.n1 gnd 0.0149f
C93 vp.n3 gnd 0.01794f
C94 vp.t6 gnd 0.01455f
C95 vp.n5 gnd 0.02822f
C96 vp.t3 gnd 0.0176f
C97 vp.n6 gnd 0.07078f
C98 vp.t2 gnd 0.01934f
C99 vp.n7 gnd 0.05787f
C100 vp.n8 gnd 0.14701f
C101 vp.t8 gnd 0.01916f
C102 vp.n9 gnd 0.04858f
C103 vp.n10 gnd 0.01192f
C104 vp.t7 gnd 0.0176f
C105 vp.n11 gnd 0.07085f
C106 vp.n12 gnd 0.13646f
C107 vp.n13 gnd 0.01032f
C108 vp.t5 gnd 0.02088f
C109 vp.n14 gnd 0.01285f
C110 vp.t1 gnd 0.02701f
C111 vp.n15 gnd 0.15639f
C112 vp.t0 gnd 6.6044f
C113 vp.n16 gnd 0.06271f
C114 vp.n17 gnd 0.04665f
C115 UP.t0 gnd 0.23695f
C116 UP.t1 gnd 0.25861f
C117 UP.n0 gnd 0.6018f
C118 DOWN.t0 gnd 0.22948f
C119 DOWN.t1 gnd 0.21968f
C120 DOWN.n0 gnd 0.59434f
C121 cVco.t0 gnd 0.63849f
C122 cRef.t0 gnd 0.60495f
.ends
