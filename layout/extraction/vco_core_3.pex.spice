* PEX produced on Thu Oct  8 06:40:25 PM CEST 2026 using /foss/tools/sak/sak-pex.sh with m=2 and s=1
* NGSPICE file created from vco_core_3.ext - technology: ihp-sg13g2

.subckt vco_core_3 in out gd vp en11 nen11 en5 nen5
X0 vp vco_delay_cell_3_5.pgt a_n1549_748# vp sg13_lv_pmos ad=0.408p pd=3.08u as=0.408p ps=3.08u w=1.2u l=17u
X1 vco_delay_cell_3_8.out vco_delay_cell_3_9.out a_5931_748# vp sg13_lv_pmos ad=0.408p pd=3.08u as=0.408p ps=3.08u w=1.2u l=8.5u
X2 vco_delay_cell_3_9.out vco_delay_cell_3_10.out a_2191_n714# gd sg13_lv_nmos ad=0.272p pd=2.28u as=0.272p ps=2.28u w=0.8u l=8.5u
X3 gd in a_14227_n714# gd sg13_lv_nmos ad=0.272p pd=2.28u as=0.272p ps=2.28u w=0.8u l=17u
X4 vco_delay_cell_3_6.out vco_delay_cell_3_5.out a_n1549_n1506# gd sg13_lv_nmos ad=0.272p pd=2.28u as=0.272p ps=2.28u w=0.8u l=8.5u
X5 vco_delay_cell_3_6.out vco_delay_cell_3_5.out a_n1549_n3048# vp sg13_lv_pmos ad=0.408p pd=3.08u as=0.408p ps=3.08u w=1.2u l=8.5u
X6 vp vco_delay_cell_3_5.pgt a_9671_748# vp sg13_lv_pmos ad=0.408p pd=3.08u as=0.408p ps=3.08u w=1.2u l=17u
X7 vp vco_delay_cell_3_5.pgt vco_delay_cell_3_5.pgt vp sg13_lv_pmos ad=0.408p pd=3.08u as=0.408p ps=3.08u w=1.2u l=17u
X8 vp vco_delay_cell_3_5.pgt a_14227_748# vp sg13_lv_pmos ad=0.408p pd=3.08u as=0.408p ps=3.08u w=1.2u l=17u
X9 vco_delay_cell_3_7.out vco_delay_cell_3_8.out a_9671_748# vp sg13_lv_pmos ad=0.408p pd=3.08u as=0.408p ps=3.08u w=1.2u l=8.5u
X10 out vco_delay_cell_3_0.in a_14227_748# vp sg13_lv_pmos ad=0.408p pd=3.08u as=0.408p ps=3.08u w=1.2u l=8.5u
X11 vp vco_delay_cell_3_5.pgt a_9671_n3048# vp sg13_lv_pmos ad=0.408p pd=3.08u as=0.408p ps=3.08u w=1.2u l=17u
X12 gd in a_9671_n714# gd sg13_lv_nmos ad=0.272p pd=2.28u as=0.272p ps=2.28u w=0.8u l=17u
X13 gd in a_9671_n1506# gd sg13_lv_nmos ad=0.272p pd=2.28u as=0.272p ps=2.28u w=0.8u l=17u
X14 gd in a_5931_n714# gd sg13_lv_nmos ad=0.272p pd=2.28u as=0.272p ps=2.28u w=0.8u l=17u
X15 vco_delay_cell_3_4.out vco_delay_cell_3_6.out a_2191_n1506# gd sg13_lv_nmos ad=0.272p pd=2.28u as=0.272p ps=2.28u w=0.8u l=8.5u
X16 vp vco_delay_cell_3_5.pgt a_n1549_n3048# vp sg13_lv_pmos ad=0.408p pd=3.08u as=0.408p ps=3.08u w=1.2u l=17u
X17 vco_delay_cell_3_5.in nen11 vco_delay_cell_3_7.out vp sg13_lv_pmos ad=0.1005p pd=1.34u as=0.1005p ps=1.34u w=0.15u l=0.13u
X18 vco_delay_cell_3_4.out vco_delay_cell_3_6.out a_2191_n3048# vp sg13_lv_pmos ad=0.408p pd=3.08u as=0.408p ps=3.08u w=1.2u l=8.5u
X19 vp vco_delay_cell_3_5.pgt a_2191_n3048# vp sg13_lv_pmos ad=0.408p pd=3.08u as=0.408p ps=3.08u w=1.2u l=17u
X20 gd in a_n1549_n1506# gd sg13_lv_nmos ad=0.272p pd=2.28u as=0.272p ps=2.28u w=0.8u l=17u
X21 gd in vco_delay_cell_3_5.pgt gd sg13_lv_nmos ad=0.272p pd=2.28u as=0.272p ps=2.28u w=0.8u l=17u
X22 gd in a_2191_n1506# gd sg13_lv_nmos ad=0.272p pd=2.28u as=0.272p ps=2.28u w=0.8u l=17u
X23 vco_delay_cell_3_2.out vco_delay_cell_3_3.out a_9671_n1506# gd sg13_lv_nmos ad=0.272p pd=2.28u as=0.272p ps=2.28u w=0.8u l=8.5u
X24 vco_delay_cell_3_2.out vco_delay_cell_3_3.out a_9671_n3048# vp sg13_lv_pmos ad=0.408p pd=3.08u as=0.408p ps=3.08u w=1.2u l=8.5u
X25 gd in a_n1549_n714# gd sg13_lv_nmos ad=0.272p pd=2.28u as=0.272p ps=2.28u w=0.8u l=17u
X26 gd in a_2191_n714# gd sg13_lv_nmos ad=0.272p pd=2.28u as=0.272p ps=2.28u w=0.8u l=17u
X27 vco_delay_cell_3_7.out vco_delay_cell_3_8.out a_9671_n714# gd sg13_lv_nmos ad=0.272p pd=2.28u as=0.272p ps=2.28u w=0.8u l=8.5u
X28 out vco_delay_cell_3_0.in a_14227_n714# gd sg13_lv_nmos ad=0.272p pd=2.28u as=0.272p ps=2.28u w=0.8u l=8.5u
X29 vco_delay_cell_3_1.out vco_delay_cell_3_2.out a_13411_n1506# gd sg13_lv_nmos ad=0.272p pd=2.28u as=0.272p ps=2.28u w=0.8u l=8.5u
X30 vco_delay_cell_3_0.in nen5 vco_delay_cell_3_7.out vp sg13_lv_pmos ad=0.1005p pd=1.34u as=0.1005p ps=1.34u w=0.15u l=0.13u
X31 vco_delay_cell_3_1.out vco_delay_cell_3_2.out a_13411_n3048# vp sg13_lv_pmos ad=0.408p pd=3.08u as=0.408p ps=3.08u w=1.2u l=8.5u
X32 vp vco_delay_cell_3_5.pgt a_13411_n3048# vp sg13_lv_pmos ad=0.408p pd=3.08u as=0.408p ps=3.08u w=1.2u l=17u
X33 vco_delay_cell_3_3.out vco_delay_cell_3_4.out a_5931_n1506# gd sg13_lv_nmos ad=0.272p pd=2.28u as=0.272p ps=2.28u w=0.8u l=8.5u
X34 gd in a_13411_n1506# gd sg13_lv_nmos ad=0.272p pd=2.28u as=0.272p ps=2.28u w=0.8u l=17u
X35 vco_delay_cell_3_5.out vco_delay_cell_3_5.in a_n5289_n1506# gd sg13_lv_nmos ad=0.272p pd=2.28u as=0.272p ps=2.28u w=0.8u l=8.5u
X36 vco_delay_cell_3_3.out vco_delay_cell_3_4.out a_5931_n3048# vp sg13_lv_pmos ad=0.408p pd=3.08u as=0.408p ps=3.08u w=1.2u l=8.5u
X37 vp vco_delay_cell_3_5.pgt a_5931_n3048# vp sg13_lv_pmos ad=0.408p pd=3.08u as=0.408p ps=3.08u w=1.2u l=17u
X38 vco_delay_cell_3_5.in en11 vco_delay_cell_3_7.out gd sg13_lv_nmos ad=0.1005p pd=1.34u as=0.1005p ps=1.34u w=0.15u l=0.13u
X39 gd in a_5931_n1506# gd sg13_lv_nmos ad=0.272p pd=2.28u as=0.272p ps=2.28u w=0.8u l=17u
X40 vco_delay_cell_3_5.out vco_delay_cell_3_5.in a_n5289_n3048# vp sg13_lv_pmos ad=0.408p pd=3.08u as=0.408p ps=3.08u w=1.2u l=8.5u
X41 vco_delay_cell_3_0.in nen11 vco_delay_cell_3_1.out vp sg13_lv_pmos ad=0.1005p pd=1.34u as=0.1005p ps=1.34u w=0.15u l=0.13u
X42 vco_delay_cell_3_10.out out a_n1549_748# vp sg13_lv_pmos ad=0.408p pd=3.08u as=0.408p ps=3.08u w=1.2u l=8.5u
X43 vco_delay_cell_3_0.in en11 vco_delay_cell_3_1.out gd sg13_lv_nmos ad=0.1005p pd=1.34u as=0.1005p ps=1.34u w=0.15u l=0.13u
X44 vp vco_delay_cell_3_5.pgt a_2191_748# vp sg13_lv_pmos ad=0.408p pd=3.08u as=0.408p ps=3.08u w=1.2u l=17u
X45 vco_delay_cell_3_9.out vco_delay_cell_3_10.out a_2191_748# vp sg13_lv_pmos ad=0.408p pd=3.08u as=0.408p ps=3.08u w=1.2u l=8.5u
X46 vco_delay_cell_3_8.out vco_delay_cell_3_9.out a_5931_n714# gd sg13_lv_nmos ad=0.272p pd=2.28u as=0.272p ps=2.28u w=0.8u l=8.5u
X47 vp vco_delay_cell_3_5.pgt a_n5289_n3048# vp sg13_lv_pmos ad=0.408p pd=3.08u as=0.408p ps=3.08u w=1.2u l=17u
X48 vco_delay_cell_3_0.in en5 vco_delay_cell_3_7.out gd sg13_lv_nmos ad=0.1005p pd=1.34u as=0.1005p ps=1.34u w=0.15u l=0.13u
X49 gd in a_n5289_n1506# gd sg13_lv_nmos ad=0.272p pd=2.28u as=0.272p ps=2.28u w=0.8u l=17u
X50 vp vco_delay_cell_3_5.pgt a_5931_748# vp sg13_lv_pmos ad=0.408p pd=3.08u as=0.408p ps=3.08u w=1.2u l=17u
X51 vco_delay_cell_3_10.out out a_n1549_n714# gd sg13_lv_nmos ad=0.272p pd=2.28u as=0.272p ps=2.28u w=0.8u l=8.5u
C0 a_5931_n1506# vco_delay_cell_3_4.out 0.05103f
C1 vco_delay_cell_3_1.out vp 0.45317f
C2 in a_n1549_n714# 0.21677f
C3 vp in 0.51184f
C4 a_9671_n714# vco_delay_cell_3_5.in 0.10119f
C5 a_13411_n3048# vco_delay_cell_3_5.pgt 0.2524f
C6 vp vco_delay_cell_3_10.out 2.62889f
C7 in vco_delay_cell_3_0.in 0.67574f
C8 vp a_2191_748# 0.3912f
C9 in vco_delay_cell_3_8.out 0.1683f
C10 vp vco_delay_cell_3_0.in 0.18772f
C11 in vco_delay_cell_3_9.out 0.1683f
C12 a_9671_n3048# vco_delay_cell_3_3.out 0.06627f
C13 a_n1549_n714# vco_delay_cell_3_5.in 0.10119f
C14 vp vco_delay_cell_3_5.in 0.35946f
C15 vp nen5 0.15665f
C16 vp a_n5289_n3048# 0.36073f
C17 vco_delay_cell_3_9.out vco_delay_cell_3_10.out 0.16226f
C18 a_5931_n3048# vco_delay_cell_3_5.pgt 0.25509f
C19 vp a_2191_n714# 0.03722f
C20 vco_delay_cell_3_8.out vco_delay_cell_3_5.in 0.29541f
C21 in vco_delay_cell_3_3.out 0.36831f
C22 in a_n1549_n1506# 0.22644f
C23 vco_delay_cell_3_5.pgt a_14227_748# 0.25909f
C24 vp vco_delay_cell_3_3.out 2.64435f
C25 vco_delay_cell_3_9.out vco_delay_cell_3_5.in 0.29511f
C26 vp a_n1549_n1506# 0.03722f
C27 a_n5289_n3048# vco_delay_cell_3_5.in 0.05788f
C28 vco_delay_cell_3_6.out vco_delay_cell_3_4.out 0.16226f
C29 in a_13411_n1506# 0.22644f
C30 in vco_delay_cell_3_4.out 0.36831f
C31 vp a_13411_n1506# 0.03722f
C32 vco_delay_cell_3_6.out vco_delay_cell_3_5.out 0.16226f
C33 vp a_n1549_n3048# 0.3912f
C34 in a_14227_n714# 0.22466f
C35 vp vco_delay_cell_3_4.out 2.64435f
C36 vco_delay_cell_3_5.pgt a_5931_748# 0.24519f
C37 vp nen11 0.16449f
C38 in vco_delay_cell_3_5.out 0.36803f
C39 vp vco_delay_cell_3_5.out 2.64447f
C40 vco_delay_cell_3_1.out vco_delay_cell_3_5.pgt 0.04291f
C41 a_n1549_748# out 0.05985f
C42 vco_delay_cell_3_5.pgt a_n1549_n714# 0.0144f
C43 vp vco_delay_cell_3_5.pgt 37.9877f
C44 vco_delay_cell_3_7.out out 0.05145f
C45 vp a_14227_748# 0.3875f
C46 vco_delay_cell_3_2.out in 0.36831f
C47 vco_delay_cell_3_2.out vp 2.64417f
C48 vp a_9671_n714# 0.03722f
C49 vco_delay_cell_3_5.pgt vco_delay_cell_3_0.in 0.34165f
C50 in a_5931_n1506# 0.22644f
C51 vco_delay_cell_3_5.in vco_delay_cell_3_5.out 0.16469f
C52 vco_delay_cell_3_5.pgt vco_delay_cell_3_8.out 0.44717f
C53 a_9671_n1506# vco_delay_cell_3_3.out 0.05103f
C54 vp a_5931_n1506# 0.03722f
C55 a_14227_748# vco_delay_cell_3_0.in 0.06968f
C56 vco_delay_cell_3_5.pgt vco_delay_cell_3_9.out 0.60306f
C57 vp a_5931_748# 0.3912f
C58 a_13411_n3048# a_13411_n1506# 0.01315f
C59 vco_delay_cell_3_5.pgt a_n5289_n3048# 0.26508f
C60 in out 0.16635f
C61 vco_delay_cell_3_8.out a_9671_n714# 0.0465f
C62 vp a_n1549_n714# 0.03722f
C63 in a_n5289_n1506# 0.20685f
C64 vco_delay_cell_3_10.out out 0.34004f
C65 in a_5931_n714# 0.21677f
C66 vco_delay_cell_3_5.pgt a_9671_748# 0.24329f
C67 vp a_n5289_n1506# 0.03722f
C68 a_2191_748# out 0.05581f
C69 vco_delay_cell_3_5.pgt vco_delay_cell_3_3.out 0.60163f
C70 vco_delay_cell_3_1.out vco_delay_cell_3_0.in 0.18031f
C71 vco_delay_cell_3_5.pgt a_n1549_n1506# 0.02097f
C72 vco_delay_cell_3_9.out a_5931_748# 0.06579f
C73 in vco_delay_cell_3_7.out 0.0219f
C74 vp vco_delay_cell_3_0.in 2.56324f
C75 a_9671_748# a_9671_n714# 0.01315f
C76 vp vco_delay_cell_3_8.out 2.63595f
C77 vco_delay_cell_3_2.out a_13411_n3048# 0.06627f
C78 out vco_delay_cell_3_5.in 0.22855f
C79 a_5931_n3048# vco_delay_cell_3_4.out 0.06627f
C80 a_n1549_n3048# vco_delay_cell_3_5.pgt 0.27596f
C81 vp vco_delay_cell_3_9.out 2.63604f
C82 vco_delay_cell_3_5.pgt vco_delay_cell_3_4.out 0.75992f
C83 a_9671_n3048# vp 0.3912f
C84 vco_delay_cell_3_5.pgt a_14227_n714# 0.0164f
C85 a_n5289_n1506# vco_delay_cell_3_5.in 0.04506f
C86 a_2191_n3048# vco_delay_cell_3_6.out 0.06627f
C87 a_5931_n714# vco_delay_cell_3_5.in 0.10119f
C88 vco_delay_cell_3_5.pgt vco_delay_cell_3_5.out 0.47209f
C89 a_14227_748# a_14227_n714# 0.01315f
C90 in vco_delay_cell_3_6.out 0.3809f
C91 vp vco_delay_cell_3_6.out 2.64447f
C92 vco_delay_cell_3_9.out vco_delay_cell_3_8.out 0.16226f
C93 vp a_2191_n3048# 0.3912f
C94 vco_delay_cell_3_7.out vco_delay_cell_3_5.in 0.43816f
C95 vp a_9671_748# 0.3912f
C96 vp in 0.52552f
C97 a_5931_n3048# a_5931_n1506# 0.01315f
C98 vco_delay_cell_3_2.out vco_delay_cell_3_5.pgt 0.60126f
C99 in vco_delay_cell_3_10.out 0.17976f
C100 a_9671_748# vco_delay_cell_3_8.out 0.06579f
C101 vp a_14227_n714# 0.03722f
C102 in vco_delay_cell_3_5.in 3.12256f
C103 vco_delay_cell_3_10.out a_2191_748# 0.06579f
C104 vp vco_delay_cell_3_5.in 2.231f
C105 vp nen11 0.1673f
C106 vco_delay_cell_3_5.pgt out 4.56943f
C107 a_9671_n3048# a_9671_n1506# 0.01315f
C108 a_14227_748# out 0.05772f
C109 in a_2191_n714# 0.21677f
C110 a_14227_n714# vco_delay_cell_3_0.in 0.06933f
C111 vco_delay_cell_3_10.out vco_delay_cell_3_5.in 0.29511f
C112 vco_delay_cell_3_5.pgt a_n5289_n1506# 0.01435f
C113 vco_delay_cell_3_1.out vco_delay_cell_3_2.out 0.16311f
C114 vco_delay_cell_3_10.out a_2191_n714# 0.0465f
C115 vp a_13411_n3048# 0.3912f
C116 vco_delay_cell_3_5.pgt a_n1549_748# 0.27619f
C117 in a_9671_n1506# 0.22644f
C118 a_2191_748# a_2191_n714# 0.01315f
C119 vco_delay_cell_3_5.pgt vco_delay_cell_3_7.out 0.02199f
C120 vp a_9671_n1506# 0.03722f
C121 a_5931_748# out 0.05581f
C122 a_9671_n3048# vco_delay_cell_3_5.pgt 0.25301f
C123 a_2191_n714# vco_delay_cell_3_5.in 0.10119f
C124 a_n1549_n3048# a_n1549_n1506# 0.01315f
C125 vco_delay_cell_3_4.out vco_delay_cell_3_3.out 0.16226f
C126 a_n1549_n714# out 0.04128f
C127 a_5931_748# a_5931_n714# 0.01315f
C128 vp out 3.72657f
C129 vco_delay_cell_3_5.pgt vco_delay_cell_3_6.out 0.3698f
C130 a_n1549_n1506# vco_delay_cell_3_5.out 0.05103f
C131 vco_delay_cell_3_5.pgt a_2191_n3048# 0.24887f
C132 a_5931_n3048# vp 0.3912f
C133 in vco_delay_cell_3_5.pgt 2.15109f
C134 vco_delay_cell_3_0.in out 0.34455f
C135 vp a_5931_n714# 0.03722f
C136 a_2191_n1506# vco_delay_cell_3_6.out 0.05103f
C137 vp vco_delay_cell_3_5.pgt 37.9751f
C138 vco_delay_cell_3_8.out out 0.17398f
C139 a_2191_n1506# a_2191_n3048# 0.01315f
C140 a_n1549_748# a_n1549_n714# 0.01315f
C141 a_n1549_n3048# vco_delay_cell_3_5.out 0.06627f
C142 vp a_n1549_748# 0.3912f
C143 in a_2191_n1506# 0.22644f
C144 vco_delay_cell_3_9.out out 0.17398f
C145 vp vco_delay_cell_3_7.out 0.62905f
C146 in a_9671_n714# 0.21677f
C147 vco_delay_cell_3_5.pgt vco_delay_cell_3_10.out 0.22016f
C148 vco_delay_cell_3_2.out vco_delay_cell_3_3.out 0.16226f
C149 vp a_2191_n1506# 0.03722f
C150 en5 a_14227_n714# 0.01138f
C151 vco_delay_cell_3_5.pgt a_2191_748# 0.23914f
C152 vco_delay_cell_3_9.out a_5931_n714# 0.0465f
C153 vco_delay_cell_3_7.out vco_delay_cell_3_0.in 0.23969f
C154 vco_delay_cell_3_2.out a_13411_n1506# 0.05103f
C155 a_n5289_n3048# a_n5289_n1506# 0.01315f
C156 vco_delay_cell_3_5.pgt vco_delay_cell_3_5.in 0.59852f
C157 vco_delay_cell_3_7.out vco_delay_cell_3_8.out 0.16279f
C158 a_9671_748# out 0.05581f
C159 vco_delay_cell_3_1.out in 0.0516f
C160 vp gd 2.85785f
C161 vp gd 10.06244f
C162 a_13411_n3048# gd 0.04496f
C163 a_9671_n3048# gd 0.04496f
C164 a_5931_n3048# gd 0.04496f
C165 a_2191_n3048# gd 0.04496f
C166 a_n1549_n3048# gd 0.04496f
C167 a_n5289_n3048# gd 0.12788f
C168 vco_delay_cell_3_1.out gd 1.96116f
C169 vco_delay_cell_3_3.out gd 1.73199f
C170 vco_delay_cell_3_5.out gd 1.84429f
C171 a_13411_n1506# gd 1.80884f
C172 a_9671_n1506# gd 1.315f
C173 a_5931_n1506# gd 2.05729f
C174 a_2191_n1506# gd 1.80987f
C175 a_n1549_n1506# gd 1.31503f
C176 a_n5289_n1506# gd 2.13929f
C177 a_14227_n714# gd 31.53852f
C178 a_9671_n714# gd 0.3253f
C179 a_5931_n714# gd 1.2141f
C180 a_2191_n714# gd 1.29245f
C181 a_n1549_n714# gd 0.3253f
C182 vco_delay_cell_3_0.in gd 0.17633f
C183 vco_delay_cell_3_7.out gd 2.16747f
C184 vco_delay_cell_3_8.out gd 0.8888f
C185 a_14227_748# gd 1.38747f
C186 a_9671_748# gd 1.50683f
C187 a_5931_748# gd 1.01966f
C188 a_2191_748# gd 0.85542f
C189 a_n1549_748# gd 8.67934f
.ends
