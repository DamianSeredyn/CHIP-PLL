* PEX produced on Thu Sep  3 01:16:58 PM CEST 2026 using /foss/tools/sak/sak-pex.sh with m=2 and s=1
* NGSPICE file created from PFD_cell_2.ext - technology: ihp-sg13g2

.subckt PFD_cell_2 gnd vp cRef UP DOWN cVco rst
X0 PFD_flip_flop_0.1 PFD_flip_flop_0.clk_n vp gnd sg13_lv_nmos ad=0.102p pd=1.28u as=0.102p ps=1.28u w=0.3u l=0.15u
X1 gnd PFD_flip_flop_1.2 PFD_flip_flop_1.post_NOR gnd sg13_lv_nmos ad=57f pd=0.68u as=0.102p ps=1.28u w=0.3u l=0.15u
X2 inverter_x4_3.OUT pre_up vp vp sg13_lv_pmos ad=0.204p pd=1.88u as=0.204p ps=1.88u w=0.6u l=0.13u
X3 vp rst flip_flop_reset gnd sg13_lv_nmos ad=0.102p pd=1.28u as=0.102p ps=1.28u w=0.3u l=0.15u
X4 gnd a_2226_46# PFD_passgate_0.B gnd sg13_lv_nmos ad=76f pd=0.78u as=0.136p ps=1.48u w=0.4u l=0.5u
X5 PFD_flip_flop_0.1 PFD_flip_flop_0.clk_n PFD_flip_flop_0.post_NOR vp sg13_lv_pmos ad=0.102p pd=1.28u as=0.102p ps=1.28u w=0.3u l=0.15u
X6 PFD_flip_flop_1.3 cRef PFD_flip_flop_1.2 gnd sg13_lv_nmos ad=0.102p pd=1.28u as=0.102p ps=1.28u w=0.3u l=0.15u
X7 a_812_76# PFD_flip_flop_1.3 vp vp sg13_lv_pmos ad=57f pd=0.68u as=0.102p ps=1.28u w=0.3u l=0.15u
X8 UP inverter_x4_3.OUT vp vp sg13_lv_pmos ad=0.204p pd=1.88u as=0.204p ps=1.88u w=0.6u l=0.13u
X9 inverter_x4_5.OUT rst gnd gnd sg13_lv_nmos ad=0.204p pd=1.88u as=0.204p ps=1.88u w=0.6u l=0.13u
X10 PFD_flip_flop_1.NQ pre_down vp vp sg13_lv_pmos ad=0.408p pd=3.08u as=0.408p ps=3.08u w=1.2u l=0.13u
X11 a_n184_n846# PFD_flip_flop_0.2 vp vp sg13_lv_pmos ad=57f pd=0.68u as=0.102p ps=1.28u w=0.3u l=0.15u
X12 PFD_flip_flop_1.1 cRef vp vp sg13_lv_pmos ad=0.102p pd=1.28u as=0.102p ps=1.28u w=0.3u l=0.15u
X13 PFD_flip_flop_0.1 cVco vp vp sg13_lv_pmos ad=0.102p pd=1.28u as=0.102p ps=1.28u w=0.3u l=0.15u
X14 a_812_n846# PFD_flip_flop_0.3 vp vp sg13_lv_pmos ad=57f pd=0.68u as=0.102p ps=1.28u w=0.3u l=0.15u
X15 gnd PFD_flip_flop_0.3 gnd gnd sg13_lv_nmos ad=0.95p pd=5.38u as=58.18222p ps=0.27981m w=5u l=5u
X16 PFD_passgate_0.B inverter_x4_5.OUT flip_flop_reset gnd sg13_lv_nmos ad=0.102p pd=1.28u as=0.102p ps=1.28u w=0.3u l=0.15u
X17 PFD_flip_flop_1.clk_n cRef vp vp sg13_lv_pmos ad=0.204p pd=1.88u as=0.204p ps=1.88u w=0.6u l=0.13u
X18 PFD_flip_flop_1.2 PFD_flip_flop_1.1 vp vp sg13_lv_pmos ad=0.408p pd=3.08u as=0.408p ps=3.08u w=1.2u l=0.13u
X19 PFD_flip_flop_1.1 PFD_flip_flop_1.clk_n PFD_flip_flop_1.post_NOR vp sg13_lv_pmos ad=0.102p pd=1.28u as=0.102p ps=1.28u w=0.3u l=0.15u
X20 vp inverter_x4_5.OUT flip_flop_reset vp sg13_lv_pmos ad=0.102p pd=1.28u as=0.102p ps=1.28u w=0.3u l=0.15u
X21 gnd PFD_flip_flop_0.2 gnd gnd sg13_lv_nmos ad=0.95p pd=5.38u as=0 ps=0 w=5u l=5u
X22 pre_down flip_flop_reset gnd gnd sg13_lv_nmos ad=0.102p pd=1.28u as=57f ps=0.68u w=0.3u l=0.15u
X23 PFD_flip_flop_1.post_NOR flip_flop_reset gnd gnd sg13_lv_nmos ad=0.102p pd=1.28u as=57f ps=0.68u w=0.3u l=0.15u
X24 a_2226_46# PFD_buffor_0.in gnd gnd sg13_lv_nmos ad=0.136p pd=1.48u as=76f ps=0.78u w=0.4u l=0.5u
X25 vp pre_up post_nand vp sg13_lv_pmos ad=0.102p pd=1.28u as=57f ps=0.68u w=0.3u l=0.13u
X26 PFD_flip_flop_0.NQ pre_up gnd gnd sg13_lv_nmos ad=0.408p pd=3.08u as=0.408p ps=3.08u w=1.2u l=0.13u
X27 DOWN inverter_x4_0.OUT gnd gnd sg13_lv_nmos ad=0.204p pd=1.88u as=0.204p ps=1.88u w=0.6u l=0.13u
X28 gnd PFD_flip_flop_1.2 gnd gnd sg13_lv_nmos ad=0.95p pd=5.38u as=0 ps=0 w=5u l=5u
X29 gnd PFD_flip_flop_1.1 gnd gnd sg13_lv_nmos ad=1.7p pd=10.68u as=0 ps=0 w=5u l=5u
X30 PFD_flip_flop_1.NQ pre_down gnd gnd sg13_lv_nmos ad=0.408p pd=3.08u as=0.408p ps=3.08u w=1.2u l=0.13u
X31 pre_up flip_flop_reset a_812_n846# vp sg13_lv_pmos ad=0.102p pd=1.28u as=57f ps=0.68u w=0.3u l=0.15u
X32 PFD_flip_flop_0.3 cVco PFD_flip_flop_0.NQ vp sg13_lv_pmos ad=0.102p pd=1.28u as=0.102p ps=1.28u w=0.3u l=0.15u
X33 PFD_flip_flop_0.clk_n cVco gnd gnd sg13_lv_nmos ad=0.204p pd=1.88u as=0.204p ps=1.88u w=0.6u l=0.13u
X34 gnd PFD_flip_flop_0.2 PFD_flip_flop_0.post_NOR gnd sg13_lv_nmos ad=57f pd=0.68u as=0.102p ps=1.28u w=0.3u l=0.15u
X35 PFD_flip_flop_1.3 cRef PFD_flip_flop_1.NQ vp sg13_lv_pmos ad=0.102p pd=1.28u as=0.102p ps=1.28u w=0.3u l=0.15u
X36 inverter_x4_5.OUT rst vp vp sg13_lv_pmos ad=0.204p pd=1.88u as=0.204p ps=1.88u w=0.6u l=0.13u
X37 inverter_x4_0.OUT pre_down vp vp sg13_lv_pmos ad=0.204p pd=1.88u as=0.204p ps=1.88u w=0.6u l=0.13u
X38 PFD_flip_flop_1.2 PFD_flip_flop_1.1 gnd gnd sg13_lv_nmos ad=0.408p pd=3.08u as=0.408p ps=3.08u w=1.2u l=0.13u
X39 gnd PFD_flip_flop_1.3 pre_down gnd sg13_lv_nmos ad=57f pd=0.68u as=0.102p ps=1.28u w=0.3u l=0.15u
X40 gnd post_nand PFD_buffor_0.in gnd sg13_lv_nmos ad=0.204p pd=1.88u as=0.204p ps=1.88u w=0.6u l=0.13u
X41 PFD_flip_flop_1.3 PFD_flip_flop_1.clk_n PFD_flip_flop_1.2 vp sg13_lv_pmos ad=0.102p pd=1.28u as=0.102p ps=1.28u w=0.3u l=0.15u
X42 PFD_flip_flop_1.post_NOR flip_flop_reset a_n184_76# vp sg13_lv_pmos ad=0.102p pd=1.28u as=57f ps=0.68u w=0.3u l=0.15u
X43 vp a_2226_46# PFD_passgate_0.B vp sg13_lv_pmos ad=76f pd=0.78u as=0.136p ps=1.48u w=0.4u l=0.5u
X44 PFD_flip_flop_0.clk_n cVco vp vp sg13_lv_pmos ad=0.204p pd=1.88u as=0.204p ps=1.88u w=0.6u l=0.13u
X45 PFD_flip_flop_0.post_NOR flip_flop_reset gnd gnd sg13_lv_nmos ad=0.102p pd=1.28u as=57f ps=0.68u w=0.3u l=0.15u
X46 gnd PFD_flip_flop_0.3 pre_up gnd sg13_lv_nmos ad=57f pd=0.68u as=0.102p ps=1.28u w=0.3u l=0.15u
X47 UP inverter_x4_3.OUT gnd gnd sg13_lv_nmos ad=0.204p pd=1.88u as=0.204p ps=1.88u w=0.6u l=0.13u
X48 PFD_flip_flop_0.2 PFD_flip_flop_0.1 gnd gnd sg13_lv_nmos ad=0.408p pd=3.08u as=0.408p ps=3.08u w=1.2u l=0.13u
X49 PFD_flip_flop_1.clk_n cRef gnd gnd sg13_lv_nmos ad=0.204p pd=1.88u as=0.204p ps=1.88u w=0.6u l=0.13u
X50 a_n184_76# PFD_flip_flop_1.2 vp vp sg13_lv_pmos ad=57f pd=0.68u as=0.102p ps=1.28u w=0.3u l=0.15u
X51 pre_down flip_flop_reset a_812_76# vp sg13_lv_pmos ad=0.102p pd=1.28u as=57f ps=0.68u w=0.3u l=0.15u
X52 PFD_passgate_0.B rst flip_flop_reset vp sg13_lv_pmos ad=0.102p pd=1.28u as=0.102p ps=1.28u w=0.3u l=0.15u
X53 PFD_flip_flop_0.3 PFD_flip_flop_0.clk_n PFD_flip_flop_0.2 vp sg13_lv_pmos ad=0.102p pd=1.28u as=0.102p ps=1.28u w=0.3u l=0.15u
X54 gnd rst DOWN gnd sg13_lv_nmos ad=0.153p pd=1.58u as=0.153p ps=1.58u w=0.45u l=0.15u
X55 a_3426_854# pre_down post_nand gnd sg13_lv_nmos ad=0.114p pd=0.98u as=0.204p ps=1.88u w=0.6u l=0.13u
X56 PFD_flip_flop_0.post_NOR flip_flop_reset a_n184_n846# vp sg13_lv_pmos ad=0.102p pd=1.28u as=57f ps=0.68u w=0.3u l=0.15u
X57 pre_up flip_flop_reset gnd gnd sg13_lv_nmos ad=0.102p pd=1.28u as=57f ps=0.68u w=0.3u l=0.15u
X58 gnd PFD_flip_flop_1.3 gnd gnd sg13_lv_nmos ad=0.95p pd=5.38u as=0 ps=0 w=5u l=5u
X59 inverter_x4_3.OUT pre_up gnd gnd sg13_lv_nmos ad=0.204p pd=1.88u as=0.204p ps=1.88u w=0.6u l=0.13u
X60 PFD_flip_flop_1.1 PFD_flip_flop_1.clk_n vp gnd sg13_lv_nmos ad=0.102p pd=1.28u as=0.102p ps=1.28u w=0.3u l=0.15u
X61 gnd pre_up a_3426_854# gnd sg13_lv_nmos ad=0.204p pd=1.88u as=0.114p ps=0.98u w=0.6u l=0.13u
X62 inverter_x4_0.OUT pre_down gnd gnd sg13_lv_nmos ad=0.204p pd=1.88u as=0.204p ps=1.88u w=0.6u l=0.13u
X63 UP rst gnd gnd sg13_lv_nmos ad=0.153p pd=1.58u as=0.153p ps=1.58u w=0.45u l=0.15u
X64 PFD_flip_flop_1.1 cRef PFD_flip_flop_1.post_NOR gnd sg13_lv_nmos ad=0.102p pd=1.28u as=0.102p ps=1.28u w=0.3u l=0.15u
X65 vp post_nand PFD_buffor_0.in vp sg13_lv_pmos ad=0.204p pd=1.88u as=0.204p ps=1.88u w=0.6u l=0.13u
X66 post_nand pre_down vp vp sg13_lv_pmos ad=57f pd=0.68u as=0.102p ps=1.28u w=0.3u l=0.13u
X67 DOWN inverter_x4_0.OUT vp vp sg13_lv_pmos ad=0.204p pd=1.88u as=0.204p ps=1.88u w=0.6u l=0.13u
X68 a_2226_46# PFD_buffor_0.in vp vp sg13_lv_pmos ad=0.136p pd=1.48u as=76f ps=0.78u w=0.4u l=0.5u
X69 gnd PFD_flip_flop_0.1 gnd gnd sg13_lv_nmos ad=1.7p pd=10.68u as=0 ps=0 w=5u l=5u
X70 PFD_flip_flop_0.2 PFD_flip_flop_0.1 vp vp sg13_lv_pmos ad=0.408p pd=3.08u as=0.408p ps=3.08u w=1.2u l=0.13u
X71 PFD_flip_flop_0.NQ pre_up vp vp sg13_lv_pmos ad=0.408p pd=3.08u as=0.408p ps=3.08u w=1.2u l=0.13u
X72 PFD_flip_flop_0.3 cVco PFD_flip_flop_0.2 gnd sg13_lv_nmos ad=0.102p pd=1.28u as=0.102p ps=1.28u w=0.3u l=0.15u
X73 PFD_flip_flop_0.1 cVco PFD_flip_flop_0.post_NOR gnd sg13_lv_nmos ad=0.102p pd=1.28u as=0.102p ps=1.28u w=0.3u l=0.15u
X74 PFD_flip_flop_1.3 PFD_flip_flop_1.clk_n PFD_flip_flop_1.NQ gnd sg13_lv_nmos ad=0.102p pd=1.28u as=0.102p ps=1.28u w=0.3u l=0.15u
X75 PFD_flip_flop_0.3 PFD_flip_flop_0.clk_n PFD_flip_flop_0.NQ gnd sg13_lv_nmos ad=0.102p pd=1.28u as=0.102p ps=1.28u w=0.3u l=0.15u
C0 flip_flop_reset cVco 0.41666f
C1 post_nand pre_down 0.16546f
C2 pre_up pre_down 0.26215f
C3 inverter_x4_0.OUT pre_up 0.02369f
C4 a_n184_76# PFD_flip_flop_1.post_NOR 0.0257f
C5 PFD_flip_flop_1.3 pre_down 0.79861f
C6 PFD_flip_flop_0.post_NOR pre_up 0.01195f
C7 a_n184_n846# vp 0.03287f
C8 inverter_x4_5.OUT PFD_buffor_0.in 0.07478f
C9 PFD_flip_flop_1.post_NOR PFD_flip_flop_1.clk_n 0.07102f
C10 PFD_flip_flop_1.post_NOR vp 0.19875f
C11 PFD_flip_flop_0.post_NOR PFD_flip_flop_0.2 0.52975f
C12 PFD_flip_flop_0.clk_n flip_flop_reset 0.12894f
C13 cVco PFD_flip_flop_0.post_NOR 0.02321f
C14 PFD_buffor_0.in vp 0.3673f
C15 rst cRef 0.05115f
C16 PFD_flip_flop_0.3 PFD_flip_flop_0.NQ 0.41135f
C17 inverter_x4_5.OUT a_2226_46# 0.0881f
C18 a_3426_854# pre_down 0.01278f
C19 a_812_76# pre_down 0.0257f
C20 PFD_flip_flop_1.NQ cRef 0.04711f
C21 vp a_2226_46# 0.30605f
C22 pre_up PFD_flip_flop_0.NQ 0.2823f
C23 PFD_flip_flop_0.clk_n PFD_flip_flop_0.post_NOR 0.07102f
C24 PFD_flip_flop_1.clk_n cRef 1.67009f
C25 vp cRef 1.9836f
C26 a_812_n846# pre_up 0.0257f
C27 UP rst 0.07165f
C28 flip_flop_reset pre_down 0.25449f
C29 PFD_flip_flop_1.2 PFD_flip_flop_1.clk_n 0.17021f
C30 PFD_flip_flop_1.2 vp 0.44896f
C31 cVco PFD_flip_flop_0.NQ 0.05073f
C32 rst pre_up 0.28314f
C33 PFD_flip_flop_1.1 flip_flop_reset 0.02862f
C34 DOWN inverter_x4_0.OUT 0.16299f
C35 flip_flop_reset PFD_passgate_0.B 0.33419f
C36 flip_flop_reset PFD_flip_flop_0.post_NOR 0.29197f
C37 PFD_flip_flop_0.3 vp 0.23056f
C38 UP vp 0.15705f
C39 post_nand vp 0.52059f
C40 PFD_flip_flop_0.clk_n PFD_flip_flop_0.NQ 0.04811f
C41 inverter_x4_0.OUT pre_down 0.15111f
C42 pre_up vp 1.12274f
C43 inverter_x4_5.OUT cVco 0.06106f
C44 inverter_x4_3.OUT UP 0.14723f
C45 PFD_flip_flop_1.3 PFD_flip_flop_1.NQ 0.41033f
C46 vp PFD_flip_flop_0.2 0.45066f
C47 PFD_flip_flop_1.post_NOR cRef 0.02321f
C48 PFD_flip_flop_1.3 PFD_flip_flop_1.clk_n 0.17876f
C49 PFD_flip_flop_0.1 PFD_flip_flop_0.2 0.73166f
C50 PFD_flip_flop_1.3 vp 0.22673f
C51 inverter_x4_3.OUT pre_up 0.27449f
C52 PFD_buffor_0.in a_2226_46# 0.4719f
C53 cVco vp 2.00486f
C54 PFD_flip_flop_0.clk_n rst 0.039f
C55 PFD_flip_flop_1.2 PFD_flip_flop_1.post_NOR 0.52975f
C56 PFD_flip_flop_0.1 cVco 0.41322f
C57 flip_flop_reset PFD_flip_flop_0.NQ 0.0773f
C58 rst flip_flop_reset 0.18085f
C59 PFD_flip_flop_0.clk_n PFD_flip_flop_1.clk_n 0.01062f
C60 DOWN rst 0.06991f
C61 PFD_flip_flop_0.clk_n vp 1.27201f
C62 PFD_flip_flop_0.clk_n PFD_flip_flop_0.1 0.29182f
C63 inverter_x4_5.OUT flip_flop_reset 0.11007f
C64 a_812_76# vp 0.03285f
C65 post_nand PFD_buffor_0.in 0.1305f
C66 flip_flop_reset PFD_flip_flop_1.NQ 0.10926f
C67 PFD_flip_flop_1.2 cRef 0.38856f
C68 flip_flop_reset PFD_flip_flop_1.clk_n 0.13047f
C69 flip_flop_reset vp 2.39946f
C70 rst pre_down 0.05072f
C71 DOWN vp 0.19137f
C72 PFD_flip_flop_0.1 flip_flop_reset 0.02862f
C73 rst inverter_x4_0.OUT 0.05853f
C74 inverter_x4_5.OUT pre_down 1.03444f
C75 rst PFD_passgate_0.B 0.02705f
C76 DOWN inverter_x4_3.OUT 0.01996f
C77 post_nand a_2226_46# 0.02842f
C78 inverter_x4_5.OUT inverter_x4_0.OUT 0.03857f
C79 PFD_flip_flop_1.NQ pre_down 0.30677f
C80 inverter_x4_5.OUT PFD_passgate_0.B 0.05626f
C81 PFD_flip_flop_1.clk_n pre_down 0.24435f
C82 vp pre_down 0.95002f
C83 PFD_flip_flop_1.1 PFD_flip_flop_1.clk_n 0.29183f
C84 PFD_flip_flop_1.3 cRef 0.05283f
C85 inverter_x4_0.OUT vp 0.40924f
C86 PFD_flip_flop_1.1 vp 0.61032f
C87 PFD_passgate_0.B vp 0.10579f
C88 PFD_flip_flop_0.post_NOR vp 0.1998f
C89 cVco cRef 1.41056f
C90 PFD_flip_flop_0.1 PFD_flip_flop_0.post_NOR 0.44383f
C91 PFD_flip_flop_0.3 pre_up 0.87941f
C92 PFD_flip_flop_1.3 PFD_flip_flop_1.2 0.47261f
C93 flip_flop_reset PFD_flip_flop_1.post_NOR 0.29197f
C94 PFD_flip_flop_0.3 PFD_flip_flop_0.2 0.47261f
C95 rst PFD_flip_flop_0.NQ 0.01534f
C96 PFD_flip_flop_0.3 cVco 0.05287f
C97 post_nand pre_up 0.07886f
C98 pre_up PFD_flip_flop_0.2 0.04335f
C99 PFD_flip_flop_1.post_NOR pre_down 0.01195f
C100 vp PFD_flip_flop_0.NQ 0.3156f
C101 PFD_flip_flop_1.1 PFD_flip_flop_1.post_NOR 0.44383f
C102 cVco pre_up 0.02905f
C103 PFD_flip_flop_0.post_NOR a_n184_n846# 0.0257f
C104 inverter_x4_5.OUT rst 0.32117f
C105 PFD_buffor_0.in pre_down 0.20084f
C106 flip_flop_reset a_2226_46# 0.01669f
C107 cVco PFD_flip_flop_0.2 0.38864f
C108 a_812_n846# vp 0.03287f
C109 PFD_flip_flop_0.clk_n PFD_flip_flop_0.3 0.17847f
C110 flip_flop_reset cRef 0.53235f
C111 PFD_buffor_0.in PFD_passgate_0.B 0.01924f
C112 rst vp 1.19942f
C113 a_3426_854# post_nand 0.0511f
C114 PFD_flip_flop_1.2 flip_flop_reset 0.43181f
C115 inverter_x4_5.OUT PFD_flip_flop_1.clk_n 0.03251f
C116 PFD_flip_flop_0.clk_n pre_up 0.20409f
C117 inverter_x4_5.OUT vp 0.82029f
C118 PFD_flip_flop_0.3 flip_flop_reset 0.45495f
C119 a_2226_46# pre_down 0.038f
C120 inverter_x4_3.OUT rst 0.05924f
C121 PFD_flip_flop_0.clk_n PFD_flip_flop_0.2 0.17019f
C122 pre_down cRef 0.02948f
C123 a_n184_76# vp 0.03285f
C124 PFD_flip_flop_1.clk_n PFD_flip_flop_1.NQ 0.04811f
C125 PFD_flip_flop_1.NQ vp 0.30816f
C126 PFD_passgate_0.B a_2226_46# 0.28336f
C127 PFD_flip_flop_1.clk_n vp 1.26654f
C128 PFD_flip_flop_1.1 cRef 0.41322f
C129 PFD_flip_flop_0.clk_n cVco 1.67005f
C130 PFD_flip_flop_1.2 pre_down 0.04332f
C131 PFD_flip_flop_0.1 vp 0.61384f
C132 flip_flop_reset pre_up 0.25429f
C133 DOWN pre_up 0.12645f
C134 flip_flop_reset PFD_flip_flop_0.2 0.43181f
C135 PFD_flip_flop_1.1 PFD_flip_flop_1.2 0.73165f
C136 inverter_x4_3.OUT vp 0.39417f
C137 PFD_flip_flop_1.3 flip_flop_reset 0.44748f
C138 UP gnd 1.4476f
C139 DOWN gnd 0.54127f
C140 vp gnd 17.2197f
C141 PFD_flip_flop_0.NQ gnd 0.28519f
C142 a_812_n846# gnd 2.39659f
C143 PFD_flip_flop_0.post_NOR gnd 0.31194f
C144 a_n184_n846# gnd 2.374f
C145 PFD_flip_flop_0.2 gnd 3.42739f
C146 a_812_76# gnd 2.93854f
C147 a_3426_854# gnd 0.05949f
C148 PFD_passgate_0.B gnd 0.71361f
C149 a_2226_46# gnd 0.17005f
C150 PFD_flip_flop_1.NQ gnd 2.07464f
C151 PFD_flip_flop_1.post_NOR gnd 3.44877f
.ends
