* PEX produced on Mon Sep  7 02:04:51 PM CEST 2026 using /foss/tools/sak/sak-pex.sh with m=2 and s=1
* NGSPICE file created from PFD_cell_2.ext - technology: ihp-sg13cmos5l

.subckt PFD_cell_2 DOWN UP cRef cVco vp gnd rst
X0 PFD_flip_flop_0.1 PFD_flip_flop_0.clk_n PFD_flip_flop_0.post_NOR vp sg13_lv_pmos ad=0.102p pd=1.28u as=0.102p ps=1.28u w=0.3u l=0.15u
X1 gnd a_2226_46# PFD_passgate_0.B gnd sg13_lv_nmos ad=76f pd=0.78u as=0.136p ps=1.48u w=0.4u l=0.5u
X2 gnd pre_up a_3420_929# gnd sg13_lv_nmos ad=0.1005p pd=1.34u as=55.5f ps=0.74u w=0.15u l=0.13u
X3 a_812_76# PFD_flip_flop_1.3 vp vp sg13_lv_pmos ad=57f pd=0.68u as=0.102p ps=1.28u w=0.3u l=0.15u
X4 UP inverter_x4_3.OUT vp vp sg13_lv_pmos ad=0.204p pd=1.88u as=0.204p ps=1.88u w=0.6u l=0.13u
X5 inverter_x4_5.OUT rst gnd gnd sg13_lv_nmos ad=0.204p pd=1.88u as=0.204p ps=1.88u w=0.6u l=0.13u
X6 PFD_flip_flop_1.3 cRef PFD_flip_flop_1.2 gnd sg13_lv_nmos ad=0.102p pd=1.28u as=0.102p ps=1.28u w=0.3u l=0.15u
X7 PFD_flip_flop_1.NQ pre_down vp vp sg13_lv_pmos ad=0.408p pd=3.08u as=0.408p ps=3.08u w=1.2u l=0.13u
X8 a_n184_n846# PFD_flip_flop_0.2 vp vp sg13_lv_pmos ad=57f pd=0.68u as=0.102p ps=1.28u w=0.3u l=0.15u
X9 PFD_flip_flop_1.1 cRef vp vp sg13_lv_pmos ad=0.102p pd=1.28u as=0.102p ps=1.28u w=0.3u l=0.15u
X10 PFD_flip_flop_0.1 cVco vp vp sg13_lv_pmos ad=0.102p pd=1.28u as=0.102p ps=1.28u w=0.3u l=0.15u
X11 a_812_n846# PFD_flip_flop_0.3 vp vp sg13_lv_pmos ad=57f pd=0.68u as=0.102p ps=1.28u w=0.3u l=0.15u
X12 gnd PFD_flip_flop_0.3 gnd gnd sg13_lv_nmos ad=0.95p pd=5.38u as=58.13102p ps=0.27917m w=5u l=5u
X13 PFD_passgate_0.B inverter_x4_5.OUT flip_flop_reset gnd sg13_lv_nmos ad=0.102p pd=1.28u as=0.102p ps=1.28u w=0.3u l=0.15u
X14 PFD_flip_flop_1.clk_n cRef vp vp sg13_lv_pmos ad=0.204p pd=1.88u as=0.204p ps=1.88u w=0.6u l=0.13u
X15 PFD_flip_flop_1.2 PFD_flip_flop_1.1 vp vp sg13_lv_pmos ad=0.408p pd=3.08u as=0.408p ps=3.08u w=1.2u l=0.13u
X16 PFD_flip_flop_1.1 PFD_flip_flop_1.clk_n PFD_flip_flop_1.post_NOR vp sg13_lv_pmos ad=0.102p pd=1.28u as=0.102p ps=1.28u w=0.3u l=0.15u
X17 vp inverter_x4_5.OUT flip_flop_reset vp sg13_lv_pmos ad=0.102p pd=1.28u as=0.102p ps=1.28u w=0.3u l=0.15u
X18 gnd PFD_flip_flop_0.2 gnd gnd sg13_lv_nmos ad=0.95p pd=5.38u as=0 ps=0 w=5u l=5u
X19 pre_down flip_flop_reset gnd gnd sg13_lv_nmos ad=0.102p pd=1.28u as=57f ps=0.68u w=0.3u l=0.15u
X20 a_2226_46# PFD_buffor_0.in gnd gnd sg13_lv_nmos ad=0.136p pd=1.48u as=76f ps=0.78u w=0.4u l=0.5u
X21 PFD_flip_flop_1.post_NOR flip_flop_reset gnd gnd sg13_lv_nmos ad=0.102p pd=1.28u as=57f ps=0.68u w=0.3u l=0.15u
X22 PFD_flip_flop_0.NQ pre_up gnd gnd sg13_lv_nmos ad=0.408p pd=3.08u as=0.408p ps=3.08u w=1.2u l=0.13u
X23 DOWN inverter_x4_0.OUT gnd gnd sg13_lv_nmos ad=0.204p pd=1.88u as=0.204p ps=1.88u w=0.6u l=0.13u
X24 gnd PFD_flip_flop_1.1 gnd gnd sg13_lv_nmos ad=1.7p pd=10.68u as=0 ps=0 w=5u l=5u
X25 gnd PFD_flip_flop_1.2 gnd gnd sg13_lv_nmos ad=0.95p pd=5.38u as=0 ps=0 w=5u l=5u
X26 PFD_flip_flop_1.NQ pre_down gnd gnd sg13_lv_nmos ad=0.408p pd=3.08u as=0.408p ps=3.08u w=1.2u l=0.13u
X27 PFD_flip_flop_0.3 cVco PFD_flip_flop_0.NQ vp sg13_lv_pmos ad=0.102p pd=1.28u as=0.102p ps=1.28u w=0.3u l=0.15u
X28 PFD_flip_flop_1.3 cRef PFD_flip_flop_1.NQ vp sg13_lv_pmos ad=0.102p pd=1.28u as=0.102p ps=1.28u w=0.3u l=0.15u
X29 pre_up flip_flop_reset a_812_n846# vp sg13_lv_pmos ad=0.102p pd=1.28u as=57f ps=0.68u w=0.3u l=0.15u
X30 PFD_flip_flop_0.clk_n cVco gnd gnd sg13_lv_nmos ad=0.204p pd=1.88u as=0.204p ps=1.88u w=0.6u l=0.13u
X31 gnd PFD_flip_flop_0.2 PFD_flip_flop_0.post_NOR gnd sg13_lv_nmos ad=57f pd=0.68u as=0.102p ps=1.28u w=0.3u l=0.15u
X32 PFD_flip_flop_1.2 PFD_flip_flop_1.1 gnd gnd sg13_lv_nmos ad=0.408p pd=3.08u as=0.408p ps=3.08u w=1.2u l=0.13u
X33 inverter_x4_5.OUT rst vp vp sg13_lv_pmos ad=0.204p pd=1.88u as=0.204p ps=1.88u w=0.6u l=0.13u
X34 inverter_x4_0.OUT pre_down vp vp sg13_lv_pmos ad=0.204p pd=1.88u as=0.204p ps=1.88u w=0.6u l=0.13u
X35 gnd PFD_flip_flop_1.3 pre_down gnd sg13_lv_nmos ad=57f pd=0.68u as=0.102p ps=1.28u w=0.3u l=0.15u
X36 gnd post_nand PFD_buffor_0.in gnd sg13_lv_nmos ad=0.204p pd=1.88u as=0.204p ps=1.88u w=0.6u l=0.13u
X37 PFD_flip_flop_1.3 PFD_flip_flop_1.clk_n PFD_flip_flop_1.2 vp sg13_lv_pmos ad=0.102p pd=1.28u as=0.102p ps=1.28u w=0.3u l=0.15u
X38 vp a_2226_46# PFD_passgate_0.B vp sg13_lv_pmos ad=76f pd=0.78u as=0.136p ps=1.48u w=0.4u l=0.5u
X39 PFD_flip_flop_0.clk_n cVco vp vp sg13_lv_pmos ad=0.204p pd=1.88u as=0.204p ps=1.88u w=0.6u l=0.13u
X40 PFD_flip_flop_0.post_NOR flip_flop_reset gnd gnd sg13_lv_nmos ad=0.102p pd=1.28u as=57f ps=0.68u w=0.3u l=0.15u
X41 gnd PFD_flip_flop_0.3 pre_up gnd sg13_lv_nmos ad=57f pd=0.68u as=0.102p ps=1.28u w=0.3u l=0.15u
X42 UP inverter_x4_3.OUT gnd gnd sg13_lv_nmos ad=0.204p pd=1.88u as=0.204p ps=1.88u w=0.6u l=0.13u
X43 PFD_flip_flop_1.post_NOR flip_flop_reset a_n184_76# vp sg13_lv_pmos ad=0.102p pd=1.28u as=57f ps=0.68u w=0.3u l=0.15u
X44 vp pre_up post_nand vp sg13_lv_pmos ad=0.1005p pd=1.34u as=55.5f ps=0.74u w=0.15u l=0.13u
X45 PFD_flip_flop_0.2 PFD_flip_flop_0.1 gnd gnd sg13_lv_nmos ad=0.408p pd=3.08u as=0.408p ps=3.08u w=1.2u l=0.13u
X46 PFD_flip_flop_1.clk_n cRef gnd gnd sg13_lv_nmos ad=0.204p pd=1.88u as=0.204p ps=1.88u w=0.6u l=0.13u
X47 a_n184_76# PFD_flip_flop_1.2 vp vp sg13_lv_pmos ad=57f pd=0.68u as=0.102p ps=1.28u w=0.3u l=0.15u
X48 pre_down flip_flop_reset a_812_76# vp sg13_lv_pmos ad=0.102p pd=1.28u as=57f ps=0.68u w=0.3u l=0.15u
X49 PFD_passgate_0.B rst flip_flop_reset vp sg13_lv_pmos ad=0.102p pd=1.28u as=0.102p ps=1.28u w=0.3u l=0.15u
X50 gnd rst DOWN gnd sg13_lv_nmos ad=0.153p pd=1.58u as=0.153p ps=1.58u w=0.45u l=0.15u
X51 PFD_flip_flop_0.post_NOR flip_flop_reset a_n184_n846# vp sg13_lv_pmos ad=0.102p pd=1.28u as=57f ps=0.68u w=0.3u l=0.15u
X52 PFD_flip_flop_0.3 PFD_flip_flop_0.clk_n PFD_flip_flop_0.2 vp sg13_lv_pmos ad=0.102p pd=1.28u as=0.102p ps=1.28u w=0.3u l=0.15u
X53 pre_up flip_flop_reset gnd gnd sg13_lv_nmos ad=0.102p pd=1.28u as=57f ps=0.68u w=0.3u l=0.15u
X54 a_3420_929# pre_down post_nand gnd sg13_lv_nmos ad=55.5f pd=0.74u as=0.1005p ps=1.34u w=0.15u l=0.13u
X55 inverter_x4_3.OUT pre_up gnd gnd sg13_lv_nmos ad=0.204p pd=1.88u as=0.204p ps=1.88u w=0.6u l=0.13u
X56 gnd PFD_flip_flop_1.3 gnd gnd sg13_lv_nmos ad=0.95p pd=5.38u as=0 ps=0 w=5u l=5u
X57 PFD_flip_flop_1.1 PFD_flip_flop_1.clk_n vp gnd sg13_lv_nmos ad=0.102p pd=1.28u as=0.102p ps=1.28u w=0.3u l=0.15u
X58 inverter_x4_0.OUT pre_down gnd gnd sg13_lv_nmos ad=0.204p pd=1.88u as=0.204p ps=1.88u w=0.6u l=0.13u
X59 PFD_flip_flop_1.1 cRef PFD_flip_flop_1.post_NOR gnd sg13_lv_nmos ad=0.102p pd=1.28u as=0.102p ps=1.28u w=0.3u l=0.15u
X60 vp post_nand PFD_buffor_0.in vp sg13_lv_pmos ad=0.204p pd=1.88u as=0.204p ps=1.88u w=0.6u l=0.13u
X61 UP rst gnd gnd sg13_lv_nmos ad=0.153p pd=1.58u as=0.153p ps=1.58u w=0.45u l=0.15u
X62 DOWN inverter_x4_0.OUT vp vp sg13_lv_pmos ad=0.204p pd=1.88u as=0.204p ps=1.88u w=0.6u l=0.13u
X63 a_2226_46# PFD_buffor_0.in vp vp sg13_lv_pmos ad=0.136p pd=1.48u as=76f ps=0.78u w=0.4u l=0.5u
X64 post_nand pre_down vp vp sg13_lv_pmos ad=55.5f pd=0.74u as=0.1005p ps=1.34u w=0.15u l=0.13u
X65 gnd PFD_flip_flop_0.1 gnd gnd sg13_lv_nmos ad=1.7p pd=10.68u as=0 ps=0 w=5u l=5u
X66 PFD_flip_flop_0.2 PFD_flip_flop_0.1 vp vp sg13_lv_pmos ad=0.408p pd=3.08u as=0.408p ps=3.08u w=1.2u l=0.13u
X67 PFD_flip_flop_0.NQ pre_up vp vp sg13_lv_pmos ad=0.408p pd=3.08u as=0.408p ps=3.08u w=1.2u l=0.13u
X68 PFD_flip_flop_0.3 cVco PFD_flip_flop_0.2 gnd sg13_lv_nmos ad=0.102p pd=1.28u as=0.102p ps=1.28u w=0.3u l=0.15u
X69 PFD_flip_flop_0.1 cVco PFD_flip_flop_0.post_NOR gnd sg13_lv_nmos ad=0.102p pd=1.28u as=0.102p ps=1.28u w=0.3u l=0.15u
X70 PFD_flip_flop_0.3 PFD_flip_flop_0.clk_n PFD_flip_flop_0.NQ gnd sg13_lv_nmos ad=0.102p pd=1.28u as=0.102p ps=1.28u w=0.3u l=0.15u
X71 PFD_flip_flop_1.3 PFD_flip_flop_1.clk_n PFD_flip_flop_1.NQ gnd sg13_lv_nmos ad=0.102p pd=1.28u as=0.102p ps=1.28u w=0.3u l=0.15u
X72 PFD_flip_flop_0.1 PFD_flip_flop_0.clk_n vp gnd sg13_lv_nmos ad=0.102p pd=1.28u as=0.102p ps=1.28u w=0.3u l=0.15u
X73 gnd PFD_flip_flop_1.2 PFD_flip_flop_1.post_NOR gnd sg13_lv_nmos ad=57f pd=0.68u as=0.102p ps=1.28u w=0.3u l=0.15u
X74 inverter_x4_3.OUT pre_up vp vp sg13_lv_pmos ad=0.204p pd=1.88u as=0.204p ps=1.88u w=0.6u l=0.13u
X75 vp rst flip_flop_reset gnd sg13_lv_nmos ad=0.102p pd=1.28u as=0.102p ps=1.28u w=0.3u l=0.15u
C0 vp PFD_flip_flop_1.NQ 0.32559f
C1 flip_flop_reset PFD_flip_flop_1.1 0.03335f
C2 PFD_flip_flop_0.3 PFD_flip_flop_0.NQ 0.47972f
C3 PFD_flip_flop_0.1 flip_flop_reset 0.03335f
C4 flip_flop_reset PFD_flip_flop_0.post_NOR 0.34484f
C5 flip_flop_reset a_812_n846# 0.01021f
C6 cRef PFD_flip_flop_1.NQ 0.0592f
C7 flip_flop_reset PFD_flip_flop_0.3 0.57484f
C8 vp PFD_flip_flop_1.2 0.47192f
C9 a_n184_76# PFD_flip_flop_1.post_NOR 0.03017f
C10 PFD_passgate_0.B rst 0.03246f
C11 flip_flop_reset PFD_flip_flop_1.3 0.5641f
C12 pre_up cVco 0.03761f
C13 inverter_x4_5.OUT PFD_flip_flop_1.NQ 0.01353f
C14 PFD_flip_flop_1.clk_n PFD_flip_flop_1.post_NOR 0.08815f
C15 vp a_812_76# 0.03918f
C16 a_2226_46# PFD_buffor_0.in 0.5679f
C17 cRef PFD_flip_flop_1.2 0.47243f
C18 flip_flop_reset PFD_flip_flop_0.NQ 0.10737f
C19 a_2226_46# flip_flop_reset 0.01969f
C20 post_nand a_3420_929# 0.02445f
C21 rst PFD_flip_flop_0.clk_n 0.05478f
C22 PFD_flip_flop_1.1 PFD_flip_flop_1.2 0.8777f
C23 PFD_flip_flop_1.NQ PFD_flip_flop_1.3 0.4787f
C24 pre_down PFD_flip_flop_1.post_NOR 0.01691f
C25 vp cVco 2.05823f
C26 PFD_flip_flop_1.clk_n PFD_flip_flop_0.clk_n 0.01861f
C27 PFD_flip_flop_1.2 PFD_flip_flop_1.3 0.58675f
C28 cRef cVco 1.60147f
C29 cVco PFD_flip_flop_0.2 0.47252f
C30 flip_flop_reset PFD_flip_flop_1.NQ 0.14459f
C31 vp a_n184_n846# 0.0392f
C32 cVco inverter_x4_5.OUT 0.07604f
C33 UP rst 0.07849f
C34 flip_flop_reset PFD_flip_flop_1.2 0.55101f
C35 flip_flop_reset a_812_76# 0.01021f
C36 pre_down rst 0.09422f
C37 PFD_flip_flop_0.1 cVco 0.49697f
C38 PFD_flip_flop_0.post_NOR cVco 0.02789f
C39 cVco PFD_flip_flop_0.3 0.0668f
C40 PFD_flip_flop_1.clk_n pre_down 0.28511f
C41 inverter_x4_0.OUT rst 0.07109f
C42 pre_up PFD_flip_flop_0.clk_n 0.24336f
C43 a_n184_n846# PFD_flip_flop_0.post_NOR 0.03017f
C44 vp PFD_passgate_0.B 0.11093f
C45 vp PFD_flip_flop_1.post_NOR 0.20324f
C46 cVco PFD_flip_flop_0.NQ 0.06354f
C47 pre_up rst 0.37132f
C48 flip_flop_reset cVco 0.46288f
C49 cRef PFD_flip_flop_1.post_NOR 0.02789f
C50 PFD_passgate_0.B inverter_x4_5.OUT 0.06494f
C51 flip_flop_reset a_n184_n846# 0.01022f
C52 inverter_x4_0.OUT pre_down 0.21799f
C53 vp PFD_flip_flop_0.clk_n 1.33932f
C54 inverter_x4_3.OUT rst 0.07189f
C55 PFD_flip_flop_1.1 PFD_flip_flop_1.post_NOR 0.5285f
C56 vp a_n184_76# 0.03918f
C57 vp rst 1.28279f
C58 pre_up pre_down 0.38515f
C59 PFD_flip_flop_0.clk_n PFD_flip_flop_0.2 0.20681f
C60 UP inverter_x4_3.OUT 0.18564f
C61 vp PFD_flip_flop_1.clk_n 1.33368f
C62 PFD_passgate_0.B PFD_flip_flop_1.3 0.01152f
C63 cRef rst 0.06716f
C64 pre_up inverter_x4_0.OUT 0.05674f
C65 vp UP 0.16607f
C66 PFD_buffor_0.in PFD_passgate_0.B 0.02339f
C67 cRef PFD_flip_flop_1.clk_n 1.97143f
C68 inverter_x4_5.OUT rst 0.4133f
C69 flip_flop_reset PFD_passgate_0.B 0.39535f
C70 a_2226_46# PFD_passgate_0.B 0.31914f
C71 flip_flop_reset PFD_flip_flop_1.post_NOR 0.34484f
C72 PFD_flip_flop_0.1 PFD_flip_flop_0.clk_n 0.33345f
C73 PFD_flip_flop_1.clk_n inverter_x4_5.OUT 0.04745f
C74 PFD_flip_flop_0.post_NOR PFD_flip_flop_0.clk_n 0.08815f
C75 PFD_flip_flop_0.3 PFD_flip_flop_0.clk_n 0.22291f
C76 vp pre_down 0.95726f
C77 DOWN rst 0.07553f
C78 post_nand pre_down 0.19685f
C79 PFD_flip_flop_1.1 PFD_flip_flop_1.clk_n 0.33346f
C80 vp inverter_x4_0.OUT 0.42137f
C81 cRef pre_down 0.03822f
C82 inverter_x4_3.OUT pre_up 0.38308f
C83 PFD_flip_flop_0.NQ PFD_flip_flop_0.clk_n 0.05672f
C84 flip_flop_reset PFD_flip_flop_0.clk_n 0.13811f
C85 inverter_x4_5.OUT pre_down 1.22886f
C86 PFD_flip_flop_1.clk_n PFD_flip_flop_1.3 0.2232f
C87 vp pre_up 1.13047f
C88 PFD_flip_flop_0.NQ rst 0.02073f
C89 pre_up post_nand 0.09477f
C90 flip_flop_reset a_n184_76# 0.01022f
C91 flip_flop_reset rst 0.23166f
C92 inverter_x4_5.OUT inverter_x4_0.OUT 0.0561f
C93 pre_up PFD_flip_flop_0.2 0.06073f
C94 PFD_flip_flop_1.2 PFD_flip_flop_1.post_NOR 0.60407f
C95 flip_flop_reset PFD_flip_flop_1.clk_n 0.13963f
C96 DOWN inverter_x4_0.OUT 0.20449f
C97 vp inverter_x4_3.OUT 0.40635f
C98 pre_down PFD_flip_flop_1.3 0.93788f
C99 PFD_buffor_0.in pre_down 0.26555f
C100 pre_up DOWN 0.17555f
C101 vp post_nand 0.54342f
C102 a_2226_46# pre_down 0.04283f
C103 flip_flop_reset pre_down 0.29576f
C104 pre_up PFD_flip_flop_0.post_NOR 0.01691f
C105 pre_up a_812_n846# 0.03017f
C106 pre_up PFD_flip_flop_0.3 1.0138f
C107 PFD_flip_flop_1.clk_n PFD_flip_flop_1.NQ 0.05672f
C108 vp cRef 2.03391f
C109 vp PFD_flip_flop_0.2 0.47368f
C110 vp inverter_x4_5.OUT 0.8563f
C111 inverter_x4_3.OUT DOWN 0.02611f
C112 PFD_flip_flop_1.clk_n PFD_flip_flop_1.2 0.20683f
C113 pre_up PFD_flip_flop_0.NQ 0.35881f
C114 flip_flop_reset pre_up 0.2957f
C115 vp PFD_flip_flop_1.1 0.66984f
C116 vp DOWN 0.20446f
C117 PFD_flip_flop_1.NQ pre_down 0.38588f
C118 vp PFD_flip_flop_0.1 0.67335f
C119 vp PFD_flip_flop_0.post_NOR 0.20428f
C120 vp a_812_n846# 0.0392f
C121 vp PFD_flip_flop_0.3 0.23303f
C122 cVco PFD_flip_flop_0.clk_n 1.97139f
C123 cRef PFD_flip_flop_1.1 0.49697f
C124 vp PFD_flip_flop_1.3 0.22826f
C125 PFD_flip_flop_0.1 PFD_flip_flop_0.2 0.87771f
C126 PFD_flip_flop_1.2 pre_down 0.06069f
C127 PFD_flip_flop_0.post_NOR PFD_flip_flop_0.2 0.60407f
C128 PFD_flip_flop_0.3 PFD_flip_flop_0.2 0.58675f
C129 vp PFD_buffor_0.in 0.37856f
C130 PFD_buffor_0.in post_nand 0.16014f
C131 vp PFD_flip_flop_0.NQ 0.33333f
C132 cRef PFD_flip_flop_1.3 0.06675f
C133 a_812_76# pre_down 0.03017f
C134 vp flip_flop_reset 2.51875f
C135 a_2226_46# vp 0.31205f
C136 a_2226_46# post_nand 0.03532f
C137 PFD_buffor_0.in inverter_x4_5.OUT 0.07654f
C138 cRef flip_flop_reset 0.59577f
C139 flip_flop_reset PFD_flip_flop_0.2 0.55101f
C140 PFD_flip_flop_0.1 PFD_flip_flop_0.post_NOR 0.5285f
C141 PFD_flip_flop_1.1 PFD_flip_flop_1.3 0.01203f
C142 PFD_flip_flop_0.1 PFD_flip_flop_0.3 0.01203f
C143 a_2226_46# inverter_x4_5.OUT 0.09685f
C144 flip_flop_reset inverter_x4_5.OUT 0.13267f
C145 UP gnd 0.91242f
C146 DOWN gnd 0.56832f
C147 vp gnd 13.79713f
C148 PFD_flip_flop_0.NQ gnd 0.30765f
C149 a_812_n846# gnd 2.42963f
C150 PFD_flip_flop_0.post_NOR gnd 1.10852f
C151 a_n184_n846# gnd 2.41941f
C152 PFD_flip_flop_0.2 gnd 3.51281f
C153 a_812_76# gnd 2.43727f
C154 a_3420_929# gnd 1.49584f
C155 PFD_passgate_0.B gnd 1.23764f
C156 a_2226_46# gnd 0.24694f
C157 PFD_flip_flop_1.NQ gnd 2.01683f
C158 PFD_flip_flop_1.post_NOR gnd 1.12634f
.ends
