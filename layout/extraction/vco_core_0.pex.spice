* PEX produced on Thu Oct  8 06:31:34 PM CEST 2026 using /foss/tools/sak/sak-pex.sh with m=2 and s=1
* NGSPICE file created from vco_core_0.ext - technology: ihp-sg13cmos5l

.subckt vco_core_0 in out gnd vp
X0 vco_delay_cell_0$1_1.pgt vco_delay_cell_0$1_1.pgt vp vp sg13_lv_pmos ad=0.114p pd=0.98u as=0.204p ps=1.88u w=0.6u l=0.56u
X1 a_938_n478# vco_delay_cell_0$1_4.in vco_delay_cell_0$1_3.in gnd sg13_lv_nmos ad=0.136p pd=1.48u as=76f ps=0.78u w=0.4u l=0.28u
X2 a_292_1054# vco_delay_cell_0$1_1.pgt vp vp sg13_lv_pmos ad=0.114p pd=0.98u as=0.204p ps=1.88u w=0.6u l=0.56u
X3 a_904_626# in gnd gnd sg13_lv_nmos ad=76f pd=0.78u as=0.136p ps=1.48u w=0.4u l=0.56u
X4 a_n354_n946# vco_delay_cell_0$1_1.pgt vp vp sg13_lv_pmos ad=0.114p pd=0.98u as=0.204p ps=1.88u w=0.6u l=0.56u
X5 vp vco_delay_cell_0$1_1.pgt a_904_1054# vp sg13_lv_pmos ad=0.204p pd=1.88u as=0.114p ps=0.98u w=0.6u l=0.56u
X6 a_938_n478# in gnd gnd sg13_lv_nmos ad=76f pd=0.78u as=0.136p ps=1.48u w=0.4u l=0.56u
X7 a_n354_n478# vco_delay_cell_0$1_2.in out gnd sg13_lv_nmos ad=0.136p pd=1.48u as=76f ps=0.78u w=0.4u l=0.28u
X8 a_258_n478# vco_delay_cell_0$1_3.in vco_delay_cell_0$1_2.in gnd sg13_lv_nmos ad=0.136p pd=1.48u as=76f ps=0.78u w=0.4u l=0.28u
X9 out vco_delay_cell_0$1_2.in a_n354_n946# vp sg13_lv_pmos ad=0.114p pd=0.98u as=0.204p ps=1.88u w=0.6u l=0.28u
X10 a_258_n478# in gnd gnd sg13_lv_nmos ad=76f pd=0.78u as=0.136p ps=1.48u w=0.4u l=0.56u
X11 a_292_1054# out vco_delay_cell_0$1_1.out vp sg13_lv_pmos ad=0.204p pd=1.88u as=0.114p ps=0.98u w=0.6u l=0.28u
X12 a_292_626# out vco_delay_cell_0$1_1.out gnd sg13_lv_nmos ad=0.136p pd=1.48u as=76f ps=0.78u w=0.4u l=0.28u
X13 a_n354_n478# in gnd gnd sg13_lv_nmos ad=76f pd=0.78u as=0.136p ps=1.48u w=0.4u l=0.56u
X14 vco_delay_cell_0$1_4.in vco_delay_cell_0$1_1.out a_904_626# gnd sg13_lv_nmos ad=76f pd=0.78u as=0.136p ps=1.48u w=0.4u l=0.28u
X15 vp vco_delay_cell_0$1_1.pgt a_938_n946# vp sg13_lv_pmos ad=0.204p pd=1.88u as=0.114p ps=0.98u w=0.6u l=0.56u
X16 gnd in a_938_n478# gnd sg13_lv_nmos ad=0.136p pd=1.48u as=76f ps=0.78u w=0.4u l=0.56u
X17 vco_delay_cell_0$1_3.in vco_delay_cell_0$1_4.in a_938_n946# vp sg13_lv_pmos ad=0.114p pd=0.98u as=0.204p ps=1.88u w=0.6u l=0.28u
X18 vp vco_delay_cell_0$1_1.pgt a_n354_n946# vp sg13_lv_pmos ad=0.204p pd=1.88u as=0.114p ps=0.98u w=0.6u l=0.56u
X19 gnd in a_904_626# gnd sg13_lv_nmos ad=0.136p pd=1.48u as=76f ps=0.78u w=0.4u l=0.56u
X20 out vco_delay_cell_0$1_2.in a_n354_n478# gnd sg13_lv_nmos ad=76f pd=0.78u as=0.136p ps=1.48u w=0.4u l=0.28u
X21 gnd in vco_delay_cell_0$1_1.pgt gnd sg13_lv_nmos ad=0.136p pd=1.48u as=76f ps=0.78u w=0.4u l=0.56u
X22 gnd in a_258_n478# gnd sg13_lv_nmos ad=0.136p pd=1.48u as=76f ps=0.78u w=0.4u l=0.56u
X23 vco_delay_cell_0$1_2.in vco_delay_cell_0$1_3.in a_258_n946# vp sg13_lv_pmos ad=0.114p pd=0.98u as=0.204p ps=1.88u w=0.6u l=0.28u
X24 vco_delay_cell_0$1_4.in vco_delay_cell_0$1_1.out a_904_1054# vp sg13_lv_pmos ad=0.114p pd=0.98u as=0.204p ps=1.88u w=0.6u l=0.28u
X25 a_938_n946# vco_delay_cell_0$1_1.pgt vp vp sg13_lv_pmos ad=0.114p pd=0.98u as=0.204p ps=1.88u w=0.6u l=0.56u
X26 vp vco_delay_cell_0$1_1.pgt a_292_1054# vp sg13_lv_pmos ad=0.204p pd=1.88u as=0.114p ps=0.98u w=0.6u l=0.56u
X27 a_904_1054# vco_delay_cell_0$1_1.out vco_delay_cell_0$1_4.in vp sg13_lv_pmos ad=0.204p pd=1.88u as=0.114p ps=0.98u w=0.6u l=0.28u
X28 vp vco_delay_cell_0$1_1.pgt a_258_n946# vp sg13_lv_pmos ad=0.204p pd=1.88u as=0.114p ps=0.98u w=0.6u l=0.56u
X29 vp vco_delay_cell_0$1_1.pgt vco_delay_cell_0$1_1.pgt vp sg13_lv_pmos ad=0.204p pd=1.88u as=0.114p ps=0.98u w=0.6u l=0.56u
X30 vco_delay_cell_0$1_3.in vco_delay_cell_0$1_4.in a_938_n478# gnd sg13_lv_nmos ad=76f pd=0.78u as=0.136p ps=1.48u w=0.4u l=0.28u
X31 a_258_n946# vco_delay_cell_0$1_1.pgt vp vp sg13_lv_pmos ad=0.114p pd=0.98u as=0.204p ps=1.88u w=0.6u l=0.56u
X32 a_292_626# in gnd gnd sg13_lv_nmos ad=76f pd=0.78u as=0.136p ps=1.48u w=0.4u l=0.56u
X33 a_938_n946# vco_delay_cell_0$1_4.in vco_delay_cell_0$1_3.in vp sg13_lv_pmos ad=0.204p pd=1.88u as=0.114p ps=0.98u w=0.6u l=0.28u
X34 gnd in a_292_626# gnd sg13_lv_nmos ad=0.136p pd=1.48u as=76f ps=0.78u w=0.4u l=0.56u
X35 a_904_1054# vco_delay_cell_0$1_1.pgt vp vp sg13_lv_pmos ad=0.114p pd=0.98u as=0.204p ps=1.88u w=0.6u l=0.56u
X36 vco_delay_cell_0$1_1.pgt in gnd gnd sg13_lv_nmos ad=76f pd=0.78u as=0.136p ps=1.48u w=0.4u l=0.56u
X37 vco_delay_cell_0$1_2.in vco_delay_cell_0$1_3.in a_258_n478# gnd sg13_lv_nmos ad=76f pd=0.78u as=0.136p ps=1.48u w=0.4u l=0.28u
X38 a_n354_n946# vco_delay_cell_0$1_2.in out vp sg13_lv_pmos ad=0.204p pd=1.88u as=0.114p ps=0.98u w=0.6u l=0.28u
X39 vco_delay_cell_0$1_1.out out a_292_1054# vp sg13_lv_pmos ad=0.114p pd=0.98u as=0.204p ps=1.88u w=0.6u l=0.28u
X40 a_904_626# vco_delay_cell_0$1_1.out vco_delay_cell_0$1_4.in gnd sg13_lv_nmos ad=0.136p pd=1.48u as=76f ps=0.78u w=0.4u l=0.28u
X41 a_258_n946# vco_delay_cell_0$1_3.in vco_delay_cell_0$1_2.in vp sg13_lv_pmos ad=0.204p pd=1.88u as=0.114p ps=0.98u w=0.6u l=0.28u
X42 gnd in a_n354_n478# gnd sg13_lv_nmos ad=0.136p pd=1.48u as=76f ps=0.78u w=0.4u l=0.56u
X43 vco_delay_cell_0$1_1.out out a_292_626# gnd sg13_lv_nmos ad=76f pd=0.78u as=0.136p ps=1.48u w=0.4u l=0.28u
C0 vp a_292_1054# 0.15936f
C1 a_292_626# a_904_626# 0.01752f
C2 vco_delay_cell_0$1_4.in in 0.16679f
C3 vco_delay_cell_0$1_2.in in 0.08169f
C4 a_258_n946# vco_delay_cell_0$1_3.in 0.08084f
C5 vp vco_delay_cell_0$1_4.in 0.32542f
C6 vco_delay_cell_0$1_2.in vp 0.35797f
C7 vco_delay_cell_0$1_1.pgt vco_delay_cell_0$1_3.in 0.07661f
C8 vco_delay_cell_0$1_1.pgt vco_delay_cell_0$1_1.out 0.07534f
C9 out a_292_1054# 0.07831f
C10 a_n354_n478# in 0.12518f
C11 vp vco_delay_cell_0$1_1.out 0.36746f
C12 a_292_1054# a_904_1054# 0.01898f
C13 vp a_n354_n946# 0.15136f
C14 a_258_n946# a_938_n946# 0.01578f
C15 a_938_n478# in 0.12756f
C16 out vco_delay_cell_0$1_3.in 0.012f
C17 vco_delay_cell_0$1_1.pgt a_938_n946# 0.11616f
C18 out vco_delay_cell_0$1_1.out 0.25201f
C19 vco_delay_cell_0$1_1.out a_904_626# 0.06929f
C20 vco_delay_cell_0$1_1.pgt a_258_n946# 0.11803f
C21 vco_delay_cell_0$1_1.out a_904_1054# 0.08176f
C22 vp in 0.01663f
C23 vco_delay_cell_0$1_4.in vco_delay_cell_0$1_3.in 0.25513f
C24 vco_delay_cell_0$1_2.in vco_delay_cell_0$1_3.in 0.27785f
C25 vco_delay_cell_0$1_4.in vco_delay_cell_0$1_1.out 0.28232f
C26 a_292_626# in 0.12828f
C27 vco_delay_cell_0$1_2.in a_258_n478# 0.11652f
C28 vco_delay_cell_0$1_1.pgt vp 2.38456f
C29 a_258_n478# a_n354_n478# 0.01752f
C30 vco_delay_cell_0$1_1.pgt out 0.86495f
C31 a_938_n946# vco_delay_cell_0$1_4.in 0.081f
C32 a_938_n478# vco_delay_cell_0$1_3.in 0.1165f
C33 a_258_n478# a_938_n478# 0.01446f
C34 out vp 0.37689f
C35 vco_delay_cell_0$1_1.pgt a_904_1054# 0.11492f
C36 vco_delay_cell_0$1_2.in a_258_n946# 0.12324f
C37 vco_delay_cell_0$1_1.pgt vco_delay_cell_0$1_4.in 0.06047f
C38 vco_delay_cell_0$1_1.pgt vco_delay_cell_0$1_2.in 0.07846f
C39 vco_delay_cell_0$1_3.in in 0.08487f
C40 vco_delay_cell_0$1_1.out in 0.08247f
C41 a_258_n478# in 0.12786f
C42 vp vco_delay_cell_0$1_3.in 0.3719f
C43 vp a_904_1054# 0.15136f
C44 vp vco_delay_cell_0$1_4.in 0.08668f
C45 vco_delay_cell_0$1_1.out a_292_626# 0.11652f
C46 a_n354_n946# a_258_n946# 0.01898f
C47 vco_delay_cell_0$1_1.pgt a_n354_n946# 0.12423f
C48 out vco_delay_cell_0$1_4.in 0.01517f
C49 vco_delay_cell_0$1_2.in out 0.28085f
C50 vp a_938_n946# 0.15596f
C51 vco_delay_cell_0$1_1.out a_292_1054# 0.12324f
C52 vco_delay_cell_0$1_4.in a_904_626# 0.12443f
C53 out a_n354_n478# 0.12459f
C54 vco_delay_cell_0$1_4.in a_904_1054# 0.12317f
C55 vco_delay_cell_0$1_1.pgt in 0.07287f
C56 a_n354_n946# out 0.12373f
C57 vp a_258_n946# 0.15627f
C58 vco_delay_cell_0$1_1.pgt vp 2.22945f
C59 vco_delay_cell_0$1_1.pgt a_292_626# 0.01152f
C60 a_258_n478# vco_delay_cell_0$1_3.in 0.06851f
C61 vp in 0.02495f
C62 vco_delay_cell_0$1_2.in a_n354_n478# 0.06929f
C63 vco_delay_cell_0$1_2.in a_n354_n946# 0.08176f
C64 out in 0.16538f
C65 a_938_n478# vco_delay_cell_0$1_4.in 0.07779f
C66 vco_delay_cell_0$1_1.pgt a_292_1054# 0.131f
C67 vp out 0.08273f
C68 out a_292_626# 0.06841f
C69 a_938_n946# vco_delay_cell_0$1_3.in 0.12322f
C70 a_904_626# in 0.12562f
C71 vp gnd 0.27631f
C72 vp gnd 1.05343f
C73 a_938_n946# gnd 0.30759f
C74 a_258_n946# gnd 0.1413f
C75 a_n354_n946# gnd 0.34318f
C76 a_938_n478# gnd 0.67371f
C77 a_258_n478# gnd 0.62039f
C78 a_n354_n478# gnd 0.3742f
C79 a_904_626# gnd 2.7941f
C80 a_292_626# gnd 0.1352f
C81 vco_delay_cell_0$1_4.in gnd 0.0175f
C82 a_904_1054# gnd 0.02895f
C83 a_292_1054# gnd 0.67942f
.ends
