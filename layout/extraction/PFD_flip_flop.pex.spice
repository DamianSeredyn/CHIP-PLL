* PEX produced on Sat Aug 29 08:09:23 PM CEST 2026 using /foss/tools/sak/sak-pex.sh with m=2 and s=1
* NGSPICE file created from PFD_flip_flop.ext - technology: ihp-sg13cmos5l

.subckt PFD_flip_flop clk rst D Q NQ vp gd
X0 Q rst gd gd sg13_lv_nmos ad=0.102p pd=1.28u as=57f ps=0.68u w=0.3u l=0.15u
X1 3 clk NQ vp sg13_lv_pmos ad=0.102p pd=1.28u as=0.102p ps=1.28u w=0.3u l=0.15u
X2 3 clk_n NQ gd sg13_lv_nmos ad=0.102p pd=1.28u as=0.102p ps=1.28u w=0.3u l=0.15u
X3 a_812_118# 3 vp vp sg13_lv_pmos ad=57f pd=0.68u as=0.102p ps=1.28u w=0.3u l=0.15u
X4 PFD_NOR_1.Out rst gd gd sg13_lv_nmos ad=0.102p pd=1.28u as=57f ps=0.68u w=0.3u l=0.15u
X5 2 1 vp vp sg13_lv_pmos ad=0.408p pd=3.08u as=0.408p ps=3.08u w=1.2u l=0.13u
X6 3 clk 2 gd sg13_lv_nmos ad=0.102p pd=1.28u as=0.102p ps=1.28u w=0.3u l=0.15u
X7 clk_n clk vp vp sg13_lv_pmos ad=0.204p pd=1.88u as=0.204p ps=1.88u w=0.6u l=0.13u
X8 a_n184_118# 2 vp vp sg13_lv_pmos ad=57f pd=0.68u as=0.102p ps=1.28u w=0.3u l=0.15u
X9 2 1 gd gd sg13_lv_nmos ad=0.408p pd=3.08u as=0.408p ps=3.08u w=1.2u l=0.13u
X10 gd 2 PFD_NOR_1.Out gd sg13_lv_nmos ad=57f pd=0.68u as=0.102p ps=1.28u w=0.3u l=0.15u
X11 NQ Q gd gd sg13_lv_nmos ad=0.408p pd=3.08u as=0.408p ps=3.08u w=1.2u l=0.13u
X12 1 clk D vp sg13_lv_pmos ad=0.102p pd=1.28u as=0.102p ps=1.28u w=0.3u l=0.15u
X13 1 clk PFD_NOR_1.Out gd sg13_lv_nmos ad=0.102p pd=1.28u as=0.102p ps=1.28u w=0.3u l=0.15u
X14 gd 3 Q gd sg13_lv_nmos ad=57f pd=0.68u as=0.102p ps=1.28u w=0.3u l=0.15u
X15 clk_n clk gd gd sg13_lv_nmos ad=0.204p pd=1.88u as=0.204p ps=1.88u w=0.6u l=0.13u
X16 1 clk_n D gd sg13_lv_nmos ad=0.102p pd=1.28u as=0.102p ps=1.28u w=0.3u l=0.15u
X17 Q rst a_812_118# vp sg13_lv_pmos ad=0.102p pd=1.28u as=57f ps=0.68u w=0.3u l=0.15u
X18 1 clk_n PFD_NOR_1.Out vp sg13_lv_pmos ad=0.102p pd=1.28u as=0.102p ps=1.28u w=0.3u l=0.15u
X19 PFD_NOR_1.Out rst a_n184_118# vp sg13_lv_pmos ad=0.102p pd=1.28u as=57f ps=0.68u w=0.3u l=0.15u
X20 3 clk_n 2 vp sg13_lv_pmos ad=0.102p pd=1.28u as=0.102p ps=1.28u w=0.3u l=0.15u
X21 NQ Q vp vp sg13_lv_pmos ad=0.408p pd=3.08u as=0.408p ps=3.08u w=1.2u l=0.13u
C0 vp clk_n 1.26634f
C1 1 clk 0.29731f
C2 3 Q 0.55625f
C3 2 rst 0.99349f
C4 rst PFD_NOR_1.Out 0.60296f
C5 2 Q 0.034f
C6 Q PFD_NOR_1.Out 0.03611f
C7 vp 3 0.18791f
C8 3 clk_n 0.24812f
C9 1 rst 0.04133f
C10 vp D 0.07894f
C11 D clk_n 0.20898f
C12 1 Q 0.0284f
C13 2 vp 0.51704f
C14 2 clk_n 0.26566f
C15 vp PFD_NOR_1.Out 0.20087f
C16 clk_n PFD_NOR_1.Out 0.15594f
C17 vp 1 0.25544f
C18 1 clk_n 0.40016f
C19 NQ clk 0.11295f
C20 2 3 0.71485f
C21 a_812_118# rst 0.01334f
C22 rst clk 0.25069f
C23 a_n184_118# rst 0.01395f
C24 a_812_118# Q 0.05335f
C25 Q clk 0.06922f
C26 1 3 0.02114f
C27 2 PFD_NOR_1.Out 0.89874f
C28 rst NQ 0.02663f
C29 1 D 0.65487f
C30 NQ Q 0.3724f
C31 vp a_812_118# 0.06667f
C32 2 1 1.14481f
C33 vp clk 1.56107f
C34 1 PFD_NOR_1.Out 0.99003f
C35 a_n184_118# vp 0.06667f
C36 clk_n clk 3.81747f
C37 rst Q 0.45601f
C38 vp NQ 0.37374f
C39 NQ clk_n 0.09386f
C40 vp rst 0.52003f
C41 3 clk 0.10675f
C42 rst clk_n 0.16252f
C43 D clk 0.12106f
C44 vp Q 0.32568f
C45 clk_n Q 0.04943f
C46 NQ 3 0.84138f
C47 2 clk 0.13277f
C48 PFD_NOR_1.Out clk 0.04475f
C49 a_n184_118# PFD_NOR_1.Out 0.05335f
C50 rst 3 0.64883f
C51 NQ gd 3.72636f
C52 D gd 0.12956f
C53 vp gd 3.21027f
C54 a_812_118# gd 1.5597f
C55 PFD_NOR_1.Out gd 0.48522f
C56 a_n184_118# gd 0.56876f
.ends
