* PEX produced on Mon Aug 31 02:59:27 PM CEST 2026 using /foss/tools/sak/sak-pex.sh with m=2 and s=1
* NGSPICE file created from PFD_flip_flop.ext - technology: ihp-sg13cmos5l

.subckt PFD_flip_flop clk rst D Q NQ vp gd
X0 Q rst gd gd sg13_lv_nmos ad=0.102p pd=1.28u as=57f ps=0.68u w=0.3u l=0.15u
X1 3 clk NQ vp sg13_lv_pmos ad=0.102p pd=1.28u as=0.102p ps=1.28u w=0.3u l=0.15u
X2 3 clk_n NQ gd sg13_lv_nmos ad=0.102p pd=1.28u as=0.102p ps=1.28u w=0.3u l=0.15u
X3 a_812_118# 3 vp vp sg13_lv_pmos ad=57f pd=0.68u as=0.102p ps=1.28u w=0.3u l=0.15u
X4 post_NOR rst gd gd sg13_lv_nmos ad=0.102p pd=1.28u as=57f ps=0.68u w=0.3u l=0.15u
X5 2 1 vp vp sg13_lv_pmos ad=0.408p pd=3.08u as=0.408p ps=3.08u w=1.2u l=0.13u
X6 3 clk 2 gd sg13_lv_nmos ad=0.102p pd=1.28u as=0.102p ps=1.28u w=0.3u l=0.15u
X7 clk_n clk vp vp sg13_lv_pmos ad=0.204p pd=1.88u as=0.204p ps=1.88u w=0.6u l=0.13u
X8 a_n184_118# 2 vp vp sg13_lv_pmos ad=57f pd=0.68u as=0.102p ps=1.28u w=0.3u l=0.15u
X9 2 1 gd gd sg13_lv_nmos ad=0.408p pd=3.08u as=0.408p ps=3.08u w=1.2u l=0.13u
X10 gd 2 post_NOR gd sg13_lv_nmos ad=57f pd=0.68u as=0.102p ps=1.28u w=0.3u l=0.15u
X11 NQ Q gd gd sg13_lv_nmos ad=0.408p pd=3.08u as=0.408p ps=3.08u w=1.2u l=0.13u
X12 1 clk D vp sg13_lv_pmos ad=0.102p pd=1.28u as=0.102p ps=1.28u w=0.3u l=0.15u
X13 1 clk post_NOR gd sg13_lv_nmos ad=0.102p pd=1.28u as=0.102p ps=1.28u w=0.3u l=0.15u
X14 gd 3 Q gd sg13_lv_nmos ad=57f pd=0.68u as=0.102p ps=1.28u w=0.3u l=0.15u
X15 clk_n clk gd gd sg13_lv_nmos ad=0.204p pd=1.88u as=0.204p ps=1.88u w=0.6u l=0.13u
X16 1 clk_n D gd sg13_lv_nmos ad=0.102p pd=1.28u as=0.102p ps=1.28u w=0.3u l=0.15u
X17 Q rst a_812_118# vp sg13_lv_pmos ad=0.102p pd=1.28u as=57f ps=0.68u w=0.3u l=0.15u
X18 1 clk_n post_NOR vp sg13_lv_pmos ad=0.102p pd=1.28u as=0.102p ps=1.28u w=0.3u l=0.15u
X19 post_NOR rst a_n184_118# vp sg13_lv_pmos ad=0.102p pd=1.28u as=57f ps=0.68u w=0.3u l=0.15u
X20 3 clk_n 2 vp sg13_lv_pmos ad=0.102p pd=1.28u as=0.102p ps=1.28u w=0.3u l=0.15u
X21 NQ Q vp vp sg13_lv_pmos ad=0.408p pd=3.08u as=0.408p ps=3.08u w=1.2u l=0.13u
C0 vp rst 0.51049f
C1 3 clk 0.06681f
C2 rst clk_n 0.13716f
C3 D clk 0.0734f
C4 vp Q 0.29178f
C5 clk_n Q 0.02865f
C6 NQ 3 0.48898f
C7 2 clk 0.07765f
C8 post_NOR clk 0.0281f
C9 a_n184_118# post_NOR 0.03017f
C10 rst 3 0.38749f
C11 vp clk_n 1.08244f
C12 1 clk 0.19569f
C13 3 Q 0.54746f
C14 2 rst 0.54622f
C15 rst post_NOR 0.4044f
C16 2 Q 0.02053f
C17 Q post_NOR 0.02014f
C18 vp 3 0.18397f
C19 3 clk_n 0.14311f
C20 1 rst 0.03328f
C21 vp D 0.07753f
C22 D clk_n 0.13788f
C23 1 Q 0.01651f
C24 2 vp 0.41519f
C25 2 clk_n 0.14643f
C26 vp post_NOR 0.18301f
C27 clk_n post_NOR 0.09203f
C28 1 vp 0.25171f
C29 1 clk_n 0.28807f
C30 NQ clk 0.06599f
C31 2 3 0.37f
C32 rst clk 0.19966f
C33 a_n184_118# rst 0.01021f
C34 a_812_118# Q 0.03017f
C35 Q clk 0.03947f
C36 1 3 0.01278f
C37 2 post_NOR 0.63775f
C38 rst NQ 0.01411f
C39 1 D 0.3729f
C40 NQ Q 0.21689f
C41 vp a_812_118# 0.03861f
C42 2 1 0.6704f
C43 vp clk 1.44159f
C44 1 post_NOR 0.53655f
C45 a_n184_118# vp 0.03861f
C46 clk_n clk 1.99007f
C47 rst Q 0.26248f
C48 vp NQ 0.29121f
C49 NQ clk_n 0.05654f
C50 NQ gd 3.34273f
C51 D gd 0.12634f
C52 vp gd 3.01335f
C53 a_812_118# gd 1.45521f
C54 post_NOR gd 0.35824f
C55 a_n184_118# gd 0.51327f
C56 1 gd 20f
C57 3 gd 20f
C58 2 gd 20f
.ends
