* PEX produced on Sat Sep 26 10:33:42 PM CEST 2026 using /foss/tools/sak/sak-pex.sh with m=2 and s=1
* NGSPICE file created from vco_core_2.ext - technology: ihp-sg13cmos5l

.subckt vco_core_2 in out en11 nen11 en5 nen5 gnd vp
X0 a_7270_n448# in gnd gnd sg13_lv_nmos ad=0.272p pd=2.28u as=0.272p ps=2.28u w=0.8u l=6u
X1 a_4678_n1920# in gnd gnd sg13_lv_nmos ad=0.272p pd=2.28u as=0.272p ps=2.28u w=0.8u l=6u
X2 a_4678_292# vco_delay_cell_2$3_4.pgt vp vp sg13_lv_pmos ad=0.408p pd=3.08u as=0.408p ps=3.08u w=1.2u l=6u
X3 vco_delay_cell_2$3_3.out a_1618_n1956# a_1550_n1920# gnd sg13_lv_nmos ad=0.272p pd=2.28u as=0.272p ps=2.28u w=0.8u l=3u
X4 vco_delay_cell_2$3_3.out vco_delay_cell_2$3_5.out a_1550_n2740# vp sg13_lv_pmos ad=0.408p pd=3.08u as=0.408p ps=3.08u w=1.2u l=3u
X5 vco_delay_cell_2$3_4.in nen11 vco_delay_cell_2$3_7.out vp sg13_lv_pmos ad=0.1005p pd=1.34u as=0.1005p ps=1.34u w=0.15u l=0.13u
X6 a_7270_292# vco_delay_cell_2$3_4.pgt vp vp sg13_lv_pmos ad=0.408p pd=3.08u as=0.408p ps=3.08u w=1.2u l=6u
X7 a_6242_n1920# in gnd gnd sg13_lv_nmos ad=0.272p pd=2.28u as=0.272p ps=2.28u w=0.8u l=6u
X8 a_3114_n2740# vco_delay_cell_2$3_4.pgt vp vp sg13_lv_pmos ad=0.408p pd=3.08u as=0.408p ps=3.08u w=1.2u l=6u
X9 a_1550_292# vco_delay_cell_2$3_4.pgt vp vp sg13_lv_pmos ad=0.408p pd=3.08u as=0.408p ps=3.08u w=1.2u l=6u
X10 vco_delay_cell_2$3_4.out a_n1510_n1956# a_n1578_n1920# gnd sg13_lv_nmos ad=0.272p pd=2.28u as=0.272p ps=2.28u w=0.8u l=3u
X11 vco_delay_cell_2$3_4.out vco_delay_cell_2$3_4.in a_n1578_n2740# vp sg13_lv_pmos ad=0.408p pd=3.08u as=0.408p ps=3.08u w=1.2u l=3u
X12 vco_delay_cell_2$3_6.in nen11 vco_delay_cell_2$3_0.out vp sg13_lv_pmos ad=0.1005p pd=1.34u as=0.1005p ps=1.34u w=0.15u l=0.13u
X13 a_4678_n2740# vco_delay_cell_2$3_4.pgt vp vp sg13_lv_pmos ad=0.408p pd=3.08u as=0.408p ps=3.08u w=1.2u l=6u
X14 vco_delay_cell_2$3_4.in en11 vco_delay_cell_2$3_7.out gnd sg13_lv_nmos ad=0.1005p pd=1.34u as=0.1005p ps=1.34u w=0.15u l=0.13u
X15 vco_delay_cell_2$3_5.out a_54_n1956# a_n14_n1920# gnd sg13_lv_nmos ad=0.272p pd=2.28u as=0.272p ps=2.28u w=0.8u l=3u
X16 vco_delay_cell_2$3_6.in en11 vco_delay_cell_2$3_0.out gnd sg13_lv_nmos ad=0.1005p pd=1.34u as=0.1005p ps=1.34u w=0.15u l=0.13u
X17 vco_delay_cell_2$3_5.out vco_delay_cell_2$3_4.out a_n14_n2740# vp sg13_lv_pmos ad=0.408p pd=3.08u as=0.408p ps=3.08u w=1.2u l=3u
X18 vco_delay_cell_2$3_9.out a_1618_n484# a_1550_n448# gnd sg13_lv_nmos ad=0.272p pd=2.28u as=0.272p ps=2.28u w=0.8u l=3u
X19 a_1550_n1920# in gnd gnd sg13_lv_nmos ad=0.272p pd=2.28u as=0.272p ps=2.28u w=0.8u l=6u
X20 a_6242_n2740# vco_delay_cell_2$3_4.pgt vp vp sg13_lv_pmos ad=0.408p pd=3.08u as=0.408p ps=3.08u w=1.2u l=6u
X21 vco_delay_cell_2$3_6.in nen5 vco_delay_cell_2$3_7.out vp sg13_lv_pmos ad=0.1005p pd=1.34u as=0.1005p ps=1.34u w=0.15u l=0.13u
X22 vco_delay_cell_2$3_7.out a_4746_n484# a_4678_n448# gnd sg13_lv_nmos ad=0.272p pd=2.28u as=0.272p ps=2.28u w=0.8u l=3u
X23 a_1550_n448# in gnd gnd sg13_lv_nmos ad=0.272p pd=2.28u as=0.272p ps=2.28u w=0.8u l=6u
X24 vco_delay_cell_2$3_7.out vco_delay_cell_2$3_8.out a_4678_292# vp sg13_lv_pmos ad=0.408p pd=3.08u as=0.408p ps=3.08u w=1.2u l=3u
X25 vco_delay_cell_2$3_4.pgt in a_n1880_n788# gnd sg13_lv_nmos ad=0.272p pd=2.28u as=0.272p ps=2.28u w=0.8u l=6u
X26 a_n14_n1920# in gnd gnd sg13_lv_nmos ad=0.272p pd=2.28u as=0.272p ps=2.28u w=0.8u l=6u
X27 vco_delay_cell_2$3_6.in en5 vco_delay_cell_2$3_7.out gnd sg13_lv_nmos ad=0.1005p pd=1.34u as=0.1005p ps=1.34u w=0.15u l=0.13u
X28 a_4678_n448# in gnd gnd sg13_lv_nmos ad=0.272p pd=2.28u as=0.272p ps=2.28u w=0.8u l=6u
X29 a_n1578_n1920# in gnd gnd sg13_lv_nmos ad=0.272p pd=2.28u as=0.272p ps=2.28u w=0.8u l=6u
X30 out vco_delay_cell_2$3_6.in a_7270_292# vp sg13_lv_pmos ad=0.408p pd=3.08u as=0.408p ps=3.08u w=1.2u l=3u
X31 a_3114_n448# in gnd gnd sg13_lv_nmos ad=0.272p pd=2.28u as=0.272p ps=2.28u w=0.8u l=6u
X32 vco_delay_cell_2$3_2.out a_3182_n1956# a_3114_n1920# gnd sg13_lv_nmos ad=0.272p pd=2.28u as=0.272p ps=2.28u w=0.8u l=3u
X33 vco_delay_cell_2$3_2.out vco_delay_cell_2$3_3.out a_3114_n2740# vp sg13_lv_pmos ad=0.408p pd=3.08u as=0.408p ps=3.08u w=1.2u l=3u
X34 a_1550_n2740# vco_delay_cell_2$3_4.pgt vp vp sg13_lv_pmos ad=0.408p pd=3.08u as=0.408p ps=3.08u w=1.2u l=6u
X35 a_3114_292# vco_delay_cell_2$3_4.pgt vp vp sg13_lv_pmos ad=0.408p pd=3.08u as=0.408p ps=3.08u w=1.2u l=6u
X36 vco_delay_cell_2$3_9.out vco_delay_cell_2$3_10.out a_1550_292# vp sg13_lv_pmos ad=0.408p pd=3.08u as=0.408p ps=3.08u w=1.2u l=3u
X37 vco_delay_cell_2$3_0.out a_6310_n1956# a_6242_n1920# gnd sg13_lv_nmos ad=0.272p pd=2.28u as=0.272p ps=2.28u w=0.8u l=3u
X38 vco_delay_cell_2$3_0.out vco_delay_cell_2$3_1.out a_6242_n2740# vp sg13_lv_pmos ad=0.408p pd=3.08u as=0.408p ps=3.08u w=1.2u l=3u
X39 a_n14_n2740# vco_delay_cell_2$3_4.pgt vp vp sg13_lv_pmos ad=0.408p pd=3.08u as=0.408p ps=3.08u w=1.2u l=6u
X40 vco_delay_cell_2$3_4.pgt vco_delay_cell_2$3_4.pgt vp vp sg13_lv_pmos ad=0.408p pd=3.08u as=0.408p ps=3.08u w=1.2u l=6u
X41 vco_delay_cell_2$3_10.out a_54_n484# a_n14_n448# gnd sg13_lv_nmos ad=0.272p pd=2.28u as=0.272p ps=2.28u w=0.8u l=3u
X42 a_n1578_n2740# vco_delay_cell_2$3_4.pgt vp vp sg13_lv_pmos ad=0.408p pd=3.08u as=0.408p ps=3.08u w=1.2u l=6u
X43 vco_delay_cell_2$3_8.out vco_delay_cell_2$3_9.out a_3114_292# vp sg13_lv_pmos ad=0.408p pd=3.08u as=0.408p ps=3.08u w=1.2u l=3u
X44 vco_delay_cell_2$3_1.out a_4746_n1956# a_4678_n1920# gnd sg13_lv_nmos ad=0.272p pd=2.28u as=0.272p ps=2.28u w=0.8u l=3u
X45 vco_delay_cell_2$3_1.out vco_delay_cell_2$3_2.out a_4678_n2740# vp sg13_lv_pmos ad=0.408p pd=3.08u as=0.408p ps=3.08u w=1.2u l=3u
X46 vco_delay_cell_2$3_8.out a_3182_n484# a_3114_n448# gnd sg13_lv_nmos ad=0.272p pd=2.28u as=0.272p ps=2.28u w=0.8u l=3u
X47 a_n14_292# vco_delay_cell_2$3_4.pgt vp vp sg13_lv_pmos ad=0.408p pd=3.08u as=0.408p ps=3.08u w=1.2u l=6u
X48 a_n14_n448# in gnd gnd sg13_lv_nmos ad=0.272p pd=2.28u as=0.272p ps=2.28u w=0.8u l=6u
X49 out a_7338_n484# a_7270_n448# gnd sg13_lv_nmos ad=0.272p pd=2.28u as=0.272p ps=2.28u w=0.8u l=3u
X50 a_3114_n1920# in gnd gnd sg13_lv_nmos ad=0.272p pd=2.28u as=0.272p ps=2.28u w=0.8u l=6u
X51 vco_delay_cell_2$3_10.out vco_delay_cell_2$3_10.in a_n14_292# vp sg13_lv_pmos ad=0.408p pd=3.08u as=0.408p ps=3.08u w=1.2u l=3u
C0 vp vco_delay_cell_2$3_4.out 1.33476f
C1 a_1550_n1920# a_1550_n2740# 0.01756f
C2 a_1550_292# a_1550_n448# 0.01756f
C3 vco_delay_cell_2$3_4.pgt a_3114_292# 0.36367f
C4 vco_delay_cell_2$3_1.out a_6242_n2740# 0.2073f
C5 vco_delay_cell_2$3_2.out vp 1.33406f
C6 vco_delay_cell_2$3_6.in vp 0.141f
C7 vco_delay_cell_2$3_1.out a_4678_n1920# 0.03784f
C8 vco_delay_cell_2$3_10.out vco_delay_cell_2$3_9.out 0.28028f
C9 vco_delay_cell_2$3_8.out a_4746_n484# 0.27978f
C10 vp vco_delay_cell_2$3_4.pgt 18.1449f
C11 vco_delay_cell_2$3_2.out a_4678_n2740# 0.2073f
C12 a_3114_n448# vco_delay_cell_2$3_9.out 0.07474f
C13 a_4678_n448# vco_delay_cell_2$3_7.out 0.06078f
C14 vp in 0.10859f
C15 vp a_1550_n1920# 0.01292f
C16 vp a_3114_n1920# 0.01292f
C17 vco_delay_cell_2$3_4.pgt a_3182_n484# 0.03203f
C18 vco_delay_cell_2$3_1.out a_6242_n1920# 0.07619f
C19 vco_delay_cell_2$3_9.out a_1550_292# 0.03999f
C20 a_4678_n2740# vco_delay_cell_2$3_4.pgt 0.36395f
C21 vco_delay_cell_2$3_4.in a_n1510_n1956# 0.30492f
C22 a_n14_n2740# vco_delay_cell_2$3_4.out 0.2073f
C23 vp vco_delay_cell_2$3_10.in 1.10258f
C24 a_3114_n448# vco_delay_cell_2$3_8.out 0.03561f
C25 a_3182_n484# in 0.18244f
C26 vp vco_delay_cell_2$3_10.out 1.33456f
C27 vco_delay_cell_2$3_6.in vco_delay_cell_2$3_7.out 0.62154f
C28 vp a_n14_292# 0.3309f
C29 vco_delay_cell_2$3_4.in a_n14_n448# 0.12442f
C30 vp out 0.1283f
C31 vp a_3114_n448# 0.01292f
C32 vco_delay_cell_2$3_4.pgt vco_delay_cell_2$3_7.out 0.12251f
C33 a_54_n484# vco_delay_cell_2$3_4.pgt 0.03016f
C34 vp a_3114_n2740# 0.33867f
C35 vco_delay_cell_2$3_4.pgt a_1618_n484# 0.03217f
C36 vco_delay_cell_2$3_9.out a_3114_292# 0.2073f
C37 vp nen5 0.16097f
C38 vp a_n14_n1920# 0.01292f
C39 vco_delay_cell_2$3_7.out in 0.02433f
C40 vp a_1550_292# 0.33867f
C41 a_54_n484# in 0.18244f
C42 in a_1618_n484# 0.18244f
C43 vp nen11 0.16237f
C44 a_n14_n2740# vco_delay_cell_2$3_4.pgt 0.3623f
C45 vco_delay_cell_2$3_6.in a_7270_292# 0.20413f
C46 vco_delay_cell_2$3_4.pgt a_6310_n1956# 0.03011f
C47 a_7270_n448# a_7270_292# 0.01756f
C48 vco_delay_cell_2$3_0.out a_6242_n2740# 0.03984f
C49 a_1550_n448# a_1618_n484# 0.12018f
C50 vco_delay_cell_2$3_8.out a_3114_292# 0.03999f
C51 vco_delay_cell_2$3_4.pgt a_7270_292# 0.32484f
C52 a_6310_n1956# in 0.20023f
C53 vco_delay_cell_2$3_4.in a_4746_n484# 0.03959f
C54 a_4746_n1956# a_4678_n1920# 0.12018f
C55 vp a_3114_292# 0.33867f
C56 vco_delay_cell_2$3_4.in a_n1578_n1920# 0.09308f
C57 vco_delay_cell_2$3_4.pgt vco_delay_cell_2$3_4.out 0.50533f
C58 vco_delay_cell_2$3_4.pgt a_4678_n448# 0.01635f
C59 vco_delay_cell_2$3_9.out a_3182_n484# 0.27978f
C60 vco_delay_cell_2$3_4.out a_54_n1956# 0.27978f
C61 a_n1880_n788# in 0.03255f
C62 vco_delay_cell_2$3_4.in vco_delay_cell_2$3_10.in 0.09815f
C63 vco_delay_cell_2$3_4.out in 0.13368f
C64 vco_delay_cell_2$3_4.in vco_delay_cell_2$3_10.out 0.19249f
C65 vco_delay_cell_2$3_2.out vco_delay_cell_2$3_4.pgt 0.55139f
C66 a_4678_n448# in 0.34304f
C67 vco_delay_cell_2$3_6.in a_7338_n484# 0.34201f
C68 vco_delay_cell_2$3_6.in a_7270_n448# 0.16085f
C69 a_7270_n448# a_7338_n484# 0.12018f
C70 vco_delay_cell_2$3_4.in a_3114_n448# 0.12451f
C71 a_n1578_n1920# a_n1510_n1956# 0.12018f
C72 a_n14_n2740# a_n14_n1920# 0.01756f
C73 vco_delay_cell_2$3_2.out in 0.13368f
C74 vco_delay_cell_2$3_6.in vco_delay_cell_2$3_4.pgt 0.48541f
C75 vco_delay_cell_2$3_0.out a_6242_n1920# 0.03777f
C76 vco_delay_cell_2$3_2.out a_3114_n1920# 0.03784f
C77 a_3182_n484# vco_delay_cell_2$3_8.out 0.05133f
C78 vco_delay_cell_2$3_9.out a_1618_n484# 0.05133f
C79 vco_delay_cell_2$3_6.in in 0.38585f
C80 vp a_6242_n2740# 0.31763f
C81 vco_delay_cell_2$3_10.in a_n14_n448# 0.06587f
C82 a_7338_n484# in 0.18333f
C83 a_7270_n448# in 0.33803f
C84 vco_delay_cell_2$3_10.out a_n14_n448# 0.03561f
C85 vco_delay_cell_2$3_4.pgt a_54_n1956# 0.02968f
C86 vco_delay_cell_2$3_4.in a_n1578_n2740# 0.1944f
C87 a_n14_292# a_n14_n448# 0.01756f
C88 vco_delay_cell_2$3_4.pgt in 2.44895f
C89 a_1550_n1920# vco_delay_cell_2$3_4.pgt 0.02701f
C90 a_54_n1956# in 0.20023f
C91 vco_delay_cell_2$3_4.out a_n14_n1920# 0.07619f
C92 a_3114_n1920# vco_delay_cell_2$3_4.pgt 0.02693f
C93 vco_delay_cell_2$3_8.out vco_delay_cell_2$3_7.out 0.27631f
C94 vco_delay_cell_2$3_1.out a_4746_n1956# 0.05133f
C95 vp a_4678_n1920# 0.01292f
C96 vco_delay_cell_2$3_2.out a_3114_n2740# 0.03999f
C97 vco_delay_cell_2$3_4.pgt a_1550_n448# 0.0163f
C98 a_1550_n1920# in 0.35402f
C99 vp vco_delay_cell_2$3_7.out 0.47974f
C100 a_3114_n1920# in 0.35402f
C101 vco_delay_cell_2$3_1.out vco_delay_cell_2$3_0.out 0.26277f
C102 a_1550_n448# in 0.34485f
C103 a_4678_n2740# a_4678_n1920# 0.01756f
C104 vco_delay_cell_2$3_4.pgt a_3114_n2740# 0.36371f
C105 a_4678_n448# en11 0.02071f
C106 vp a_6242_n1920# 0.01292f
C107 vco_delay_cell_2$3_4.pgt a_n14_n1920# 0.02588f
C108 a_4678_292# vco_delay_cell_2$3_7.out 0.03984f
C109 a_54_n1956# a_n14_n1920# 0.12018f
C110 vco_delay_cell_2$3_3.out vco_delay_cell_2$3_5.out 0.28028f
C111 vco_delay_cell_2$3_4.in vp 1.1264f
C112 in a_n14_n1920# 0.35402f
C113 vp a_7270_292# 0.28733f
C114 a_3114_n1920# a_3114_n2740# 0.01756f
C115 a_4678_n448# vco_delay_cell_2$3_8.out 0.07474f
C116 vco_delay_cell_2$3_10.in vco_delay_cell_2$3_10.out 0.24883f
C117 vco_delay_cell_2$3_10.in a_n14_292# 0.19393f
C118 vco_delay_cell_2$3_10.out a_n14_292# 0.03999f
C119 vco_delay_cell_2$3_4.pgt vco_delay_cell_2$3_9.out 0.54484f
C120 vco_delay_cell_2$3_4.in a_3182_n484# 0.03802f
C121 vp nen11 0.16536f
C122 vp a_4678_n448# 0.01292f
C123 vco_delay_cell_2$3_3.out a_3182_n1956# 0.27978f
C124 vco_delay_cell_2$3_1.out vp 1.33525f
C125 vco_delay_cell_2$3_3.out a_1618_n1956# 0.05133f
C126 a_n1578_n2740# a_n1578_n1920# 0.01756f
C127 a_1618_n1956# vco_delay_cell_2$3_5.out 0.27978f
C128 vco_delay_cell_2$3_4.in vco_delay_cell_2$3_7.out 0.98541f
C129 vco_delay_cell_2$3_6.in vp 1.34331f
C130 vco_delay_cell_2$3_10.out a_1550_292# 0.2073f
C131 vco_delay_cell_2$3_4.pgt vco_delay_cell_2$3_8.out 0.55f
C132 vco_delay_cell_2$3_3.out a_1550_n2740# 0.03999f
C133 vco_delay_cell_2$3_9.out a_1550_n448# 0.03561f
C134 a_4678_n448# a_4678_292# 0.01756f
C135 vp a_7270_n448# 0.01292f
C136 vco_delay_cell_2$3_5.out a_1550_n2740# 0.2073f
C137 vco_delay_cell_2$3_4.in a_54_n484# 0.03802f
C138 vco_delay_cell_2$3_4.in a_1618_n484# 0.03802f
C139 vco_delay_cell_2$3_1.out a_4678_n2740# 0.03999f
C140 vp vco_delay_cell_2$3_4.pgt 18.9063f
C141 a_6310_n1956# a_6242_n1920# 0.12018f
C142 vp in 0.13465f
C143 vco_delay_cell_2$3_2.out a_4678_n1920# 0.07619f
C144 vco_delay_cell_2$3_4.pgt a_6242_n2740# 0.36009f
C145 nen11 nen5 0.04467f
C146 a_54_n484# a_n14_n448# 0.12018f
C147 vco_delay_cell_2$3_4.pgt a_4678_292# 0.36306f
C148 a_3114_n448# a_3114_292# 0.01756f
C149 vp a_1550_n448# 0.01292f
C150 vp a_n1578_n1920# 0.01292f
C151 vco_delay_cell_2$3_4.pgt a_4678_n1920# 0.0271f
C152 vco_delay_cell_2$3_3.out vp 1.33406f
C153 vp vco_delay_cell_2$3_5.out 1.33406f
C154 vco_delay_cell_2$3_1.out a_6310_n1956# 0.27978f
C155 vco_delay_cell_2$3_4.in vco_delay_cell_2$3_4.out 0.27538f
C156 vco_delay_cell_2$3_4.in a_4678_n448# 0.12125f
C157 a_4678_n1920# in 0.35402f
C158 vco_delay_cell_2$3_4.out a_n1510_n1956# 0.05133f
C159 vco_delay_cell_2$3_4.pgt a_6242_n1920# 0.02538f
C160 vco_delay_cell_2$3_7.out a_4746_n484# 0.05268f
C161 vco_delay_cell_2$3_4.in vco_delay_cell_2$3_6.in 0.01048f
C162 en5 in 0.01266f
C163 vco_delay_cell_2$3_9.out vco_delay_cell_2$3_8.out 0.28028f
C164 a_3114_n448# a_3182_n484# 0.12018f
C165 a_6242_n1920# in 0.35244f
C166 vco_delay_cell_2$3_4.in vco_delay_cell_2$3_4.pgt 0.94548f
C167 vp vco_delay_cell_2$3_0.out 0.41986f
C168 vp a_n1578_n2740# 0.33941f
C169 vco_delay_cell_2$3_2.out vco_delay_cell_2$3_1.out 0.28028f
C170 vp vco_delay_cell_2$3_9.out 1.33408f
C171 vp a_1550_n2740# 0.33867f
C172 vco_delay_cell_2$3_4.in in 2.76824f
C173 vco_delay_cell_2$3_10.in a_54_n484# 0.27652f
C174 a_54_n484# vco_delay_cell_2$3_10.out 0.05133f
C175 vco_delay_cell_2$3_10.out a_1618_n484# 0.27978f
C176 a_n14_n2740# vco_delay_cell_2$3_5.out 0.03999f
C177 vco_delay_cell_2$3_1.out vco_delay_cell_2$3_4.pgt 0.54198f
C178 vco_delay_cell_2$3_4.in a_1550_n448# 0.12451f
C179 vco_delay_cell_2$3_4.pgt a_n14_n448# 0.03865f
C180 vp vco_delay_cell_2$3_8.out 1.32899f
C181 in a_n1510_n1956# 0.20023f
C182 vco_delay_cell_2$3_1.out in 0.13368f
C183 a_n14_n448# in 0.34485f
C184 a_4678_n448# a_4746_n484# 0.12018f
C185 a_n1578_n1920# vco_delay_cell_2$3_4.out 0.03784f
C186 a_7270_292# out 0.03789f
C187 vco_delay_cell_2$3_8.out a_4678_292# 0.2073f
C188 vco_delay_cell_2$3_4.out vco_delay_cell_2$3_5.out 0.28028f
C189 en5 en11 0.04309f
C190 vp a_4678_292# 0.32674f
C191 vco_delay_cell_2$3_2.out vco_delay_cell_2$3_3.out 0.28028f
C192 vco_delay_cell_2$3_0.out a_6310_n1956# 0.05157f
C193 vco_delay_cell_2$3_4.pgt a_4746_n484# 0.03224f
C194 vco_delay_cell_2$3_4.in vco_delay_cell_2$3_9.out 0.19249f
C195 vp a_4678_n2740# 0.33867f
C196 vco_delay_cell_2$3_4.in en11 0.01085f
C197 in a_4746_n484# 0.18244f
C198 vco_delay_cell_2$3_3.out vco_delay_cell_2$3_4.pgt 0.54651f
C199 vco_delay_cell_2$3_4.pgt vco_delay_cell_2$3_5.out 0.56401f
C200 vco_delay_cell_2$3_2.out a_3182_n1956# 0.05133f
C201 vco_delay_cell_2$3_6.in out 0.27654f
C202 a_7338_n484# out 0.05015f
C203 a_n1578_n2740# vco_delay_cell_2$3_4.out 0.03999f
C204 vco_delay_cell_2$3_2.out a_4746_n1956# 0.27978f
C205 a_7270_n448# out 0.03407f
C206 a_54_n1956# vco_delay_cell_2$3_5.out 0.05133f
C207 vco_delay_cell_2$3_10.in vco_delay_cell_2$3_4.pgt 0.47403f
C208 a_n1578_n1920# in 0.35402f
C209 vco_delay_cell_2$3_10.out vco_delay_cell_2$3_4.pgt 0.56283f
C210 vco_delay_cell_2$3_4.pgt a_n14_292# 0.39403f
C211 vco_delay_cell_2$3_3.out in 0.13368f
C212 vco_delay_cell_2$3_5.out in 0.13368f
C213 vco_delay_cell_2$3_4.pgt out 0.01023f
C214 vco_delay_cell_2$3_4.in vco_delay_cell_2$3_8.out 0.19265f
C215 vco_delay_cell_2$3_3.out a_1550_n1920# 0.03784f
C216 a_1550_n1920# vco_delay_cell_2$3_5.out 0.07619f
C217 vco_delay_cell_2$3_4.pgt a_3114_n448# 0.01615f
C218 vco_delay_cell_2$3_3.out a_3114_n1920# 0.07619f
C219 vco_delay_cell_2$3_4.in vp 0.13782f
C220 a_3182_n1956# vco_delay_cell_2$3_4.pgt 0.03217f
C221 a_6242_n1920# a_6242_n2740# 0.01756f
C222 vp a_n14_n2740# 0.33867f
C223 a_4746_n1956# vco_delay_cell_2$3_4.pgt 0.03231f
C224 a_3114_n448# in 0.34485f
C225 vco_delay_cell_2$3_6.in vco_delay_cell_2$3_0.out 0.44722f
C226 a_3182_n1956# in 0.20023f
C227 vco_delay_cell_2$3_10.out a_1550_n448# 0.07474f
C228 vco_delay_cell_2$3_4.pgt a_1618_n1956# 0.03232f
C229 vco_delay_cell_2$3_4.pgt a_1550_292# 0.3638f
C230 vco_delay_cell_2$3_4.pgt vco_delay_cell_2$3_0.out 0.0632f
C231 a_n1578_n2740# vco_delay_cell_2$3_4.pgt 0.34074f
C232 a_4746_n1956# in 0.20023f
C233 a_3182_n1956# a_3114_n1920# 0.12018f
C234 vco_delay_cell_2$3_3.out a_3114_n2740# 0.2073f
C235 vco_delay_cell_2$3_4.pgt a_1550_n2740# 0.36384f
C236 a_1618_n1956# in 0.20023f
C237 vco_delay_cell_2$3_0.out in 0.06968f
C238 vp a_n14_n448# 0.01292f
C239 a_1550_n1920# a_1618_n1956# 0.12018f
C240 vco_delay_cell_2$3_5.out a_n14_n1920# 0.03784f
C241 out gnd 1.2727f
C242 vp gnd 1.0875f
C243 vp gnd 4.48361f
C244 a_6242_n2740# gnd 0.31089f
C245 a_4678_n2740# gnd 0.68072f
C246 a_3114_n2740# gnd 0.55253f
C247 a_1550_n2740# gnd 0.29616f
C248 a_n14_n2740# gnd 0.79895f
C249 a_n1578_n2740# gnd 0.77271f
C250 vco_delay_cell_2$3_0.out gnd 1.02029f
C251 vco_delay_cell_2$3_1.out gnd 0.89731f
C252 vco_delay_cell_2$3_5.out gnd 1.01554f
C253 a_6242_n1920# gnd 0.47631f
C254 a_4678_n1920# gnd 0.47911f
C255 a_3114_n1920# gnd 0.47911f
C256 a_1550_n1920# gnd 0.47882f
C257 a_n14_n1920# gnd 0.47911f
C258 a_n1578_n1920# gnd 0.49215f
C259 a_n1880_n788# gnd 0.04468f
C260 a_7270_n448# gnd 14.81407f
C261 a_4678_n448# gnd 0.44843f
C262 a_3114_n448# gnd 0.47911f
C263 a_1550_n448# gnd 0.47882f
C264 a_n14_n448# gnd 0.47426f
C265 vco_delay_cell_2$3_4.in gnd 0.07697f
C266 vco_delay_cell_2$3_7.out gnd 1.16763f
C267 vco_delay_cell_2$3_8.out gnd 0.76751f
C268 vco_delay_cell_2$3_10.out gnd 0.4285f
C269 a_7270_292# gnd 0.89454f
C270 a_4678_292# gnd 3.65135f
C271 a_3114_292# gnd 0.55092f
C272 a_1550_292# gnd 0.30542f
C273 a_n14_292# gnd 0.21131f
.ends
