* PEX produced on Sun Sep 27 03:38:57 PM CEST 2026 using /foss/tools/sak/sak-pex.sh with m=2 and s=1
* NGSPICE file created from vco_core_2.ext - technology: ihp-sg13cmos5l

.subckt vco_core_2 out in vp en11 nen11 en5 nen5 gnd
X0 a_4678_n1920# in gnd gnd sg13_lv_nmos ad=0.272p pd=2.28u as=0.272p ps=2.28u w=0.8u l=6u
X1 vco_delay_cell_2$4_3.out vco_delay_cell_2$4_5.out a_1550_n1920# gnd sg13_lv_nmos ad=0.272p pd=2.28u as=0.272p ps=2.28u w=0.8u l=3u
X2 a_4678_n2666# vco_delay_cell_2$4_4.pgt vp vp sg13_lv_pmos ad=0.408p pd=3.08u as=0.408p ps=3.08u w=1.2u l=6u
X3 a_4678_218# vco_delay_cell_2$4_4.pgt vp vp sg13_lv_pmos ad=0.408p pd=3.08u as=0.408p ps=3.08u w=1.2u l=6u
X4 vco_delay_cell_2$4_4.in nen11 vco_delay_cell_2$4_7.out vp sg13_lv_pmos ad=0.1005p pd=1.34u as=0.1005p ps=1.34u w=0.15u l=0.13u
X5 vco_delay_cell_2$4_3.out vco_delay_cell_2$4_5.out a_1550_n2666# vp sg13_lv_pmos ad=0.408p pd=3.08u as=0.408p ps=3.08u w=1.2u l=3u
X6 vco_delay_cell_2$4_9.out vco_delay_cell_2$4_10.out a_1550_218# vp sg13_lv_pmos ad=0.408p pd=3.08u as=0.408p ps=3.08u w=1.2u l=3u
X7 a_6242_n1920# in gnd gnd sg13_lv_nmos ad=0.272p pd=2.28u as=0.272p ps=2.28u w=0.8u l=6u
X8 a_6242_n2666# vco_delay_cell_2$4_4.pgt vp vp sg13_lv_pmos ad=0.408p pd=3.08u as=0.408p ps=3.08u w=1.2u l=6u
X9 a_1550_218# vco_delay_cell_2$4_4.pgt vp vp sg13_lv_pmos ad=0.408p pd=3.08u as=0.408p ps=3.08u w=1.2u l=6u
X10 vco_delay_cell_2$4_8.out vco_delay_cell_2$4_9.out a_3114_218# vp sg13_lv_pmos ad=0.408p pd=3.08u as=0.408p ps=3.08u w=1.2u l=3u
X11 a_n1510_n1920# in gnd gnd sg13_lv_nmos ad=0.272p pd=2.28u as=0.272p ps=2.28u w=0.8u l=6u
X12 vco_delay_cell_2$4_4.in en11 vco_delay_cell_2$4_7.out gnd sg13_lv_nmos ad=0.1005p pd=1.34u as=0.1005p ps=1.34u w=0.15u l=0.13u
X13 vco_delay_cell_2$4_5.out vco_delay_cell_2$4_4.out a_n14_n1920# gnd sg13_lv_nmos ad=0.272p pd=2.28u as=0.272p ps=2.28u w=0.8u l=3u
X14 vco_delay_cell_2$4_5.out vco_delay_cell_2$4_4.out a_n14_n2666# vp sg13_lv_pmos ad=0.408p pd=3.08u as=0.408p ps=3.08u w=1.2u l=3u
X15 a_n1510_n2666# vco_delay_cell_2$4_4.pgt vp vp sg13_lv_pmos ad=0.408p pd=3.08u as=0.408p ps=3.08u w=1.2u l=6u
X16 vco_delay_cell_2$4_9.out vco_delay_cell_2$4_10.out a_1550_n448# gnd sg13_lv_nmos ad=0.272p pd=2.28u as=0.272p ps=2.28u w=0.8u l=3u
X17 a_1550_n1920# in gnd gnd sg13_lv_nmos ad=0.272p pd=2.28u as=0.272p ps=2.28u w=0.8u l=6u
X18 vco_delay_cell_2$4_6.in nen11 vco_delay_cell_2$4_0.out vp sg13_lv_pmos ad=0.1005p pd=1.34u as=0.1005p ps=1.34u w=0.15u l=0.13u
X19 a_1550_n2666# vco_delay_cell_2$4_4.pgt vp vp sg13_lv_pmos ad=0.408p pd=3.08u as=0.408p ps=3.08u w=1.2u l=6u
X20 vco_delay_cell_2$4_6.in nen5 vco_delay_cell_2$4_7.out vp sg13_lv_pmos ad=0.1005p pd=1.34u as=0.1005p ps=1.34u w=0.15u l=0.13u
X21 vco_delay_cell_2$4_6.in en11 vco_delay_cell_2$4_0.out gnd sg13_lv_nmos ad=0.1005p pd=1.34u as=0.1005p ps=1.34u w=0.15u l=0.13u
X22 vco_delay_cell_2$4_10.out out a_n14_218# vp sg13_lv_pmos ad=0.408p pd=3.08u as=0.408p ps=3.08u w=1.2u l=3u
X23 vco_delay_cell_2$4_7.out vco_delay_cell_2$4_8.out a_4678_n448# gnd sg13_lv_nmos ad=0.272p pd=2.28u as=0.272p ps=2.28u w=0.8u l=3u
X24 a_1550_n448# in gnd gnd sg13_lv_nmos ad=0.272p pd=2.28u as=0.272p ps=2.28u w=0.8u l=6u
X25 vco_delay_cell_2$4_4.pgt in a_n1880_n788# gnd sg13_lv_nmos ad=0.272p pd=2.28u as=0.272p ps=2.28u w=0.8u l=6u
X26 a_n14_n1920# in gnd gnd sg13_lv_nmos ad=0.272p pd=2.28u as=0.272p ps=2.28u w=0.8u l=6u
X27 vco_delay_cell_2$4_6.in en5 vco_delay_cell_2$4_7.out gnd sg13_lv_nmos ad=0.1005p pd=1.34u as=0.1005p ps=1.34u w=0.15u l=0.13u
X28 a_n14_n2666# vco_delay_cell_2$4_4.pgt vp vp sg13_lv_pmos ad=0.408p pd=3.08u as=0.408p ps=3.08u w=1.2u l=6u
X29 out vco_delay_cell_2$4_6.in a_6922_218# vp sg13_lv_pmos ad=0.408p pd=3.08u as=0.408p ps=3.08u w=1.2u l=3u
X30 a_4678_n448# in gnd gnd sg13_lv_nmos ad=0.272p pd=2.28u as=0.272p ps=2.28u w=0.8u l=6u
X31 a_3114_n448# in gnd gnd sg13_lv_nmos ad=0.272p pd=2.28u as=0.272p ps=2.28u w=0.8u l=6u
X32 vco_delay_cell_2$4_2.out vco_delay_cell_2$4_3.out a_3114_n1920# gnd sg13_lv_nmos ad=0.272p pd=2.28u as=0.272p ps=2.28u w=0.8u l=3u
X33 vco_delay_cell_2$4_2.out vco_delay_cell_2$4_3.out a_3114_n2666# vp sg13_lv_pmos ad=0.408p pd=3.08u as=0.408p ps=3.08u w=1.2u l=3u
X34 a_3114_218# vco_delay_cell_2$4_4.pgt vp vp sg13_lv_pmos ad=0.408p pd=3.08u as=0.408p ps=3.08u w=1.2u l=6u
X35 a_6922_n448# in gnd gnd sg13_lv_nmos ad=0.272p pd=2.28u as=0.272p ps=2.28u w=0.8u l=6u
X36 vco_delay_cell_2$4_0.out vco_delay_cell_2$4_1.out a_6242_n1920# gnd sg13_lv_nmos ad=0.272p pd=2.28u as=0.272p ps=2.28u w=0.8u l=3u
X37 vco_delay_cell_2$4_0.out vco_delay_cell_2$4_1.out a_6242_n2666# vp sg13_lv_pmos ad=0.408p pd=3.08u as=0.408p ps=3.08u w=1.2u l=3u
X38 a_6922_218# vco_delay_cell_2$4_4.pgt vp vp sg13_lv_pmos ad=0.408p pd=3.08u as=0.408p ps=3.08u w=1.2u l=6u
X39 vco_delay_cell_2$4_4.pgt vco_delay_cell_2$4_4.pgt vp vp sg13_lv_pmos ad=0.408p pd=3.08u as=0.408p ps=3.08u w=1.2u l=6u
X40 vco_delay_cell_2$4_10.out out a_n14_n448# gnd sg13_lv_nmos ad=0.272p pd=2.28u as=0.272p ps=2.28u w=0.8u l=3u
X41 vco_delay_cell_2$4_4.out vco_delay_cell_2$4_4.in a_n1510_n1920# gnd sg13_lv_nmos ad=0.272p pd=2.28u as=0.272p ps=2.28u w=0.8u l=3u
X42 vco_delay_cell_2$4_1.out vco_delay_cell_2$4_2.out a_4678_n1920# gnd sg13_lv_nmos ad=0.272p pd=2.28u as=0.272p ps=2.28u w=0.8u l=3u
X43 vco_delay_cell_2$4_8.out vco_delay_cell_2$4_9.out a_3114_n448# gnd sg13_lv_nmos ad=0.272p pd=2.28u as=0.272p ps=2.28u w=0.8u l=3u
X44 out vco_delay_cell_2$4_6.in a_6922_n448# gnd sg13_lv_nmos ad=0.272p pd=2.28u as=0.272p ps=2.28u w=0.8u l=3u
X45 vco_delay_cell_2$4_4.out vco_delay_cell_2$4_4.in a_n1510_n2666# vp sg13_lv_pmos ad=0.408p pd=3.08u as=0.408p ps=3.08u w=1.2u l=3u
X46 vco_delay_cell_2$4_1.out vco_delay_cell_2$4_2.out a_4678_n2666# vp sg13_lv_pmos ad=0.408p pd=3.08u as=0.408p ps=3.08u w=1.2u l=3u
X47 a_n14_n448# in gnd gnd sg13_lv_nmos ad=0.272p pd=2.28u as=0.272p ps=2.28u w=0.8u l=6u
X48 a_n14_218# vco_delay_cell_2$4_4.pgt vp vp sg13_lv_pmos ad=0.408p pd=3.08u as=0.408p ps=3.08u w=1.2u l=6u
X49 a_3114_n1920# in gnd gnd sg13_lv_nmos ad=0.272p pd=2.28u as=0.272p ps=2.28u w=0.8u l=6u
X50 vco_delay_cell_2$4_7.out vco_delay_cell_2$4_8.out a_4678_218# vp sg13_lv_pmos ad=0.408p pd=3.08u as=0.408p ps=3.08u w=1.2u l=3u
X51 a_3114_n2666# vco_delay_cell_2$4_4.pgt vp vp sg13_lv_pmos ad=0.408p pd=3.08u as=0.408p ps=3.08u w=1.2u l=6u
C0 a_1550_218# vp 0.33867f
C1 a_1550_218# vco_delay_cell_2$4_9.out 0.03776f
C2 vco_delay_cell_2$4_7.out a_4678_n448# 0.06097f
C3 a_3114_n448# vco_delay_cell_2$4_4.in 0.12451f
C4 vco_delay_cell_2$4_0.out in 0.04742f
C5 vco_delay_cell_2$4_4.pgt a_1550_n1920# 0.02629f
C6 vco_delay_cell_2$4_6.in vco_delay_cell_2$4_0.out 0.45466f
C7 vco_delay_cell_2$4_6.in in 0.59738f
C8 vp a_3114_n1920# 0.01559f
C9 a_n14_n448# in 0.34485f
C10 vco_delay_cell_2$4_10.out in 0.18541f
C11 vco_delay_cell_2$4_5.out in 0.34789f
C12 a_n14_n448# vco_delay_cell_2$4_10.out 0.03583f
C13 vco_delay_cell_2$4_4.out a_n1510_n2666# 0.04001f
C14 vco_delay_cell_2$4_4.pgt a_4678_n448# 0.01563f
C15 vp vco_delay_cell_2$4_0.out 0.30839f
C16 a_n14_218# out 0.31551f
C17 vp in 0.12843f
C18 vco_delay_cell_2$4_4.pgt a_n14_n1920# 0.02515f
C19 vco_delay_cell_2$4_7.out vco_delay_cell_2$4_4.in 0.9967f
C20 vp vco_delay_cell_2$4_6.in 0.14424f
C21 vp in 0.15896f
C22 vco_delay_cell_2$4_9.out in 0.18541f
C23 vp vco_delay_cell_2$4_5.out 1.33676f
C24 vco_delay_cell_2$4_6.in vp 1.26108f
C25 out vco_delay_cell_2$4_7.out 0.12546f
C26 a_n14_n448# vp 0.01559f
C27 vco_delay_cell_2$4_10.out vp 1.28891f
C28 vco_delay_cell_2$4_10.out vco_delay_cell_2$4_9.out 0.33263f
C29 vco_delay_cell_2$4_4.pgt vco_delay_cell_2$4_4.in 0.93144f
C30 a_3114_n2666# vco_delay_cell_2$4_3.out 0.20769f
C31 vp nen11 0.15972f
C32 nen11 vp 0.15936f
C33 in vco_delay_cell_2$4_8.out 0.1854f
C34 vco_delay_cell_2$4_1.out vco_delay_cell_2$4_4.pgt 0.56834f
C35 vco_delay_cell_2$4_4.pgt out 2.79513f
C36 vco_delay_cell_2$4_9.out vp 1.31121f
C37 vco_delay_cell_2$4_4.pgt vco_delay_cell_2$4_3.out 0.57489f
C38 a_4678_218# vco_delay_cell_2$4_7.out 0.03867f
C39 vco_delay_cell_2$4_1.out a_4678_n2666# 0.04001f
C40 a_3114_n2666# vco_delay_cell_2$4_2.out 0.04001f
C41 out a_3114_218# 0.13218f
C42 vco_delay_cell_2$4_4.pgt a_4678_n1920# 0.02638f
C43 vco_delay_cell_2$4_4.pgt vco_delay_cell_2$4_2.out 0.57965f
C44 vp vco_delay_cell_2$4_8.out 1.30614f
C45 vco_delay_cell_2$4_9.out vco_delay_cell_2$4_8.out 0.33263f
C46 a_4678_218# vco_delay_cell_2$4_4.pgt 0.34585f
C47 a_6922_218# vco_delay_cell_2$4_4.pgt 0.32274f
C48 a_4678_n2666# a_4678_n1920# 0.01895f
C49 a_4678_n2666# vco_delay_cell_2$4_2.out 0.20769f
C50 vco_delay_cell_2$4_1.out a_6242_n2666# 0.20769f
C51 a_1550_n1920# in 0.35402f
C52 vco_delay_cell_2$4_1.out a_6242_n1920# 0.21377f
C53 a_n14_n2666# vco_delay_cell_2$4_4.pgt 0.3623f
C54 a_1550_n2666# vco_delay_cell_2$4_4.pgt 0.36384f
C55 vco_delay_cell_2$4_5.out a_1550_n1920# 0.21377f
C56 en11 a_4678_n448# 0.02071f
C57 vco_delay_cell_2$4_4.pgt vco_delay_cell_2$4_4.out 0.52907f
C58 in a_4678_n448# 0.34304f
C59 vp a_1550_n1920# 0.01559f
C60 a_n1510_n1920# in 0.35458f
C61 a_1550_218# out 0.13261f
C62 in a_n14_n1920# 0.35402f
C63 vco_delay_cell_2$4_4.pgt a_n1510_n2666# 0.34058f
C64 vco_delay_cell_2$4_5.out a_n14_n1920# 0.0384f
C65 vp a_n1510_n1920# 0.01559f
C66 vp a_n14_n1920# 0.01559f
C67 en11 vco_delay_cell_2$4_4.in 0.01085f
C68 vp a_4678_n448# 0.01559f
C69 vco_delay_cell_2$4_4.in in 2.97698f
C70 vco_delay_cell_2$4_3.out a_3114_n1920# 0.21377f
C71 vco_delay_cell_2$4_6.in vco_delay_cell_2$4_4.in 0.01729f
C72 vco_delay_cell_2$4_1.out vco_delay_cell_2$4_0.out 0.3305f
C73 a_n14_n448# vco_delay_cell_2$4_4.in 0.12442f
C74 vco_delay_cell_2$4_10.out vco_delay_cell_2$4_4.in 0.26016f
C75 vco_delay_cell_2$4_1.out in 0.34789f
C76 out in 0.19107f
C77 vco_delay_cell_2$4_4.pgt a_1550_n448# 0.01557f
C78 nen11 nen5 0.04467f
C79 vco_delay_cell_2$4_3.out in 0.34789f
C80 vco_delay_cell_2$4_6.in out 0.51287f
C81 a_n14_n448# out 0.20304f
C82 vp vco_delay_cell_2$4_4.in 1.12658f
C83 nen5 vp 0.16226f
C84 vco_delay_cell_2$4_10.out out 0.58373f
C85 en5 en11 0.04309f
C86 vco_delay_cell_2$4_2.out a_3114_n1920# 0.0384f
C87 en5 in 0.01295f
C88 a_4678_n448# vco_delay_cell_2$4_8.out 0.21187f
C89 vco_delay_cell_2$4_5.out vco_delay_cell_2$4_3.out 0.33262f
C90 vp vco_delay_cell_2$4_4.in 0.14742f
C91 vco_delay_cell_2$4_1.out vp 1.3292f
C92 vco_delay_cell_2$4_9.out vco_delay_cell_2$4_4.in 0.26017f
C93 a_6922_n448# in 0.33668f
C94 in a_4678_n1920# 0.35402f
C95 vco_delay_cell_2$4_4.pgt a_3114_n448# 0.01542f
C96 vp vco_delay_cell_2$4_3.out 1.33743f
C97 nen11 out 0.03141f
C98 vco_delay_cell_2$4_2.out in 0.34789f
C99 a_6922_n448# vco_delay_cell_2$4_6.in 0.30287f
C100 out vp 2.0745f
C101 out vco_delay_cell_2$4_9.out 0.22822f
C102 a_n14_218# vco_delay_cell_2$4_4.pgt 0.38074f
C103 vco_delay_cell_2$4_6.in a_6922_218# 0.21608f
C104 a_3114_n448# a_3114_218# 0.01895f
C105 vco_delay_cell_2$4_4.in vco_delay_cell_2$4_8.out 0.26189f
C106 vp a_4678_n1920# 0.01559f
C107 vp vco_delay_cell_2$4_2.out 1.33743f
C108 a_4678_218# nen11 0.01416f
C109 a_6922_n448# vp 0.01559f
C110 vco_delay_cell_2$4_4.pgt vco_delay_cell_2$4_7.out 0.0534f
C111 vco_delay_cell_2$4_4.out in 0.34284f
C112 out vco_delay_cell_2$4_8.out 0.22822f
C113 a_n14_n2666# vco_delay_cell_2$4_5.out 0.04001f
C114 a_4678_218# vp 0.32137f
C115 a_1550_n2666# vco_delay_cell_2$4_5.out 0.20769f
C116 a_1550_218# a_1550_n448# 0.01895f
C117 a_6922_218# vp 0.27837f
C118 vco_delay_cell_2$4_4.pgt a_3114_n2666# 0.36371f
C119 vp a_n14_n2666# 0.33739f
C120 vp a_1550_n2666# 0.33867f
C121 vco_delay_cell_2$4_5.out vco_delay_cell_2$4_4.out 0.33396f
C122 vp vco_delay_cell_2$4_4.out 1.32536f
C123 a_4678_218# vco_delay_cell_2$4_8.out 0.20636f
C124 vco_delay_cell_2$4_4.pgt a_4678_n2666# 0.36395f
C125 vco_delay_cell_2$4_4.pgt a_3114_218# 0.34635f
C126 vp a_n1510_n2666# 0.34931f
C127 vco_delay_cell_2$4_3.out a_1550_n1920# 0.0384f
C128 a_1550_n448# in 0.34485f
C129 vco_delay_cell_2$4_4.in a_4678_n448# 0.12125f
C130 a_n1510_n1920# vco_delay_cell_2$4_4.in 0.22995f
C131 a_1550_n448# vco_delay_cell_2$4_10.out 0.21187f
C132 vco_delay_cell_2$4_4.pgt a_6242_n2666# 0.36009f
C133 vco_delay_cell_2$4_4.pgt a_6242_n1920# 0.02466f
C134 a_3114_n448# in 0.34485f
C135 a_1550_n448# vp 0.01559f
C136 a_1550_n448# vco_delay_cell_2$4_9.out 0.03583f
C137 a_1550_218# vco_delay_cell_2$4_4.pgt 0.34655f
C138 nen5 out 0.03395f
C139 a_n14_218# a_n14_n448# 0.01895f
C140 a_n14_218# vco_delay_cell_2$4_10.out 0.03619f
C141 a_1550_n2666# a_1550_n1920# 0.01895f
C142 a_4678_218# a_4678_n448# 0.01895f
C143 a_3114_n2666# a_3114_n1920# 0.01895f
C144 out vco_delay_cell_2$4_4.in 0.17933f
C145 vco_delay_cell_2$4_7.out in 0.02601f
C146 a_3114_n448# vp 0.01559f
C147 a_3114_n448# vco_delay_cell_2$4_9.out 0.21187f
C148 vco_delay_cell_2$4_6.in vco_delay_cell_2$4_7.out 0.63589f
C149 a_6242_n1920# a_6242_n2666# 0.01895f
C150 vco_delay_cell_2$4_4.pgt a_3114_n1920# 0.02621f
C151 a_n14_218# vp 0.3309f
C152 a_n14_n2666# a_n14_n1920# 0.01895f
C153 vco_delay_cell_2$4_0.out vco_delay_cell_2$4_4.pgt 0.06222f
C154 vco_delay_cell_2$4_4.pgt in 2.47459f
C155 a_n1510_n1920# vco_delay_cell_2$4_4.out 0.0384f
C156 vco_delay_cell_2$4_4.out a_n14_n1920# 0.21459f
C157 a_3114_n448# vco_delay_cell_2$4_8.out 0.03583f
C158 vco_delay_cell_2$4_1.out a_4678_n1920# 0.0384f
C159 vco_delay_cell_2$4_6.in vco_delay_cell_2$4_4.pgt 0.44253f
C160 vco_delay_cell_2$4_1.out vco_delay_cell_2$4_2.out 0.33262f
C161 vp a_3114_n2666# 0.33867f
C162 a_6922_n448# out 0.03509f
C163 a_n14_n448# vco_delay_cell_2$4_4.pgt 0.03793f
C164 vco_delay_cell_2$4_7.out vp 0.46458f
C165 vco_delay_cell_2$4_4.pgt vco_delay_cell_2$4_10.out 0.45049f
C166 vco_delay_cell_2$4_3.out vco_delay_cell_2$4_2.out 0.33262f
C167 vco_delay_cell_2$4_5.out vco_delay_cell_2$4_4.pgt 0.5913f
C168 a_4678_218# out 0.12988f
C169 a_6922_218# out 0.12656f
C170 a_n1880_n788# in 0.03255f
C171 vp vco_delay_cell_2$4_4.pgt 18.184f
C172 a_n1510_n1920# a_n1510_n2666# 0.01895f
C173 vco_delay_cell_2$4_4.out vco_delay_cell_2$4_4.in 0.32892f
C174 vp a_4678_n2666# 0.33867f
C175 vco_delay_cell_2$4_4.pgt vp 18.5222f
C176 vco_delay_cell_2$4_4.pgt vco_delay_cell_2$4_9.out 0.43385f
C177 vco_delay_cell_2$4_7.out vco_delay_cell_2$4_8.out 0.32669f
C178 vco_delay_cell_2$4_2.out a_4678_n1920# 0.21377f
C179 a_1550_n2666# vco_delay_cell_2$4_3.out 0.04001f
C180 vco_delay_cell_2$4_0.out a_6242_n2666# 0.03986f
C181 a_6922_n448# a_6922_218# 0.01895f
C182 en11 vco_delay_cell_2$4_0.out 0.01345f
C183 vco_delay_cell_2$4_0.out a_6242_n1920# 0.03832f
C184 a_6242_n1920# in 0.35244f
C185 vp a_3114_218# 0.33867f
C186 vco_delay_cell_2$4_4.in a_n1510_n2666# 0.19487f
C187 vco_delay_cell_2$4_9.out a_3114_218# 0.20636f
C188 vco_delay_cell_2$4_4.pgt vco_delay_cell_2$4_8.out 0.43895f
C189 vp a_6242_n2666# 0.30527f
C190 vp a_6242_n1920# 0.01559f
C191 a_1550_218# vco_delay_cell_2$4_10.out 0.20636f
C192 a_1550_n448# vco_delay_cell_2$4_4.in 0.12451f
C193 a_3114_218# vco_delay_cell_2$4_8.out 0.03776f
C194 a_n14_n2666# vco_delay_cell_2$4_4.out 0.20892f
C195 in a_3114_n1920# 0.35402f
C196 vp gnd 4.30225f
C197 vp gnd 1.2184f
C198 a_6242_n2666# gnd 0.02763f
C199 a_4678_n2666# gnd 3.21695f
C200 a_n1510_n2666# gnd 0.02428f
C201 vco_delay_cell_2$4_0.out gnd 0.79844f
C202 vco_delay_cell_2$4_1.out gnd 0.77486f
C203 vco_delay_cell_2$4_5.out gnd 0.45197f
C204 vco_delay_cell_2$4_4.out gnd 0.91103f
C205 a_6242_n1920# gnd 0.68013f
C206 a_4678_n1920# gnd 15.21971f
C207 a_3114_n1920# gnd 0.90538f
C208 a_1550_n1920# gnd 0.68383f
C209 a_n14_n1920# gnd 0.69229f
C210 a_n1510_n1920# gnd 1.17109f
C211 a_n1880_n788# gnd 0.0445f
C212 a_6922_n448# gnd 0.23137f
C213 a_4678_n448# gnd 0.97495f
C214 a_3114_n448# gnd 0.24129f
C215 a_1550_n448# gnd 0.24129f
C216 a_n14_n448# gnd 0.69405f
C217 vco_delay_cell_2$4_7.out gnd 1.37473f
C218 vco_delay_cell_2$4_10.out gnd 0.94704f
C219 a_6922_218# gnd 0.97031f
C220 a_3114_218# gnd 0.66525f
C221 a_1550_218# gnd 0.45054f
C222 a_n14_218# gnd 0.49724f
.ends
