* PEX produced on Sun Sep 27 04:30:32 PM CEST 2026 using /foss/tools/sak/sak-pex.sh with m=2 and s=1
* NGSPICE file created from vco_core_2.ext - technology: ihp-sg13cmos5l

.subckt vco_core_2 out in vp en11 nen11 en5 nen5 gnd
X0 a_4678_n1920# in gnd gnd sg13_lv_nmos ad=0.272p pd=2.28u as=0.272p ps=2.28u w=0.8u l=6u
X1 vco_delay_cell_2$4_3.out vco_delay_cell_2$4_5.out a_1550_n1920# gnd sg13_lv_nmos ad=0.272p pd=2.28u as=0.272p ps=2.28u w=0.8u l=3u
X2 a_4678_n2666# vco_delay_cell_2$4_4.pgt vp vp sg13_lv_pmos ad=0.408p pd=3.08u as=0.408p ps=3.08u w=1.2u l=6u
X3 a_4678_218# vco_delay_cell_2$4_4.pgt vp vp sg13_lv_pmos ad=0.408p pd=3.08u as=0.408p ps=3.08u w=1.2u l=6u
X4 vco_delay_cell_2$4_4.in nen11 vco_delay_cell_2$4_7.out vp sg13_lv_pmos ad=0.1005p pd=1.34u as=0.1005p ps=1.34u w=0.15u l=0.13u
X5 vco_delay_cell_2$4_3.out vco_delay_cell_2$4_5.out a_1550_n2666# vp sg13_lv_pmos ad=0.408p pd=3.08u as=0.408p ps=3.08u w=1.2u l=3u
X6 vco_delay_cell_2$4_9.out vco_delay_cell_2$4_10.out a_1550_218# vp sg13_lv_pmos ad=0.408p pd=3.08u as=0.408p ps=3.08u w=1.2u l=3u
X7 a_6242_n1920# in gnd gnd sg13_lv_nmos ad=0.272p pd=2.28u as=0.272p ps=2.28u w=0.8u l=6u
X8 a_6242_n2666# vco_delay_cell_2$4_4.pgt vp vp sg13_lv_pmos ad=0.408p pd=3.08u as=0.408p ps=3.08u w=1.2u l=6u
X9 a_1550_218# vco_delay_cell_2$4_4.pgt vp vp sg13_lv_pmos ad=0.408p pd=3.08u as=0.408p ps=3.08u w=1.2u l=6u
X10 vco_delay_cell_2$4_8.out vco_delay_cell_2$4_9.out a_3114_218# vp sg13_lv_pmos ad=0.408p pd=3.08u as=0.408p ps=3.08u w=1.2u l=3u
X11 a_n1510_n1920# in gnd gnd sg13_lv_nmos ad=0.272p pd=2.28u as=0.272p ps=2.28u w=0.8u l=6u
X12 vco_delay_cell_2$4_4.in en11 vco_delay_cell_2$4_7.out gnd sg13_lv_nmos ad=0.1005p pd=1.34u as=0.1005p ps=1.34u w=0.15u l=0.13u
X13 vco_delay_cell_2$4_5.out vco_delay_cell_2$4_4.out a_n14_n1920# gnd sg13_lv_nmos ad=0.272p pd=2.28u as=0.272p ps=2.28u w=0.8u l=3u
X14 vco_delay_cell_2$4_5.out vco_delay_cell_2$4_4.out a_n14_n2666# vp sg13_lv_pmos ad=0.408p pd=3.08u as=0.408p ps=3.08u w=1.2u l=3u
X15 a_n1510_n2666# vco_delay_cell_2$4_4.pgt vp vp sg13_lv_pmos ad=0.408p pd=3.08u as=0.408p ps=3.08u w=1.2u l=6u
X16 vco_delay_cell_2$4_9.out vco_delay_cell_2$4_10.out a_1550_n448# gnd sg13_lv_nmos ad=0.272p pd=2.28u as=0.272p ps=2.28u w=0.8u l=3u
X17 a_1550_n1920# in gnd gnd sg13_lv_nmos ad=0.272p pd=2.28u as=0.272p ps=2.28u w=0.8u l=6u
X18 vco_delay_cell_2$4_6.in nen11 vco_delay_cell_2$4_0.out vp sg13_lv_pmos ad=0.1005p pd=1.34u as=0.1005p ps=1.34u w=0.15u l=0.13u
X19 a_1550_n2666# vco_delay_cell_2$4_4.pgt vp vp sg13_lv_pmos ad=0.408p pd=3.08u as=0.408p ps=3.08u w=1.2u l=6u
X20 vco_delay_cell_2$4_6.in nen5 vco_delay_cell_2$4_7.out vp sg13_lv_pmos ad=0.1005p pd=1.34u as=0.1005p ps=1.34u w=0.15u l=0.13u
X21 vco_delay_cell_2$4_6.in en11 vco_delay_cell_2$4_0.out gnd sg13_lv_nmos ad=0.1005p pd=1.34u as=0.1005p ps=1.34u w=0.15u l=0.13u
X22 vco_delay_cell_2$4_10.out out a_n14_218# vp sg13_lv_pmos ad=0.408p pd=3.08u as=0.408p ps=3.08u w=1.2u l=3u
X23 vco_delay_cell_2$4_7.out vco_delay_cell_2$4_8.out a_4678_n448# gnd sg13_lv_nmos ad=0.272p pd=2.28u as=0.272p ps=2.28u w=0.8u l=3u
X24 a_1550_n448# in gnd gnd sg13_lv_nmos ad=0.272p pd=2.28u as=0.272p ps=2.28u w=0.8u l=6u
X25 vco_delay_cell_2$4_4.pgt in gnd gnd sg13_lv_nmos ad=0.272p pd=2.28u as=0.272p ps=2.28u w=0.8u l=6u
X26 a_n14_n1920# in gnd gnd sg13_lv_nmos ad=0.272p pd=2.28u as=0.272p ps=2.28u w=0.8u l=6u
X27 vco_delay_cell_2$4_6.in en5 vco_delay_cell_2$4_7.out gnd sg13_lv_nmos ad=0.1005p pd=1.34u as=0.1005p ps=1.34u w=0.15u l=0.13u
X28 a_n14_n2666# vco_delay_cell_2$4_4.pgt vp vp sg13_lv_pmos ad=0.408p pd=3.08u as=0.408p ps=3.08u w=1.2u l=6u
X29 out vco_delay_cell_2$4_6.in a_6922_218# vp sg13_lv_pmos ad=0.408p pd=3.08u as=0.408p ps=3.08u w=1.2u l=3u
X30 a_4678_n448# in gnd gnd sg13_lv_nmos ad=0.272p pd=2.28u as=0.272p ps=2.28u w=0.8u l=6u
X31 a_3114_n448# in gnd gnd sg13_lv_nmos ad=0.272p pd=2.28u as=0.272p ps=2.28u w=0.8u l=6u
X32 vco_delay_cell_2$4_2.out vco_delay_cell_2$4_3.out a_3114_n1920# gnd sg13_lv_nmos ad=0.272p pd=2.28u as=0.272p ps=2.28u w=0.8u l=3u
X33 vco_delay_cell_2$4_2.out vco_delay_cell_2$4_3.out a_3114_n2666# vp sg13_lv_pmos ad=0.408p pd=3.08u as=0.408p ps=3.08u w=1.2u l=3u
X34 a_3114_218# vco_delay_cell_2$4_4.pgt vp vp sg13_lv_pmos ad=0.408p pd=3.08u as=0.408p ps=3.08u w=1.2u l=6u
X35 a_6922_n448# in gnd gnd sg13_lv_nmos ad=0.272p pd=2.28u as=0.272p ps=2.28u w=0.8u l=6u
X36 vco_delay_cell_2$4_0.out vco_delay_cell_2$4_1.out a_6242_n1920# gnd sg13_lv_nmos ad=0.272p pd=2.28u as=0.272p ps=2.28u w=0.8u l=3u
X37 vco_delay_cell_2$4_0.out vco_delay_cell_2$4_1.out a_6242_n2666# vp sg13_lv_pmos ad=0.408p pd=3.08u as=0.408p ps=3.08u w=1.2u l=3u
X38 a_6922_218# vco_delay_cell_2$4_4.pgt vp vp sg13_lv_pmos ad=0.408p pd=3.08u as=0.408p ps=3.08u w=1.2u l=6u
X39 vco_delay_cell_2$4_4.pgt vco_delay_cell_2$4_4.pgt vp vp sg13_lv_pmos ad=0.408p pd=3.08u as=0.408p ps=3.08u w=1.2u l=6u
X40 vco_delay_cell_2$4_10.out out a_n14_n448# gnd sg13_lv_nmos ad=0.272p pd=2.28u as=0.272p ps=2.28u w=0.8u l=3u
X41 vco_delay_cell_2$4_4.out vco_delay_cell_2$4_4.in a_n1510_n1920# gnd sg13_lv_nmos ad=0.272p pd=2.28u as=0.272p ps=2.28u w=0.8u l=3u
X42 vco_delay_cell_2$4_1.out vco_delay_cell_2$4_2.out a_4678_n1920# gnd sg13_lv_nmos ad=0.272p pd=2.28u as=0.272p ps=2.28u w=0.8u l=3u
X43 vco_delay_cell_2$4_8.out vco_delay_cell_2$4_9.out a_3114_n448# gnd sg13_lv_nmos ad=0.272p pd=2.28u as=0.272p ps=2.28u w=0.8u l=3u
X44 out vco_delay_cell_2$4_6.in a_6922_n448# gnd sg13_lv_nmos ad=0.272p pd=2.28u as=0.272p ps=2.28u w=0.8u l=3u
X45 vco_delay_cell_2$4_4.out vco_delay_cell_2$4_4.in a_n1510_n2666# vp sg13_lv_pmos ad=0.408p pd=3.08u as=0.408p ps=3.08u w=1.2u l=3u
X46 vco_delay_cell_2$4_1.out vco_delay_cell_2$4_2.out a_4678_n2666# vp sg13_lv_pmos ad=0.408p pd=3.08u as=0.408p ps=3.08u w=1.2u l=3u
X47 a_n14_n448# in gnd gnd sg13_lv_nmos ad=0.272p pd=2.28u as=0.272p ps=2.28u w=0.8u l=6u
X48 a_n14_218# vco_delay_cell_2$4_4.pgt vp vp sg13_lv_pmos ad=0.408p pd=3.08u as=0.408p ps=3.08u w=1.2u l=6u
X49 a_3114_n1920# in gnd gnd sg13_lv_nmos ad=0.272p pd=2.28u as=0.272p ps=2.28u w=0.8u l=6u
X50 vco_delay_cell_2$4_7.out vco_delay_cell_2$4_8.out a_4678_218# vp sg13_lv_pmos ad=0.408p pd=3.08u as=0.408p ps=3.08u w=1.2u l=3u
X51 a_3114_n2666# vco_delay_cell_2$4_4.pgt vp vp sg13_lv_pmos ad=0.408p pd=3.08u as=0.408p ps=3.08u w=1.2u l=6u
C0 en11 vco_delay_cell_2$4_4.in 0.01085f
C1 vco_delay_cell_2$4_9.out vco_delay_cell_2$4_8.out 0.33263f
C2 nen5 out 0.03395f
C3 vco_delay_cell_2$4_4.pgt vco_delay_cell_2$4_7.out 0.0534f
C4 a_6242_n2666# vco_delay_cell_2$4_1.out 0.20769f
C5 a_1550_218# vco_delay_cell_2$4_10.out 0.20636f
C6 nen5 nen11 0.04467f
C7 out nen11 0.03141f
C8 out vco_delay_cell_2$4_8.out 0.22822f
C9 a_6922_n448# vp 0.01559f
C10 a_n14_n1920# in 0.35402f
C11 a_n1510_n1920# vco_delay_cell_2$4_4.in 0.22995f
C12 vco_delay_cell_2$4_4.in vco_delay_cell_2$4_4.out 0.32892f
C13 a_1550_n1920# vco_delay_cell_2$4_5.out 0.21377f
C14 vco_delay_cell_2$4_10.out vco_delay_cell_2$4_4.in 0.26016f
C15 a_6242_n2666# vco_delay_cell_2$4_0.out 0.03986f
C16 vp vco_delay_cell_2$4_4.in 1.12658f
C17 in vp 0.15896f
C18 out vco_delay_cell_2$4_7.out 0.12546f
C19 a_6242_n2666# vp 0.30527f
C20 in vco_delay_cell_2$4_5.out 0.34789f
C21 vco_delay_cell_2$4_6.in vp 1.26108f
C22 vco_delay_cell_2$4_8.out vco_delay_cell_2$4_7.out 0.32669f
C23 vco_delay_cell_2$4_4.pgt a_4678_n1920# 0.02638f
C24 vco_delay_cell_2$4_10.out a_n14_218# 0.03619f
C25 a_n14_n1920# vco_delay_cell_2$4_4.out 0.21459f
C26 vco_delay_cell_2$4_2.out a_4678_n1920# 0.21377f
C27 a_1550_n1920# vco_delay_cell_2$4_4.pgt 0.02629f
C28 vco_delay_cell_2$4_4.pgt a_3114_n1920# 0.02621f
C29 a_n14_n1920# vp 0.01559f
C30 in a_6242_n1920# 0.35244f
C31 a_6922_218# vp 0.27837f
C32 vco_delay_cell_2$4_5.out vco_delay_cell_2$4_4.out 0.33396f
C33 vco_delay_cell_2$4_4.pgt in 2.4735f
C34 vco_delay_cell_2$4_10.out vp 1.28891f
C35 vco_delay_cell_2$4_2.out a_3114_n1920# 0.0384f
C36 a_3114_n448# vco_delay_cell_2$4_4.in 0.12451f
C37 in en5 0.01295f
C38 vco_delay_cell_2$4_4.pgt vco_delay_cell_2$4_6.in 0.44253f
C39 out a_6922_n448# 0.03509f
C40 vp vco_delay_cell_2$4_5.out 1.33676f
C41 a_n14_n448# in 0.34485f
C42 a_1550_n448# in 0.34485f
C43 in vco_delay_cell_2$4_9.out 0.18541f
C44 vco_delay_cell_2$4_1.out a_6242_n1920# 0.21377f
C45 a_n1510_n2666# vco_delay_cell_2$4_4.pgt 0.34058f
C46 vco_delay_cell_2$4_2.out in 0.34789f
C47 vco_delay_cell_2$4_4.pgt vco_delay_cell_2$4_1.out 0.56834f
C48 vco_delay_cell_2$4_5.out vco_delay_cell_2$4_3.out 0.33262f
C49 a_4678_n448# vco_delay_cell_2$4_4.in 0.12125f
C50 en11 en5 0.04309f
C51 out in 0.19107f
C52 in vco_delay_cell_2$4_8.out 0.1854f
C53 out vco_delay_cell_2$4_6.in 0.51287f
C54 vco_delay_cell_2$4_0.out a_6242_n1920# 0.03832f
C55 vco_delay_cell_2$4_4.pgt vco_delay_cell_2$4_4.out 0.52907f
C56 vco_delay_cell_2$4_2.out vco_delay_cell_2$4_1.out 0.33262f
C57 vco_delay_cell_2$4_4.pgt vco_delay_cell_2$4_0.out 0.06222f
C58 a_n14_n2666# vco_delay_cell_2$4_4.out 0.20892f
C59 a_6922_218# vco_delay_cell_2$4_4.pgt 0.32274f
C60 vp a_6242_n1920# 0.01559f
C61 vco_delay_cell_2$4_5.out a_1550_n2666# 0.20769f
C62 vco_delay_cell_2$4_4.pgt vco_delay_cell_2$4_10.out 0.45049f
C63 en11 vco_delay_cell_2$4_0.out 0.01345f
C64 vco_delay_cell_2$4_4.pgt vp 18.184f
C65 a_n14_n2666# vp 0.33739f
C66 in vco_delay_cell_2$4_7.out 0.02601f
C67 a_n14_n448# vco_delay_cell_2$4_10.out 0.03583f
C68 a_3114_n2666# vco_delay_cell_2$4_4.pgt 0.36371f
C69 a_1550_n448# vco_delay_cell_2$4_10.out 0.21187f
C70 vco_delay_cell_2$4_4.pgt a_4678_n2666# 0.36395f
C71 a_3114_n448# vp 0.01559f
C72 vco_delay_cell_2$4_10.out vco_delay_cell_2$4_9.out 0.33263f
C73 a_4678_n448# a_4678_218# 0.01895f
C74 vco_delay_cell_2$4_6.in vco_delay_cell_2$4_7.out 0.63589f
C75 vco_delay_cell_2$4_4.pgt vco_delay_cell_2$4_3.out 0.57489f
C76 vco_delay_cell_2$4_2.out vp 1.33743f
C77 a_6922_218# out 0.12656f
C78 out vco_delay_cell_2$4_10.out 0.58373f
C79 a_3114_n2666# vco_delay_cell_2$4_2.out 0.04001f
C80 a_4678_n2666# vco_delay_cell_2$4_2.out 0.20769f
C81 a_3114_218# a_3114_n448# 0.01895f
C82 a_4678_n448# vp 0.01559f
C83 vco_delay_cell_2$4_4.pgt a_1550_n2666# 0.36384f
C84 vco_delay_cell_2$4_2.out vco_delay_cell_2$4_3.out 0.33262f
C85 a_1550_218# vp 0.33867f
C86 in a_4678_n1920# 0.35402f
C87 vco_delay_cell_2$4_4.in vp 0.14742f
C88 vco_delay_cell_2$4_4.pgt a_3114_n448# 0.01542f
C89 in a_6922_n448# 0.33668f
C90 vco_delay_cell_2$4_1.out a_4678_n1920# 0.0384f
C91 a_1550_n1920# in 0.35402f
C92 in a_3114_n1920# 0.35402f
C93 vco_delay_cell_2$4_6.in a_6922_n448# 0.30287f
C94 a_3114_n448# vco_delay_cell_2$4_9.out 0.21187f
C95 a_n14_218# vp 0.3309f
C96 vco_delay_cell_2$4_4.pgt a_4678_n448# 0.01563f
C97 in vco_delay_cell_2$4_6.in 0.59738f
C98 a_1550_218# vco_delay_cell_2$4_4.pgt 0.34655f
C99 a_3114_n448# vco_delay_cell_2$4_8.out 0.03583f
C100 a_4678_218# vp 0.32137f
C101 a_4678_n1920# vp 0.01559f
C102 a_n14_n1920# vco_delay_cell_2$4_5.out 0.0384f
C103 in vco_delay_cell_2$4_1.out 0.34789f
C104 a_1550_218# a_1550_n448# 0.01895f
C105 a_1550_218# vco_delay_cell_2$4_9.out 0.03776f
C106 a_4678_n2666# a_4678_n1920# 0.01895f
C107 vco_delay_cell_2$4_4.pgt vco_delay_cell_2$4_4.in 0.93144f
C108 a_6922_218# a_6922_n448# 0.01895f
C109 a_6242_n2666# a_6242_n1920# 0.01895f
C110 vco_delay_cell_2$4_4.pgt a_6242_n2666# 0.36009f
C111 a_4678_n448# vco_delay_cell_2$4_8.out 0.21187f
C112 a_1550_218# out 0.13261f
C113 a_1550_n1920# vp 0.01559f
C114 a_n14_n448# vco_delay_cell_2$4_4.in 0.12442f
C115 vp a_3114_n1920# 0.01559f
C116 a_1550_n448# vco_delay_cell_2$4_4.in 0.12451f
C117 a_n1510_n1920# in 0.35458f
C118 vco_delay_cell_2$4_9.out vco_delay_cell_2$4_4.in 0.26017f
C119 in vco_delay_cell_2$4_4.out 0.34284f
C120 in vco_delay_cell_2$4_0.out 0.04742f
C121 a_3114_n2666# a_3114_n1920# 0.01895f
C122 vco_delay_cell_2$4_4.pgt a_n14_218# 0.38074f
C123 vco_delay_cell_2$4_10.out in 0.18541f
C124 vco_delay_cell_2$4_0.out vco_delay_cell_2$4_6.in 0.45466f
C125 in vp 0.12843f
C126 out vco_delay_cell_2$4_4.in 0.17933f
C127 a_3114_218# vp 0.33867f
C128 a_1550_n1920# vco_delay_cell_2$4_3.out 0.0384f
C129 a_6922_218# vco_delay_cell_2$4_6.in 0.21608f
C130 vco_delay_cell_2$4_3.out a_3114_n1920# 0.21377f
C131 a_4678_n448# vco_delay_cell_2$4_7.out 0.06097f
C132 a_n1510_n2666# a_n1510_n1920# 0.01895f
C133 a_n1510_n2666# vco_delay_cell_2$4_4.out 0.04001f
C134 a_n14_n448# a_n14_218# 0.01895f
C135 vp vco_delay_cell_2$4_6.in 0.14424f
C136 vco_delay_cell_2$4_8.out vco_delay_cell_2$4_4.in 0.26189f
C137 vco_delay_cell_2$4_4.pgt a_4678_218# 0.34585f
C138 a_n14_n1920# vco_delay_cell_2$4_4.pgt 0.02515f
C139 vco_delay_cell_2$4_1.out vco_delay_cell_2$4_0.out 0.3305f
C140 a_n14_n1920# a_n14_n2666# 0.01895f
C141 a_n1510_n2666# vp 0.34931f
C142 in vco_delay_cell_2$4_3.out 0.34789f
C143 a_1550_n1920# a_1550_n2666# 0.01895f
C144 vco_delay_cell_2$4_1.out vp 1.3292f
C145 out a_n14_218# 0.31551f
C146 a_n1510_n1920# vco_delay_cell_2$4_4.out 0.0384f
C147 vco_delay_cell_2$4_4.pgt vp 18.5222f
C148 vco_delay_cell_2$4_4.in vco_delay_cell_2$4_7.out 0.9967f
C149 nen11 vp 0.15972f
C150 a_4678_n2666# vco_delay_cell_2$4_1.out 0.04001f
C151 vco_delay_cell_2$4_4.pgt vco_delay_cell_2$4_5.out 0.5913f
C152 a_n14_n2666# vco_delay_cell_2$4_5.out 0.04001f
C153 out a_4678_218# 0.12988f
C154 a_n1510_n1920# vp 0.01559f
C155 a_n14_n448# vp 0.01559f
C156 vp vco_delay_cell_2$4_4.out 1.32536f
C157 a_1550_n448# vp 0.01559f
C158 vco_delay_cell_2$4_0.out vp 0.30839f
C159 vco_delay_cell_2$4_9.out vp 1.31121f
C160 nen11 a_4678_218# 0.01416f
C161 vco_delay_cell_2$4_8.out a_4678_218# 0.20636f
C162 a_3114_218# vco_delay_cell_2$4_4.pgt 0.34635f
C163 nen5 vp 0.16226f
C164 out vp 2.0745f
C165 in a_3114_n448# 0.34485f
C166 a_3114_n2666# vp 0.33867f
C167 a_4678_n2666# vp 0.33867f
C168 nen11 vp 0.15936f
C169 a_3114_218# vco_delay_cell_2$4_9.out 0.20636f
C170 vco_delay_cell_2$4_8.out vp 1.30614f
C171 a_4678_218# vco_delay_cell_2$4_7.out 0.03867f
C172 vp vco_delay_cell_2$4_3.out 1.33743f
C173 vco_delay_cell_2$4_4.pgt a_6242_n1920# 0.02466f
C174 a_3114_n2666# vco_delay_cell_2$4_3.out 0.20769f
C175 a_3114_218# out 0.13218f
C176 in a_4678_n448# 0.34304f
C177 a_n14_n2666# vco_delay_cell_2$4_4.pgt 0.3623f
C178 a_3114_218# vco_delay_cell_2$4_8.out 0.03776f
C179 vp vco_delay_cell_2$4_7.out 0.46458f
C180 a_n14_n448# vco_delay_cell_2$4_4.pgt 0.03793f
C181 vp a_1550_n2666# 0.33867f
C182 vco_delay_cell_2$4_4.pgt a_1550_n448# 0.01557f
C183 vco_delay_cell_2$4_4.pgt vco_delay_cell_2$4_9.out 0.43385f
C184 vco_delay_cell_2$4_4.pgt vco_delay_cell_2$4_2.out 0.57965f
C185 en11 a_4678_n448# 0.02071f
C186 vco_delay_cell_2$4_4.pgt out 2.79513f
C187 in vco_delay_cell_2$4_4.in 2.97698f
C188 a_1550_n448# vco_delay_cell_2$4_9.out 0.03583f
C189 vco_delay_cell_2$4_3.out a_1550_n2666# 0.04001f
C190 vco_delay_cell_2$4_4.pgt vco_delay_cell_2$4_8.out 0.43895f
C191 vco_delay_cell_2$4_4.in vco_delay_cell_2$4_6.in 0.01729f
C192 a_n14_n448# out 0.20304f
C193 out vco_delay_cell_2$4_9.out 0.22822f
C194 a_n1510_n2666# vco_delay_cell_2$4_4.in 0.19487f
C195 vp gnd 4.3095f
C196 vp gnd 1.22042f
C197 a_6242_n2666# gnd 0.02763f
C198 a_4678_n2666# gnd 3.2242f
C199 a_n1510_n2666# gnd 0.02428f
C200 vco_delay_cell_2$4_0.out gnd 0.79844f
C201 vco_delay_cell_2$4_1.out gnd 0.77486f
C202 vco_delay_cell_2$4_5.out gnd 0.45197f
C203 vco_delay_cell_2$4_4.out gnd 0.91238f
C204 a_6242_n1920# gnd 0.68013f
C205 a_4678_n1920# gnd 15.26211f
C206 a_3114_n1920# gnd 0.90538f
C207 a_1550_n1920# gnd 0.68383f
C208 a_n14_n1920# gnd 0.69229f
C209 a_n1510_n1920# gnd 1.17244f
C210 a_6922_n448# gnd 0.23137f
C211 a_4678_n448# gnd 0.97495f
C212 a_3114_n448# gnd 0.24129f
C213 a_1550_n448# gnd 0.24129f
C214 a_n14_n448# gnd 0.69405f
C215 vco_delay_cell_2$4_7.out gnd 1.37473f
C216 vco_delay_cell_2$4_10.out gnd 0.94704f
C217 a_6922_218# gnd 0.97031f
C218 a_3114_218# gnd 0.66525f
C219 a_1550_218# gnd 0.45054f
C220 a_n14_218# gnd 0.49724f
.ends
