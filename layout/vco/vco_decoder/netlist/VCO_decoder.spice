** sch_path: /foss/designs/CHIP-PLL/schematics/divider/schematics/VCO_decoder.sch
.subckt VCO_decoder gd VP c0 c1 c2 f0 f1 f2 f3 f4 f5 VCO_sel VCO2_11_sel VCO2_5_sel VCO3_11_sel VCO3_5_sel VCO4_11_sel VCO4_5_sel
+ VCO5_11_sel
*.PININFO gd:B VP:B c1:I c2:I f0:I f1:I c0:I VCO2_11_sel:O VCO2_5_sel:O VCO_sel:O VCO3_11_sel:O VCO3_5_sel:O VCO4_11_sel:O
*+ VCO4_5_sel:O VCO5_11_sel:O f2:I f3:I f4:I f5:I
Column gd VP c0 c1 c2 000 001 010 011 100 101 110 111 3bit_to_8_outs
x2 VP gd f2 net1 f3 NOR_2in
x3 VP gd f4 net2 f5 NOR_2in
x4 VP gd f3 after_000111_n f4 f5 NOR_3in
x5 VP gd f4 after_001111_n f5 NOR_2in
x6 VP gd net1 after_000011 net2 NAND_2in
x7 after_000111_n after_000111 VP gd inverter
x8 after_001111_n after_001111 VP gd inverter
x9 after_000011 after_000011_n VP gd inverter
x1 f1 f1_n VP gd inverter
x10 f5 f5_n VP gd inverter
x11 VP gd after_000111 net3 111 NAND_2in
x12 VP gd after_001111 net4 110 NAND_2in
x13 VP gd 101 net5 f5 NAND_2in
x14 VP gd net3 VCO_sel net4 net5 NAND_3in
x15 VP gd 110 net6 after_001111_n after_000111 NAND_3in
x16 VP gd 100 net8 f5 NAND_2in
x17 VP gd 101 net7 after_000111 f5_n NAND_3in
x18 VP gd 111 net9 after_000011 after_000111_n NAND_3in
x19 VP gd net6 VCO2_5_sel net7 net8 net9 NAND_4in
x20 VP gd net10 VCO2_11_sel net11 net12 NAND_3in
x21 VP gd net14 net10 net16 NOR_2in
x22 VP gd net18 net11 net20 NOR_2in
x23 VP gd net22 net12 net28 NOR_2in
x24 VP gd 100 net13 after_000111 f5_n NAND_3in
x25 VP gd 011 net15 after_001111 NAND_2in
x26 net13 net14 VP gd inverter
x27 net15 net16 VP gd inverter
x28 VP gd 010 net17 f5 NAND_2in
x29 net17 net18 VP gd inverter
x30 VP gd 111 net19 after_000011_n NAND_2in
x31 net19 net20 VP gd inverter
x32 VP gd 101 net21 after_000011 after_000111_n NAND_3in
x33 net21 net22 VP gd inverter
x34 VP gd 110 net23 after_000011_n net29 NAND_3in
x35 net23 net24 VP gd inverter
x36 VP gd 110 net25 after_000011 after_000111_n NAND_3in
x37 net25 net26 VP gd inverter
x38 VP gd net24 net27 net26 NOR_2in
x40 net27 net28 VP gd inverter
x39 VP gd f0 net29 f1 XNOR
x41 VP gd 010 net87 after_000011_n f1_n NAND_3in
x44 net30 net31 VP gd inverter
x43 VP gd 000 net30 after_000011_n NAND_2in
x45 VP gd 011 net32 after_000111 after_001111_n NAND_3in
x46 net32 net33 VP gd inverter
x47 VP gd 010 net34 after_000111 f5_n NAND_3in
x48 net34 net35 VP gd inverter
x49 net36 net37 VP gd inverter
x50 VP gd 001 net36 f5_n NAND_2in
x51 net38 net39 VP gd inverter
x52 VP gd 101 net38 after_000011_n NAND_2in
x53 VP gd 100 net40 after_000011 after_000111_n NAND_3in
x54 net40 net41 VP gd inverter
x55 VP gd 110 net42 after_000011_n net43 NAND_3in
x56 net42 net47 VP gd inverter
x57 VP gd net44 VCO3_5_sel net45 net46 NAND_3in
x58 VP gd net33 net44 net35 NOR_2in
x59 VP gd net37 net45 net39 NOR_2in
x60 VP gd net41 net46 net47 NOR_2in
x61 VP gd f0 net48 f1 XNOR
x62 net48 net43 VP gd inverter
x63 VP gd 011 net49 after_000011_n net54 NAND_3in
x64 net49 net50 VP gd inverter
x65 VP gd 011 net51 after_000011 after_000111_n NAND_3in
x66 net51 net52 VP gd inverter
x67 VP gd net50 net53 net52 NOR_2in
x69 VP gd f0 net54 f1 XNOR
x70 VP gd 001 net55 after_000111 f5_n NAND_3in
x71 net55 net56 VP gd inverter
x72 net57 net58 VP gd inverter
x73 VP gd 000 net57 after_001111 NAND_2in
x74 net59 net60 VP gd inverter
x75 VP gd 100 net59 after_000011_n NAND_2in
x76 VP gd 010 net61 after_000011 after_000111_n NAND_3in
x77 net61 net62 VP gd inverter
x68 VP gd net63 VCO3_11_sel net64 net53 NAND_3in
x78 VP gd net56 net63 net58 NOR_2in
x79 VP gd net60 net64 net62 NOR_2in
x80 VP gd 000 net65 after_000111 after_001111_n NAND_3in
x81 net65 net66 VP gd inverter
x82 VP gd 010 net67 after_000011_n f1 NAND_3in
x83 net67 net68 VP gd inverter
x84 VP gd 011 net69 net82 after_000011_n NAND_3in
x85 net69 net70 VP gd inverter
x86 VP gd 001 net71 net81 after_000011_n NAND_3in
x87 net71 net78 VP gd inverter
x88 VP gd 001 net72 after_000011 after_000111_n NAND_3in
x89 net72 net79 VP gd inverter
x90 VP gd 000 net73 after_000011 after_000111_n NAND_3in
x91 net73 VCO4_11_sel VP gd inverter
x92 VP gd net66 net74 net68 NOR_2in
x93 VP gd net74 VCO4_5_sel net75 NAND_2in
x94 VP gd net70 net75 net76 NOR_2in
x97 VP gd net78 net77 net79 NOR_2in
x98 net77 net76 VP gd inverter
x96 VP gd f0 net81 f1 XNOR
x99 net80 net82 VP gd inverter
x95 VP gd 001 net83 net85 after_000011_n NAND_3in
x101 net83 net88 VP gd inverter
x102 net84 net85 VP gd inverter
x104 VP gd net88 net86 net31 NOR_2in
x106 VP gd net86 VCO5_11_sel net87 NAND_2in
x42 VP gd f0 net80 f1 XNOR
x100 VP gd f0 net84 f1 XNOR
.ends

* expanding   symbol:  3bit_to_8_outs.sym # of pins=13
** sym_path: /foss/designs/CHIP-PLL/schematics/divider/schematics/3bit_to_8_outs.sym
** sch_path: /foss/designs/CHIP-PLL/schematics/divider/schematics/3bit_to_8_outs.sch
.subckt 3bit_to_8_outs gd VP c0 c1 c2 coarse_0 coarse_1 coarse_2 coarse_3 coarse_4 coarse_5 coarse_6 coarse_7
*.PININFO gd:B VP:B c1:I c2:I c0:I coarse_1:O coarse_2:O coarse_0:O coarse_3:O coarse_4:O coarse_5:O coarse_6:O coarse_7:O
x1 c0 c0_n VP gd inverter
x2 c1 c1_n VP gd inverter
x3 c2 c2_n VP gd inverter
x4 VP gd c0_n net1 c1_n c2_n NAND_3in
x5 VP gd c0 net2 c1_n c2_n NAND_3in
x12 net1 coarse_0 VP gd inverter
x13 net2 coarse_1 VP gd inverter
x14 VP gd c0_n net3 c1 c2_n NAND_3in
x15 net3 coarse_2 VP gd inverter
x6 VP gd c0 net4 c1 c2_n NAND_3in
x16 net4 coarse_3 VP gd inverter
x7 VP gd c0_n net5 c1_n c2 NAND_3in
x17 VP gd c0 net6 c1_n c2 NAND_3in
x18 net5 coarse_4 VP gd inverter
x19 net6 coarse_5 VP gd inverter
x20 VP gd c0_n net7 c1 c2 NAND_3in
x21 net7 coarse_6 VP gd inverter
x22 VP gd c0 net8 c1 c2 NAND_3in
x23 net8 coarse_7 VP gd inverter
.ends

* expanding   symbol:  NOR_2in.sym # of pins=5
** sym_path: /foss/designs/CHIP-PLL/schematics/divider/schematics/NOR_2in.sym
** sch_path: /foss/designs/CHIP-PLL/schematics/divider/schematics/NOR_2in.sch
.subckt NOR_2in VP GND a y b
*.PININFO y:O GND:B a:I VP:B b:I
MM3 y a GND GND sg13_lv_nmos w=0.15u l=0.13u ng=1
MM2 y b net1 VP sg13_lv_pmos w=0.15u l=0.13u ng=1
MM4 net1 a VP VP sg13_lv_pmos w=0.15u l=0.13u ng=1
MM5 y b GND GND sg13_lv_nmos w=0.15u l=0.13u ng=1
.ends

* expanding   symbol:  NOR_3in.sym # of pins=6
** sym_path: /foss/designs/CHIP-PLL/schematics/divider/schematics/NOR_3in.sym
** sch_path: /foss/designs/CHIP-PLL/schematics/divider/schematics/NOR_3in.sch
.subckt NOR_3in VP GND a y b c
*.PININFO y:O GND:B a:I VP:B b:I c:I
MM3 y a GND GND sg13_lv_nmos w=0.15u l=0.13u ng=1
MM2 y b net2 VP sg13_lv_pmos w=0.15u l=0.13u ng=1
MM4 net1 a VP VP sg13_lv_pmos w=0.15u l=0.13u ng=1
MM5 y b GND GND sg13_lv_nmos w=0.15u l=0.13u ng=1
MM1 y c GND GND sg13_lv_nmos w=0.15u l=0.13u ng=1
MM6 net2 c net1 VP sg13_lv_pmos w=0.15u l=0.13u ng=1
.ends

* expanding   symbol:  NAND_2in.sym # of pins=5
** sym_path: /foss/designs/CHIP-PLL/schematics/divider/schematics/NAND_2in.sym
** sch_path: /foss/designs/CHIP-PLL/schematics/divider/schematics/NAND_2in.sch
.subckt NAND_2in VP GND a y b
*.PININFO y:O GND:B a:I VP:B b:I
MM1 y a net1 GND sg13_lv_nmos w=0.15u l=0.13u ng=1
MM3 net1 b GND GND sg13_lv_nmos w=0.15u l=0.13u ng=1
MM2 y b VP VP sg13_lv_pmos w=0.15u l=0.13u ng=1
MM4 y a VP VP sg13_lv_pmos w=0.15u l=0.13u ng=1
.ends

* expanding   symbol:  inverter.sym # of pins=4
** sym_path: /foss/designs/CHIP-PLL/schematics/divider/schematics/inverter.sym
** sch_path: /foss/designs/CHIP-PLL/schematics/divider/schematics/inverter.sch
.subckt inverter IN OUT VP GND
*.PININFO IN:I VP:B OUT:O GND:B
MM1 OUT IN GND GND sg13_lv_nmos w=0.15u l=0.13u ng=1
MM2 OUT IN VP VP sg13_lv_pmos w=0.15u l=0.13u ng=1
.ends

* expanding   symbol:  NAND_3in.sym # of pins=6
** sym_path: /foss/designs/CHIP-PLL/schematics/divider/schematics/NAND_3in.sym
** sch_path: /foss/designs/CHIP-PLL/schematics/divider/schematics/NAND_3in.sch
.subckt NAND_3in VP GND a y b c
*.PININFO y:O GND:B a:I VP:B b:I c:I
MM1 y a net2 GND sg13_lv_nmos w=0.15u l=0.13u ng=1
MM3 net2 b net1 GND sg13_lv_nmos w=0.15u l=0.13u ng=1
MM4 net1 c GND GND sg13_lv_nmos w=0.15u l=0.13u ng=1
MM7 y c VP VP sg13_lv_pmos w=0.15u l=0.13u ng=1
MM2 y a VP VP sg13_lv_pmos w=0.15u l=0.13u ng=1
MM5 y b VP VP sg13_lv_pmos w=0.15u l=0.13u ng=1
.ends

* expanding   symbol:  NAND_4in.sym # of pins=7
** sym_path: /foss/designs/CHIP-PLL/schematics/divider/schematics/NAND_4in.sym
** sch_path: /foss/designs/CHIP-PLL/schematics/divider/schematics/NAND_4in.sch
.subckt NAND_4in VP GND a y b c d
*.PININFO y:O GND:B a:I VP:B b:I c:I d:I
MM1 y a net2 GND sg13_lv_nmos w=0.15u l=0.13u ng=1
MM3 net3 c net1 GND sg13_lv_nmos w=0.15u l=0.13u ng=1
MM4 net1 d GND GND sg13_lv_nmos w=0.15u l=0.13u ng=1
MM7 y c VP VP sg13_lv_pmos w=0.15u l=0.13u ng=1
MM2 y a VP VP sg13_lv_pmos w=0.15u l=0.13u ng=1
MM5 y b VP VP sg13_lv_pmos w=0.15u l=0.13u ng=1
MM6 y d VP VP sg13_lv_pmos w=0.15u l=0.13u ng=1
MM8 net2 b net3 GND sg13_lv_nmos w=0.15u l=0.13u ng=1
.ends

* expanding   symbol:  XNOR.sym # of pins=5
** sym_path: /foss/designs/CHIP-PLL/schematics/divider/schematics/XNOR.sym
** sch_path: /foss/designs/CHIP-PLL/schematics/divider/schematics/XNOR.sch
.subckt XNOR VP GND a y b
*.PININFO y:O GND:B a:I VP:B b:I
MM1 y a net1 GND sg13_lv_nmos w=0.15u l=0.13u ng=1
MM3 net1 _b GND GND sg13_lv_nmos w=0.15u l=0.13u ng=1
MM2 net2 a VP VP sg13_lv_pmos w=0.15u l=0.13u ng=1 m=4
MM4 net3 _a VP VP sg13_lv_pmos w=0.15u l=0.13u ng=1 m=4
MM5 y _a net4 GND sg13_lv_nmos w=0.15u l=0.13u ng=1
MM6 net4 b GND GND sg13_lv_nmos w=0.15u l=0.13u ng=1
MM7 y b net2 VP sg13_lv_pmos w=0.15u l=0.13u ng=1 m=4
MM8 y _b net3 VP sg13_lv_pmos w=0.15u l=0.13u ng=1 m=4
x1 a _a VP GND inverter
x2 b _b VP GND inverter
.ends
