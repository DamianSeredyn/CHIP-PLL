.subckt inverter_x1 IN VP OUT GND
*.ipin IN
*.iopin VP
*.opin OUT
*.iopin GND
M1 OUT IN GND GND sg13_lv_nmos w=0.15u l=0.13u ng=1
M2 OUT IN VP VP sg13_lv_pmos w=0.15u l=0.13u ng=1
.ends
