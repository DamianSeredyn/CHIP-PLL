* Extracted by KLayout with SG13G2 LVS runset on : 08/04/2026 19:09

.SUBCKT inverter_x2 GND VP OUT IN
M$1 VP VP VP VP sg13_lv_pmos L=0.13u W=0.3u AS=0.102p AD=0.057p PS=1.28u
+ PD=0.68u
M$2 VP IN OUT VP sg13_lv_pmos L=0.13u W=0.3u AS=0.057p AD=0.057p PS=0.68u
+ PD=0.68u
M$3 OUT OUT OUT VP sg13_lv_pmos L=0.13u W=0.3u AS=0.057p AD=0.102p PS=0.68u
+ PD=1.28u
M$4 GND GND GND GND sg13_lv_nmos L=0.13u W=0.3u AS=0.102p AD=0.057p PS=1.28u
+ PD=0.68u
M$5 GND IN OUT GND sg13_lv_nmos L=0.13u W=0.3u AS=0.057p AD=0.057p PS=0.68u
+ PD=0.68u
M$6 OUT OUT OUT GND sg13_lv_nmos L=0.13u W=0.3u AS=0.057p AD=0.102p PS=0.68u
+ PD=1.28u
.ENDS inverter_x2
