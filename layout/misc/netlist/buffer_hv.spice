** sch_path: /foss/designs/CHIP-PLL/schematics/misc/buffer_hv.sch
.subckt buffer_hv vph in out gd
*.PININFO in:I out:O vph:I gd:I
MM1 buf_stage_1 in vph vph sg13_hv_pmos w=1u l=0.45u ng=1
MM2 buf_stage_1 in gd gd sg13_hv_nmos w=1u l=0.45u ng=1
MM3 out buf_stage_1 vph vph sg13_hv_pmos w=1u l=0.45u ng=1
MM4 out buf_stage_1 gd gd sg13_hv_nmos w=1u l=0.45u ng=1
.ends
