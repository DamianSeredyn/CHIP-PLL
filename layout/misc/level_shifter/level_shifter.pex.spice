* PEX produced on Tue Sep  1 11:30:35 PM CEST 2026 using /foss/tools/sak/sak-pex.sh with m=2 and s=1
* NGSPICE file created from level_shifter.ext - technology: ihp-sg13g2

.subckt level_shifter out in vph vpl gd
X0 out 3_stage_out vph vph sg13_hv_pmos ad=0.34p pd=2.68u as=0.19p ps=1.38u w=1u l=0.45u
X1 3_stage_out a_5207_4935# gd gd sg13_hv_nmos ad=0.19p pd=1.38u as=0.34p ps=2.68u w=1u l=0.45u
X2 gd a_5207_4935# 3_stage_out gd sg13_hv_nmos ad=0.34p pd=2.68u as=0.19p ps=1.38u w=1u l=0.45u
X3 a_5207_4935# 1_stage_out a_5365_4545# gd sg13_lv_nmos ad=0.34p pd=2.68u as=0.19p ps=1.38u w=1u l=0.45u
X4 3_stage_out a_5207_4935# a_6343_5165# vph sg13_hv_pmos ad=0.19p pd=1.38u as=0.19p ps=1.38u w=1u l=0.45u
X5 a_5207_4935# 1_stage_out vpl vpl sg13_lv_pmos ad=0.34p pd=2.68u as=0.19p ps=1.38u w=1u l=0.45u
X6 a_4931_4545# in gd gd sg13_lv_nmos ad=0.19p pd=1.38u as=0.34p ps=2.68u w=1u l=0.45u
X7 vph 4 a_6343_5165# vph sg13_hv_pmos ad=0.19p pd=1.38u as=0.34p ps=2.68u w=1u l=0.45u
X8 a_6343_5165# a_5207_4935# 3_stage_out vph sg13_hv_pmos ad=0.34p pd=2.68u as=0.19p ps=1.38u w=1u l=0.45u
X9 vpl in 1_stage_out vpl sg13_lv_pmos ad=0.19p pd=1.38u as=0.34p ps=2.68u w=1u l=0.45u
X10 4 1_stage_out gd gd sg13_hv_nmos ad=0.34p pd=2.68u as=0.19p ps=1.38u w=1u l=0.45u
X11 a_7267_4565# 3_stage_out gd gd sg13_hv_nmos ad=0.19p pd=1.38u as=0.34p ps=2.68u w=1u l=0.45u
X12 gd a_5207_4935# 3_stage_out gd sg13_hv_nmos ad=0.19p pd=1.38u as=0.19p ps=1.38u w=1u l=0.45u
X13 vph 3_stage_out a_6067_5165# vph sg13_hv_pmos ad=0.34p pd=2.68u as=0.19p ps=1.38u w=1u l=0.45u
X14 vph 3_stage_out out vph sg13_hv_pmos ad=0.19p pd=1.38u as=0.34p ps=2.68u w=1u l=0.45u
X15 gd 1_stage_out 4 gd sg13_hv_nmos ad=0.19p pd=1.38u as=0.34p ps=2.68u w=1u l=0.45u
X16 a_5365_4545# 1_stage_out gd gd sg13_lv_nmos ad=0.19p pd=1.38u as=0.34p ps=2.68u w=1u l=0.45u
X17 a_6343_5165# 4 vph vph sg13_hv_pmos ad=0.19p pd=1.38u as=0.19p ps=1.38u w=1u l=0.45u
X18 1_stage_out in a_4931_4545# gd sg13_lv_nmos ad=0.34p pd=2.68u as=0.19p ps=1.38u w=1u l=0.45u
X19 vpl 1_stage_out a_5207_4935# vpl sg13_lv_pmos ad=0.19p pd=1.38u as=0.34p ps=2.68u w=1u l=0.45u
X20 a_6067_5165# 1_stage_out 4 vph sg13_hv_pmos ad=0.19p pd=1.38u as=0.34p ps=2.68u w=1u l=0.45u
X21 out 3_stage_out a_7267_4565# gd sg13_hv_nmos ad=0.34p pd=2.68u as=0.19p ps=1.38u w=1u l=0.45u
X22 1_stage_out in vpl vpl sg13_lv_pmos ad=0.34p pd=2.68u as=0.19p ps=1.38u w=1u l=0.45u
X23 3_stage_out a_5207_4935# gd gd sg13_hv_nmos ad=0.19p pd=1.38u as=0.19p ps=1.38u w=1u l=0.45u
C0 3_stage_out a_7267_4565# 0.04864f
C1 vpl a_5207_4935# 0.30802f
C2 a_5365_4545# a_5207_4935# 0.05117f
C3 3_stage_out a_5207_4935# 0.84455f
C4 3_stage_out vph 0.76176f
C5 1_stage_out 4 0.47974f
C6 3_stage_out vpl 0.01771f
C7 1_stage_out in 0.53853f
C8 4 a_6343_5165# 0.08334f
C9 1_stage_out a_6067_5165# 0.02162f
C10 a_6067_5165# 4 0.05906f
C11 1_stage_out a_4931_4545# 0.05117f
C12 out a_6343_5165# 0.11705f
C13 1_stage_out a_5207_4935# 1.11646f
C14 1_stage_out vph 0.15041f
C15 4 a_5207_4935# 0.4715f
C16 out a_7267_4565# 0.05119f
C17 vph 4 0.43564f
C18 a_4931_4545# in 0.05936f
C19 out vph 0.3447f
C20 a_6343_5165# a_5207_4935# 0.09204f
C21 1_stage_out vpl 0.63397f
C22 vph a_6343_5165# 0.47445f
C23 vpl 4 0.03934f
C24 1_stage_out 3_stage_out 0.05156f
C25 1_stage_out a_5365_4545# 0.05936f
C26 vph a_6067_5165# 0.02392f
C27 3_stage_out 4 0.26034f
C28 vpl in 0.29476f
C29 3_stage_out out 0.51268f
C30 3_stage_out a_6343_5165# 0.84259f
C31 vph a_5207_4935# 0.30602f
C32 3_stage_out a_6067_5165# 0.15583f
C33 out gd 0.97925f
C34 vpl gd 0.06815f
C35 vph gd 1.3128f
C36 a_7267_4565# gd 0.48404f
C37 a_5365_4545# gd 0.68441f
C38 a_4931_4545# gd 0.29449f
C39 a_6343_5165# gd 0.79639f
.ends
