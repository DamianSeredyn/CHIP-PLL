* PEX produced on Mon Oct 19 07:55:42 PM CEST 2026 using /foss/tools/sak/sak-pex.sh with m=2 and s=1
* NGSPICE file created from vco_top.ext - technology: ihp-sg13cmos5l

.subckt vco_top vco_in out c2 c1 c0 f0 f1 f2 f3 f4 f5 VP gd
X0 gd a_44078_n653# a_44680_n1157# gd sg13_lv_nmos ad=0.11875p pd=1.005u as=0.2125p ps=1.93u w=0.625u l=0.13u
X1 VCO_decoder_cells_0.VCO2_selection_0.NAND_4in_dek_0.a VCO_decoder_cells_0.110 a_9993_n5894# gd sg13_lv_nmos ad=0.1005p pd=1.34u as=0.1005p ps=1.34u w=0.15u l=0.13u
X2 vco_core_0_0.vp PFD_passgate_2.in_p VP VP sg13_lv_pmos ad=0.11875p pd=1.005u as=0.11875p ps=1.005u w=0.625u l=0.13u
X3 gd a_45734_n11460# 0_buf_1.out gd sg13_lv_nmos ad=0.2375p pd=1.63u as=0.2375p ps=1.63u w=1.25u l=0.13u
X4 vco_core_4_0.vco_delay_cell_4_1.up vco_core_4_0.vco_delay_cell_4_1.in vco_core_4_0.vco_delay_cell_4_0.in vco_passgate_0.OI sg13_lv_pmos ad=0.408p pd=3.08u as=0.408p ps=3.08u w=1.2u l=15u
X5 VCO_decoder_cells_0.VCO2_selection_0.NAND_3in_dek_2.y VCO_decoder_cells_0.101 VP VP sg13_lv_pmos ad=0.1005p pd=1.34u as=0.1005p ps=1.34u w=0.15u l=0.13u
X6 gd a_45996_6964# a_46598_6964# gd sg13_lv_nmos ad=0.2375p pd=1.63u as=0.2375p ps=1.63u w=1.25u l=0.13u
X7 gd VCO_decoder_cells_0.after_001111_n VCO_decoder_cells_0.after_001111 gd sg13_lv_nmos ad=0.1005p pd=1.34u as=0.1005p ps=1.34u w=0.15u l=0.13u
X8 VP VCO_decoder_cells_0.3bit_to_8_outs_0.c1_n VCO_decoder_cells_0.3bit_to_8_outs_0.inverter_dek_6.in VP sg13_lv_pmos ad=0.1005p pd=1.34u as=0.1005p ps=1.34u w=0.15u l=0.13u
X9 VCO_decoder_cells_0.3bit_to_8_outs_0.NAND_3in_dek_6.y VCO_decoder_cells_0.3bit_to_8_outs_0.c0_n VP VP sg13_lv_pmos ad=0.1005p pd=1.34u as=0.1005p ps=1.34u w=0.15u l=0.13u
X10 VCO_decoder_cells_0.VCO2_selection_0.NAND_3in_dek_1.y VCO_decoder_cells_0.VCO2_selection_0.NAND_3in_dek_1.a VP VP sg13_lv_pmos ad=0.1005p pd=1.34u as=0.1005p ps=1.34u w=0.15u l=0.13u
X11 out vco_passgate_1.en 0_buf_0.out gd sg13_lv_nmos ad=0.1005p pd=1.34u as=0.1005p ps=1.34u w=0.15u l=0.13u
X12 inverter_x1_2.OUT inverter_x1_2.IN gd gd sg13_lv_nmos ad=0.1005p pd=1.34u as=0.1005p ps=1.34u w=0.15u l=0.13u
X13 VP a_45884_n1282# VCO_MUX_0.VCO_in VP sg13_lv_pmos ad=0.2375p pd=1.63u as=0.2375p ps=1.63u w=1.25u l=0.13u
X14 gd VCO_decoder_cells_0.VCO4_selection_0.NAND_2in_dek_0.y NOR_2in$1_0.A gd sg13_lv_nmos ad=0.1005p pd=1.34u as=0.1005p ps=1.34u w=0.15u l=0.13u
X15 VCO_decoder_cells_0.VCO3_selection_0.NAND_3in_dek_3.y VCO_decoder_cells_0.after_001111_n VP VP sg13_lv_pmos ad=0.1005p pd=1.34u as=0.1005p ps=1.34u w=0.15u l=0.13u
X16 gd f3 VCO_decoder_cells_0.after_000111_n gd sg13_lv_nmos ad=0.1005p pd=1.34u as=0.1005p ps=1.34u w=0.15u l=0.13u
X17 a_41752_1356# vco_core_1_0.vco_delay_cell_1$1_3.in vco_core_1_0.vco_delay_cell_1$1_3.out vco_passgate_3.OI sg13_lv_pmos ad=0.204p pd=1.88u as=0.114p ps=0.98u w=0.6u l=0.7u
X18 VCO_decoder_cells_0.VCO2_11_sel VCO_decoder_cells_0.VCO2_selection_0.inverter_dek_0.out a_11359_n3464# gd sg13_lv_nmos ad=0.1005p pd=1.34u as=0.1005p ps=1.34u w=0.15u l=0.13u
X19 VCO_decoder_cells_0.VCO5_selection_0.NAND_2in_dek_0.b VCO_decoder_cells_0.000000 VP VP sg13_lv_pmos ad=0.1005p pd=1.34u as=0.1005p ps=1.34u w=0.15u l=0.13u
X20 a_45341_n5690# a_44739_n5565# gd gd sg13_lv_nmos ad=0.425p pd=3.18u as=0.2375p ps=1.63u w=1.25u l=0.13u
X21 gd a_44964_2717# a_45566_2592# gd sg13_lv_nmos ad=0.2375p pd=1.63u as=0.2375p ps=1.63u w=1.25u l=0.13u
X22 VP VCO_decoder_cells_0.after_000111 VCO_decoder_cells_0.VCO2_selection_0.NAND_4in_dek_0.b VP sg13_lv_pmos ad=0.1005p pd=1.34u as=0.1005p ps=1.34u w=0.15u l=0.13u
X23 vco_core_1_0.vco_delay_cell_1$1_6.out vco_core_1_0.vco_delay_cell_1$1_6.in a_40664_3420# vco_passgate_3.OI sg13_lv_pmos ad=0.114p pd=0.98u as=0.204p ps=1.88u w=0.6u l=0.7u
X24 VP VCO_decoder_cells_0.VCO5_selection_0.NAND_2in_dek_0.a inverter_x1_2.IN VP sg13_lv_pmos ad=0.1005p pd=1.34u as=0.1005p ps=1.34u w=0.15u l=0.13u
X25 gd VCO_decoder_cells_0.VCO2_11_sel inverter_x1_12.IN gd sg13_lv_nmos ad=55.5f pd=0.74u as=0.1005p ps=1.34u w=0.15u l=0.13u
X26 a_43476_n653# vco_core_0_0.out VP VP sg13_lv_pmos ad=71.25f pd=0.755u as=71.25f ps=0.755u w=0.375u l=0.13u
X27 VP a_45884_n1282# VCO_MUX_0.VCO_in VP sg13_lv_pmos ad=0.2375p pd=1.63u as=0.2375p ps=1.63u w=1.25u l=0.13u
X28 VCO_decoder_cells_0.3bit_to_8_outs_0.inverter_dek_8.in VCO_decoder_cells_0.3bit_to_8_outs_0.c0_n VP VP sg13_lv_pmos ad=0.1005p pd=1.34u as=0.1005p ps=1.34u w=0.15u l=0.13u
X29 VP a_44137_n5061# a_44739_n5565# VP sg13_lv_pmos ad=0.11875p pd=1.005u as=0.2125p ps=1.93u w=0.625u l=0.13u
X30 VCO_MUX_0.VCO2_in a_46168_2592# VP VP sg13_lv_pmos ad=0.425p pd=3.18u as=0.2375p ps=1.63u w=1.25u l=0.13u
X31 VCO_MUX_0.VCO_in a_45884_n1282# VP VP sg13_lv_pmos ad=0.2375p pd=1.63u as=0.2375p ps=1.63u w=1.25u l=0.13u
X32 a_11111_n902# VCO_decoder_cells_0.VCO3_selection_0.NAND_3in_dek_3.y gd gd sg13_lv_nmos ad=0.1005p pd=1.34u as=0.1005p ps=1.34u w=0.15u l=0.13u
X33 gd a_45884_n1282# VCO_MUX_0.VCO_in gd sg13_lv_nmos ad=0.2375p pd=1.63u as=0.2375p ps=1.63u w=1.25u l=0.13u
X34 a_3747_n1430# c1 a_3531_n1430# gd sg13_lv_nmos ad=0.1005p pd=1.34u as=0.1005p ps=1.34u w=0.15u l=0.13u
X35 VP a_43326_n10831# a_43928_n10831# VP sg13_lv_pmos ad=0.114p pd=0.98u as=0.204p ps=1.88u w=0.6u l=0.13u
X36 a_36106_1826# vco_core_1_0.vco_delay_cell_1$1_0.in vco_core_1_0.vco_delay_cell_1$1_0.out gd sg13_lv_nmos ad=0.136p pd=1.48u as=76f ps=0.78u w=0.4u l=0.7u
X37 a_38352_1356# vco_core_1_0.vco_delay_cell_1$1_1.out vco_core_1_0.vco_delay_cell_1$1_7.in vco_passgate_3.OI sg13_lv_pmos ad=0.204p pd=1.88u as=0.114p ps=0.98u w=0.6u l=0.7u
X38 VCO_decoder_cells_0.VCO3_selection_0.NAND_3in_dek_4.a f5 VP VP sg13_lv_pmos ad=0.1005p pd=1.34u as=0.1005p ps=1.34u w=0.15u l=0.13u
X39 VCO_decoder_cells_0.3bit_to_8_outs_0.c1_n c1 VP VP sg13_lv_pmos ad=0.1005p pd=1.34u as=0.1005p ps=1.34u w=0.15u l=0.13u
X40 vco_passgate_1.OI vco_core_3_0.vco_delay_cell_3_0.pgt a_34662_n7843# vco_passgate_1.OI sg13_lv_pmos ad=0.408p pd=3.08u as=0.408p ps=3.08u w=1.2u l=17u
X41 VP VCO_decoder_cells_0.000 VCO_decoder_cells_0.VCO3_selection_0.NAND_2in_dek_0.y VP sg13_lv_pmos ad=0.1005p pd=1.34u as=0.1005p ps=1.34u w=0.15u l=0.13u
X42 gd a_44362_3221# a_44964_2717# gd sg13_lv_nmos ad=0.11875p pd=1.005u as=0.2125p ps=1.93u w=0.625u l=0.13u
X43 vco_core_2_0.vco_delay_cell_2$6_8.in vco_core_2_0.nen11 vco_core_2_0.vco_delay_cell_2$6_0.out vco_passgate_4.OI sg13_lv_pmos ad=0.102p pd=1.28u as=0.102p ps=1.28u w=0.3u l=0.15u
X44 a_10927_n3464# VCO_decoder_cells_0.VCO2_selection_0.NAND_4in_dek_1.d gd gd sg13_lv_nmos ad=0.1005p pd=1.34u as=0.1005p ps=1.34u w=0.15u l=0.13u
X45 a_4571_n7189# VCO_decoder_cells_0.after_000111 VCO_decoder_cells_0.VCO_selection_0.NAND_3in_dek_0.a gd sg13_lv_nmos ad=0.1005p pd=1.34u as=0.1005p ps=1.34u w=0.15u l=0.13u
X46 VP VCO_decoder_cells_0.VCO3_11_sel vco_core_2_0.nen11 VP sg13_lv_pmos ad=0.1005p pd=1.34u as=0.1005p ps=1.34u w=0.15u l=0.13u
X47 VCO_decoder_cells_0.row_section_decoding_0.NAND_3in_dek_0.a f3 gd gd sg13_lv_nmos ad=0.1005p pd=1.34u as=0.1005p ps=1.34u w=0.15u l=0.13u
X48 a_46598_6964# a_45996_6964# VP VP sg13_lv_pmos ad=0.2375p pd=1.63u as=0.2375p ps=1.63u w=1.25u l=0.13u
X49 vco_core_1_0.vco_delay_cell_1$1_2.in vco_core_1_0.out a_37194_2990# gd sg13_lv_nmos ad=76f pd=0.78u as=0.136p ps=1.48u w=0.4u l=0.7u
X50 vco_core_3_0.vco_delay_cell_3_1.in vco_core_3_0.vco_delay_cell_3_2.in a_34662_n6301# gd sg13_lv_nmos ad=0.272p pd=2.28u as=0.272p ps=2.28u w=0.8u l=8.5u
X51 vco_core_4_0.vco_delay_cell_4_1.up vco_core_4_0.pgt vco_passgate_0.OI vco_passgate_0.OI sg13_lv_pmos ad=0.408p pd=3.08u as=0.408p ps=3.08u w=1.2u l=30u
X52 VP a_43928_n10831# a_44530_n11335# VP sg13_lv_pmos ad=0.11875p pd=1.005u as=0.11875p ps=1.005u w=0.625u l=0.13u
X53 vco_passgate_4.OI vco_core_2_0.vco_delay_cell_2$6_0.pgt a_38741_8614# vco_passgate_4.OI sg13_lv_pmos ad=0.408p pd=3.08u as=0.408p ps=3.08u w=1.2u l=5u
X54 a_44190_7593# vco_core_2_0.out gd gd sg13_lv_nmos ad=76f pd=0.78u as=0.136p ps=1.48u w=0.4u l=0.13u
X55 VP vco_core_3_0.out a_43535_n5061# VP sg13_lv_pmos ad=71.25f pd=0.755u as=71.25f ps=0.755u w=0.375u l=0.13u
X56 a_4314_n4888# VCO_decoder_cells_0.011 VCO_decoder_cells_0.VCO4_selection_0.NAND_4in_dek_0.d gd sg13_lv_nmos ad=0.1005p pd=1.34u as=0.1005p ps=1.34u w=0.15u l=0.13u
X57 a_45282_n1282# a_44680_n1157# VP VP sg13_lv_pmos ad=0.2375p pd=1.63u as=0.2375p ps=1.63u w=1.25u l=0.13u
X58 VP VCO_decoder_cells_0.011 VCO_decoder_cells_0.VCO2_selection_0.NAND_3in_dek_1.b VP sg13_lv_pmos ad=0.1005p pd=1.34u as=0.1005p ps=1.34u w=0.15u l=0.13u
X59 vco_core_4_0.vco_delay_cell_4_4.up vco_core_4_0.vco_delay_cell_4_4.in vco_core_4_0.vco_delay_cell_4_3.in vco_passgate_0.OI sg13_lv_pmos ad=0.408p pd=3.08u as=0.408p ps=3.08u w=1.2u l=15u
X60 gd a_45943_n5690# 0_buf_0.out gd sg13_lv_nmos ad=0.2375p pd=1.63u as=0.2375p ps=1.63u w=1.25u l=0.13u
X61 VP a_46168_2592# VCO_MUX_0.VCO2_in VP sg13_lv_pmos ad=0.2375p pd=1.63u as=0.2375p ps=1.63u w=1.25u l=0.13u
X62 PFD_passgate_1.B vco_passgate_1.en vco_in gd sg13_lv_nmos ad=0.102p pd=1.28u as=0.102p ps=1.28u w=0.3u l=0.15u
X63 vco_core_2_0.vco_delay_cell_2$6_0.pgt vco_core_2_0.vco_delay_cell_2$6_0.pgt vco_passgate_4.OI vco_passgate_4.OI sg13_lv_pmos ad=0.408p pd=3.08u as=0.408p ps=3.08u w=1.2u l=6u
X64 a_44680_n1157# a_44078_n653# gd gd sg13_lv_nmos ad=0.11875p pd=1.005u as=0.11875p ps=1.005u w=0.625u l=0.13u
X65 a_14717_n4830# NOR_2in$1_0.A VP VP sg13_lv_pmos ad=55.5f pd=0.74u as=0.1005p ps=1.34u w=0.15u l=0.13u
X66 gd a_46168_2592# VCO_MUX_0.VCO2_in gd sg13_lv_nmos ad=0.2375p pd=1.63u as=0.2375p ps=1.63u w=1.25u l=0.13u
X67 vco_passgate_3.OI vco_core_1_0.vco_delay_cell_1$1_0.pgt a_36108_1356# vco_passgate_3.OI sg13_lv_pmos ad=0.204p pd=1.88u as=0.114p ps=0.98u w=0.6u l=1.4u
X68 PFD_passgate_4.in_p VCO_MUX_0.VCO2_sel gd gd sg13_lv_nmos ad=0.1005p pd=1.34u as=0.1005p ps=1.34u w=0.15u l=0.13u
X69 a_40662_1826# vco_core_1_0.vco_delay_cell_1$1_4.in vco_core_1_0.vco_delay_cell_1$1_3.in gd sg13_lv_nmos ad=0.136p pd=1.48u as=76f ps=0.78u w=0.4u l=0.7u
X70 vco_core_3_0.vco_delay_cell_3_8.in vco_core_3_0.vco_delay_cell_3_9.in a_27182_n4047# vco_passgate_1.OI sg13_lv_pmos ad=0.408p pd=3.08u as=0.408p ps=3.08u w=1.2u l=8.5u
X71 a_45394_7089# a_44792_7593# VP VP sg13_lv_pmos ad=0.11875p pd=1.005u as=0.11875p ps=1.005u w=0.625u l=0.13u
X72 VCO_MUX_0.VCO2_in a_46168_2592# gd gd sg13_lv_nmos ad=0.2375p pd=1.63u as=0.2375p ps=1.63u w=1.25u l=0.13u
X73 VP a_45734_n11460# 0_buf_1.out VP sg13_lv_pmos ad=0.2375p pd=1.63u as=0.2375p ps=1.63u w=1.25u l=0.13u
X74 vco_core_1_0.out vco_core_1_0.vco_delay_cell_1$1_5.in a_42226_2990# gd sg13_lv_nmos ad=76f pd=0.78u as=0.136p ps=1.48u w=0.4u l=0.7u
X75 a_41821_n2486# vco_core_0_0.vco_delay_cell_0$1_3.in vco_core_0_0.vco_delay_cell_0$1_2.in vco_core_0_0.vp sg13_lv_pmos ad=0.204p pd=1.88u as=0.114p ps=0.98u w=0.6u l=0.28u
X76 PFD_passgate_0.B inverter_x1_2.IN vco_in gd sg13_lv_nmos ad=0.102p pd=1.28u as=0.102p ps=1.28u w=0.3u l=0.15u
X77 VCO_decoder_cells_0.VCO4_selection_0.NAND_3in_dek_0.y VCO_decoder_cells_0.after_000011_n VP VP sg13_lv_pmos ad=0.1005p pd=1.34u as=0.1005p ps=1.34u w=0.15u l=0.13u
X78 a_9777_n1982# f5 gd gd sg13_lv_nmos ad=0.1005p pd=1.34u as=0.1005p ps=1.34u w=0.15u l=0.13u
X79 inverter_x1_2.OUT inverter_x1_2.IN VP VP sg13_lv_pmos ad=0.1005p pd=1.34u as=0.1005p ps=1.34u w=0.15u l=0.13u
X80 VCO_decoder_cells_0.VCO5_selection_0.NAND_2in_dek_0.a VCO_decoder_cells_0.000 a_9777_n7436# gd sg13_lv_nmos ad=0.1005p pd=1.34u as=0.1005p ps=1.34u w=0.15u l=0.13u
X81 gd a_45341_n5690# a_45943_n5690# gd sg13_lv_nmos ad=0.2375p pd=1.63u as=0.2375p ps=1.63u w=1.25u l=0.13u
X82 gd vco_core_3_0.out a_43535_n5061# gd sg13_lv_nmos ad=0.136p pd=1.48u as=76f ps=0.78u w=0.4u l=0.13u
X83 a_45734_n11460# a_45132_n11460# gd gd sg13_lv_nmos ad=0.425p pd=3.18u as=0.2375p ps=1.63u w=1.25u l=0.13u
X84 gd a_44137_n5061# a_44739_n5565# gd sg13_lv_nmos ad=0.11875p pd=1.005u as=0.11875p ps=1.005u w=0.625u l=0.13u
X85 a_4053_n5362# VCO_decoder_cells_0.001 VCO_decoder_cells_0.VCO4_selection_0.NAND_4in_dek_0.b gd sg13_lv_nmos ad=0.1005p pd=1.34u as=0.1005p ps=1.34u w=0.15u l=0.13u
X86 VCO_MUX_0.VCO3_in a_46598_6964# VP VP sg13_lv_pmos ad=0.2375p pd=1.63u as=0.2375p ps=1.63u w=1.25u l=0.13u
X87 VP c1 VCO_decoder_cells_0.3bit_to_8_outs_0.inverter_dek_1.in VP sg13_lv_pmos ad=0.1005p pd=1.34u as=0.1005p ps=1.34u w=0.15u l=0.13u
X88 a_46598_6964# a_45996_6964# gd gd sg13_lv_nmos ad=0.2375p pd=1.63u as=0.2375p ps=1.63u w=1.25u l=0.13u
X89 vco_core_4_0.vco_delay_cell_4_0.up vco_core_4_0.vco_delay_cell_4_0.in vco_core_4_0.vco_delay_cell_4_0.out vco_passgate_0.OI sg13_lv_pmos ad=0.408p pd=3.08u as=0.408p ps=3.08u w=1.2u l=15u
X90 VP f5 VCO_decoder_cells_0.VCO_selection_0.NAND_3in_dek_0.c VP sg13_lv_pmos ad=0.1005p pd=1.34u as=0.1005p ps=1.34u w=0.15u l=0.13u
X91 a_11212_n5894# VCO_decoder_cells_0.VCO2_selection_0.NAND_2in_dek_0.y a_10996_n5894# gd sg13_lv_nmos ad=0.1005p pd=1.34u as=0.1005p ps=1.34u w=0.15u l=0.13u
X92 a_10476_n5420# VCO_decoder_cells_0.f5_n gd gd sg13_lv_nmos ad=0.1005p pd=1.34u as=0.1005p ps=1.34u w=0.15u l=0.13u
X93 VP VCO_decoder_cells_0.VCO3_selection_0.NAND_4in_dek_1.a VCO_decoder_cells_0.VCO3_5_sel VP sg13_lv_pmos ad=0.1005p pd=1.34u as=0.1005p ps=1.34u w=0.15u l=0.13u
X94 VP a_45734_n11460# 0_buf_1.out VP sg13_lv_pmos ad=0.2375p pd=1.63u as=0.2375p ps=1.63u w=1.25u l=0.13u
X95 a_10729_n7436# VCO_decoder_cells_0.VCO5_selection_0.NAND_2in_dek_0.b gd gd sg13_lv_nmos ad=0.1005p pd=1.34u as=0.1005p ps=1.34u w=0.15u l=0.13u
X96 vco_core_4_0.vco_delay_cell_4_3.dn PFD_passgate_0.B gd gd sg13_lv_nmos ad=0.272p pd=2.28u as=0.272p ps=2.28u w=0.8u l=30u
X97 vco_core_2_0.vco_delay_cell_2$6_6.out vco_core_2_0.vco_delay_cell_2$6_6.in a_34661_4818# vco_passgate_4.OI sg13_lv_pmos ad=0.408p pd=3.08u as=0.408p ps=3.08u w=1.2u l=2.5u
X98 VCO_decoder_cells_0.VCO2_selection_0.NAND_4in_dek_1.c VCO_decoder_cells_0.110 VP VP sg13_lv_pmos ad=0.1005p pd=1.34u as=0.1005p ps=1.34u w=0.15u l=0.13u
X99 VCO_decoder_cells_0.001 VCO_decoder_cells_0.3bit_to_8_outs_0.NAND_3in_dek_2.y gd gd sg13_lv_nmos ad=0.1005p pd=1.34u as=0.1005p ps=1.34u w=0.15u l=0.13u
X100 a_45734_n11460# a_45132_n11460# gd gd sg13_lv_nmos ad=0.2375p pd=1.63u as=0.2375p ps=1.63u w=1.25u l=0.13u
X101 vco_core_4_0.vco_delay_cell_4_5.up 0_buf_1.in vco_core_4_0.vco_delay_cell_4_4.in vco_passgate_0.OI sg13_lv_pmos ad=0.408p pd=3.08u as=0.408p ps=3.08u w=1.2u l=15u
X102 gd inverter_x1_2.OUT PFD_passgate_0.B gd sg13_lv_nmos ad=0.102p pd=1.28u as=0.102p ps=1.28u w=0.3u l=0.13u
X103 VCO_decoder_cells_0.VCO3_selection_0.NAND_2in_dek_1.y VCO_decoder_cells_0.VCO3_selection_0.NAND_3in_dek_0.y VP VP sg13_lv_pmos ad=0.1005p pd=1.34u as=0.1005p ps=1.34u w=0.15u l=0.13u
X104 VCO_decoder_cells_0.100 VCO_decoder_cells_0.3bit_to_8_outs_0.inverter_dek_6.in VP VP sg13_lv_pmos ad=0.1005p pd=1.34u as=0.1005p ps=1.34u w=0.15u l=0.13u
X105 a_3531_n3074# VCO_decoder_cells_0.3bit_to_8_outs_0.c2_n gd gd sg13_lv_nmos ad=0.1005p pd=1.34u as=0.1005p ps=1.34u w=0.15u l=0.13u
X106 VCO_MUX_0.VCO2_sel inverter_x1_12.IN gd gd sg13_lv_nmos ad=0.1005p pd=1.34u as=0.1005p ps=1.34u w=0.15u l=0.13u
X107 VCO_decoder_cells_0.VCO3_selection_0.NAND_2in_dek_0.y VCO_decoder_cells_0.after_001111 VP VP sg13_lv_pmos ad=0.1005p pd=1.34u as=0.1005p ps=1.34u w=0.15u l=0.13u
X108 vco_core_1_0.vco_delay_cell_1$1_0.out vco_core_1_0.vco_delay_cell_1$1_0.in a_36106_1826# gd sg13_lv_nmos ad=76f pd=0.78u as=0.136p ps=1.48u w=0.4u l=0.7u
X109 a_40664_1356# vco_core_1_0.vco_delay_cell_1$1_0.pgt vco_passgate_3.OI vco_passgate_3.OI sg13_lv_pmos ad=0.114p pd=0.98u as=0.204p ps=1.88u w=0.6u l=1.4u
X110 a_37194_1826# PFD_passgate_4.B gd gd sg13_lv_nmos ad=76f pd=0.78u as=0.136p ps=1.48u w=0.4u l=1.4u
X111 VP a_45734_n11460# 0_buf_1.out VP sg13_lv_pmos ad=0.2375p pd=1.63u as=0.2375p ps=1.63u w=1.25u l=0.13u
X112 VCO_decoder_cells_0.VCO3_selection_0.inverter_dek_0.out VCO_decoder_cells_0.VCO3_selection_0.NAND_2in_dek_1.y gd gd sg13_lv_nmos ad=0.1005p pd=1.34u as=0.1005p ps=1.34u w=0.15u l=0.13u
X113 a_41821_n2018# vco_core_0_0.vco_delay_cell_0$1_3.in vco_core_0_0.vco_delay_cell_0$1_2.in gd sg13_lv_nmos ad=0.136p pd=1.48u as=76f ps=0.78u w=0.4u l=0.28u
X114 VCO_decoder_cells_0.VCO2_11_sel VCO_decoder_cells_0.VCO2_selection_0.NAND_3in_dek_2.y VP VP sg13_lv_pmos ad=0.1005p pd=1.34u as=0.1005p ps=1.34u w=0.15u l=0.13u
X115 a_44362_3221# a_43760_3221# VP VP sg13_lv_pmos ad=0.114p pd=0.98u as=0.114p ps=0.98u w=0.6u l=0.13u
X116 a_37194_2990# PFD_passgate_4.B gd gd sg13_lv_nmos ad=76f pd=0.78u as=0.136p ps=1.48u w=0.4u l=1.4u
X117 vco_core_4_0.vco_delay_cell_4_8.out vco_core_4_0.vco_delay_cell_4_10.out vco_core_4_0.vco_delay_cell_4_8.dn gd sg13_lv_nmos ad=0.272p pd=2.28u as=0.272p ps=2.28u w=0.8u l=15u
X118 vco_passgate_1.OI vco_passgate_1.en VP gd sg13_lv_nmos ad=0.2125p pd=1.93u as=0.11875p ps=1.005u w=0.625u l=0.13u
X119 a_40664_3420# vco_core_1_0.vco_delay_cell_1$1_0.pgt vco_passgate_3.OI vco_passgate_3.OI sg13_lv_pmos ad=0.114p pd=0.98u as=0.204p ps=1.88u w=0.6u l=1.4u
X120 0_buf_0.out a_45943_n5690# gd gd sg13_lv_nmos ad=0.2375p pd=1.63u as=0.2375p ps=1.63u w=1.25u l=0.13u
X121 VCO_MUX_0.VCO3_in a_46598_6964# gd gd sg13_lv_nmos ad=0.2375p pd=1.63u as=0.2375p ps=1.63u w=1.25u l=0.13u
X122 vco_passgate_0.OI inverter_x1_2.IN VP gd sg13_lv_nmos ad=0.11875p pd=1.005u as=0.11875p ps=1.005u w=0.625u l=0.13u
X123 VCO_decoder_cells_0.VCO2_selection_0.NAND_3in_dek_1.y VCO_decoder_cells_0.VCO2_selection_0.NAND_3in_dek_1.a a_10954_n1982# gd sg13_lv_nmos ad=0.1005p pd=1.34u as=0.1005p ps=1.34u w=0.15u l=0.13u
X124 VP a_45943_n5690# 0_buf_0.out VP sg13_lv_pmos ad=0.2375p pd=1.63u as=0.2375p ps=1.63u w=1.25u l=0.13u
X125 a_46168_2592# a_45566_2592# VP VP sg13_lv_pmos ad=0.2375p pd=1.63u as=0.2375p ps=1.63u w=1.25u l=0.13u
X126 gd PFD_passgate_4.in_p PFD_passgate_4.B gd sg13_lv_nmos ad=0.102p pd=1.28u as=0.102p ps=1.28u w=0.3u l=0.13u
X127 vco_core_4_0.vco_delay_cell_4_2.dn vco_core_4_0.vco_delay_cell_4_2.in vco_core_4_0.vco_delay_cell_4_1.in gd sg13_lv_nmos ad=0.272p pd=2.28u as=0.272p ps=2.28u w=0.8u l=15u
X128 a_9993_n5420# VCO_decoder_cells_0.after_000011 a_9777_n5420# gd sg13_lv_nmos ad=0.1005p pd=1.34u as=0.1005p ps=1.34u w=0.15u l=0.13u
X129 VCO_decoder_cells_0.3bit_to_8_outs_0.NAND_3in_dek_2.y VCO_decoder_cells_0.3bit_to_8_outs_0.c2_n VP VP sg13_lv_pmos ad=0.1005p pd=1.34u as=0.1005p ps=1.34u w=0.15u l=0.13u
X130 vco_core_2_0.vco_delay_cell_2$6_5.in vco_core_2_0.vco_delay_cell_2$6_4.out a_37381_8614# vco_passgate_4.OI sg13_lv_pmos ad=0.408p pd=3.08u as=0.408p ps=3.08u w=1.2u l=2.5u
X131 VCO_decoder_cells_0.VCO3_selection_0.NAND_4in_dek_1.a VCO_decoder_cells_0.VCO3_selection_0.inverter_dek_1.in gd gd sg13_lv_nmos ad=0.1005p pd=1.34u as=0.1005p ps=1.34u w=0.15u l=0.13u
X132 VP a_45734_n11460# 0_buf_1.out VP sg13_lv_pmos ad=0.2375p pd=1.63u as=0.2375p ps=1.63u w=1.25u l=0.13u
X133 VP VCO_MUX_0.VCO3_sel vco_passgate_4.OI gd sg13_lv_nmos ad=0.11875p pd=1.005u as=0.2125p ps=1.93u w=0.625u l=0.13u
X134 gd PFD_passgate_4.B a_36106_1826# gd sg13_lv_nmos ad=0.136p pd=1.48u as=76f ps=0.78u w=0.4u l=1.4u
X135 VCO_decoder_cells_0.row_section_decoding_0.NAND_2in_dek_0.b f5 gd gd sg13_lv_nmos ad=0.1005p pd=1.34u as=0.1005p ps=1.34u w=0.15u l=0.13u
X136 VCO_decoder_cells_0.111 VCO_decoder_cells_0.3bit_to_8_outs_0.NAND_3in_dek_0.y gd gd sg13_lv_nmos ad=0.1005p pd=1.34u as=0.1005p ps=1.34u w=0.15u l=0.13u
X137 vco_core_3_0.out vco_core_3_0.vco_delay_cell_3_0.in a_39218_n4047# vco_passgate_1.OI sg13_lv_pmos ad=0.408p pd=3.08u as=0.408p ps=3.08u w=1.2u l=8.5u
X138 a_42226_2990# PFD_passgate_4.B gd gd sg13_lv_nmos ad=76f pd=0.78u as=0.136p ps=1.48u w=0.4u l=1.4u
X139 vco_core_4_0.vco_delay_cell_4_4.dn PFD_passgate_0.B gd gd sg13_lv_nmos ad=0.272p pd=2.28u as=0.272p ps=2.28u w=0.8u l=30u
X140 vco_passgate_0.OI inverter_x1_2.IN VP gd sg13_lv_nmos ad=0.2125p pd=1.93u as=0.11875p ps=1.005u w=0.625u l=0.13u
X141 a_44739_n5565# a_44137_n5061# gd gd sg13_lv_nmos ad=0.11875p pd=1.005u as=0.11875p ps=1.005u w=0.625u l=0.13u
X142 gd PFD_passgate_3.B a_38741_6360# gd sg13_lv_nmos ad=0.272p pd=2.28u as=0.272p ps=2.28u w=0.8u l=5u
X143 a_45943_n5690# a_45341_n5690# gd gd sg13_lv_nmos ad=0.2375p pd=1.63u as=0.2375p ps=1.63u w=1.25u l=0.13u
X144 VP VCO_decoder_cells_0.000000 VCO_decoder_cells_0.VCO4_selection_0.NAND_4in_dek_0.d VP sg13_lv_pmos ad=0.1005p pd=1.34u as=0.1005p ps=1.34u w=0.15u l=0.13u
X145 gd a_44190_7593# a_44792_7593# gd sg13_lv_nmos ad=0.204p pd=1.88u as=0.114p ps=0.98u w=0.6u l=0.13u
X146 gd PFD_passgate_1.B a_34662_n6301# gd sg13_lv_nmos ad=0.272p pd=2.28u as=0.272p ps=2.28u w=0.8u l=17u
X147 a_46168_2592# a_45566_2592# gd gd sg13_lv_nmos ad=0.425p pd=3.18u as=0.2375p ps=1.63u w=1.25u l=0.13u
X148 gd PFD_passgate_3.B a_34661_6360# gd sg13_lv_nmos ad=0.272p pd=2.28u as=0.272p ps=2.28u w=0.8u l=5u
X149 VCO_decoder_cells_0.VCO3_5_sel VCO_decoder_cells_0.VCO3_selection_0.NAND_4in_dek_1.a a_11526_n428# gd sg13_lv_nmos ad=0.1005p pd=1.34u as=0.1005p ps=1.34u w=0.15u l=0.13u
X150 vco_core_4_0.vco_delay_cell_4_2.dn PFD_passgate_0.B gd gd sg13_lv_nmos ad=0.272p pd=2.28u as=0.272p ps=2.28u w=0.8u l=30u
X151 a_45943_n5690# a_45341_n5690# gd gd sg13_lv_nmos ad=0.2375p pd=1.63u as=0.2375p ps=1.63u w=1.25u l=0.13u
X152 VP a_46598_6964# VCO_MUX_0.VCO3_in VP sg13_lv_pmos ad=0.2375p pd=1.63u as=0.2375p ps=1.63u w=1.25u l=0.13u
X153 gd a_45566_2592# a_46168_2592# gd sg13_lv_nmos ad=0.2375p pd=1.63u as=0.2375p ps=1.63u w=1.25u l=0.13u
X154 gd f4 VCO_decoder_cells_0.row_section_decoding_0.NAND_2in_dek_0.b gd sg13_lv_nmos ad=0.1005p pd=1.34u as=0.1005p ps=1.34u w=0.15u l=0.13u
X155 out VCO_MUX_0.passgate_scaled_1.en_ VCO_MUX_0.VCO2_in VP sg13_lv_pmos ad=0.1005p pd=1.34u as=0.1005p ps=1.34u w=0.15u l=0.13u
X156 VCO_decoder_cells_0.3bit_to_8_outs_0.NAND_3in_dek_6.y VCO_decoder_cells_0.3bit_to_8_outs_0.c0_n a_4427_n3074# gd sg13_lv_nmos ad=0.1005p pd=1.34u as=0.1005p ps=1.34u w=0.15u l=0.13u
X157 a_4427_n3392# VCO_decoder_cells_0.3bit_to_8_outs_0.c1_n a_4211_n3392# gd sg13_lv_nmos ad=0.1005p pd=1.34u as=0.1005p ps=1.34u w=0.15u l=0.13u
X158 VP a_44739_n5565# a_45341_n5690# VP sg13_lv_pmos ad=0.2375p pd=1.63u as=0.2375p ps=1.63u w=1.25u l=0.13u
X159 a_41821_n2018# vco_core_0_0.in gd gd sg13_lv_nmos ad=76f pd=0.78u as=0.136p ps=1.48u w=0.4u l=0.56u
X160 a_46168_2592# a_45566_2592# gd gd sg13_lv_nmos ad=0.2375p pd=1.63u as=0.2375p ps=1.63u w=1.25u l=0.13u
X161 a_44078_n653# a_43476_n653# VP VP sg13_lv_pmos ad=0.204p pd=1.88u as=0.114p ps=0.98u w=0.6u l=0.13u
X162 a_41855_n914# vco_core_0_0.vco_delay_cell_0$1_1.in vco_core_0_0.vco_delay_cell_0$1_0.in gd sg13_lv_nmos ad=0.136p pd=1.48u as=76f ps=0.78u w=0.4u l=0.28u
X163 a_43326_n10831# 0_buf_1.in VP VP sg13_lv_pmos ad=71.25f pd=0.755u as=71.25f ps=0.755u w=0.375u l=0.13u
X164 VP VCO_decoder_cells_0.row_section_decoding_0.NAND_3in_dek_0.a VCO_decoder_cells_0.000000_n VP sg13_lv_pmos ad=0.1005p pd=1.34u as=0.1005p ps=1.34u w=0.15u l=0.13u
X165 VCO_decoder_cells_0.VCO3_selection_0.NAND_3in_dek_4.b VCO_decoder_cells_0.f5_n VP VP sg13_lv_pmos ad=0.1005p pd=1.34u as=0.1005p ps=1.34u w=0.15u l=0.13u
X166 out VCO_MUX_0.passgate_scaled_2.en_ 0_buf_0.out VP sg13_lv_pmos ad=0.1005p pd=1.34u as=0.1005p ps=1.34u w=0.15u l=0.13u
X167 vco_core_2_0.vco_delay_cell_2$6_1.in vco_core_2_0.vco_delay_cell_2$6_2.in a_38741_6360# gd sg13_lv_nmos ad=0.272p pd=2.28u as=0.272p ps=2.28u w=0.8u l=2.5u
X168 a_41855_n486# vco_core_0_0.vco_delay_cell_0$1_0.pgt vco_core_0_0.vp vco_core_0_0.vp sg13_lv_pmos ad=0.114p pd=0.98u as=0.204p ps=1.88u w=0.6u l=0.56u
X169 VP a_43476_n653# a_44078_n653# VP sg13_lv_pmos ad=0.114p pd=0.98u as=0.204p ps=1.88u w=0.6u l=0.13u
X170 gd a_43760_3221# a_44362_3221# gd sg13_lv_nmos ad=0.204p pd=1.88u as=0.114p ps=0.98u w=0.6u l=0.13u
X171 vco_passgate_3.OI vco_core_1_0.vco_delay_cell_1$1_0.pgt a_41752_1356# vco_passgate_3.OI sg13_lv_pmos ad=0.204p pd=1.88u as=0.114p ps=0.98u w=0.6u l=1.4u
X172 VCO_decoder_cells_0.VCO2_selection_0.NAND_3in_dek_0.y VCO_decoder_cells_0.100 VP VP sg13_lv_pmos ad=0.1005p pd=1.34u as=0.1005p ps=1.34u w=0.15u l=0.13u
X173 a_37196_3420# vco_core_1_0.out vco_core_1_0.vco_delay_cell_1$1_2.in vco_passgate_3.OI sg13_lv_pmos ad=0.204p pd=1.88u as=0.114p ps=0.98u w=0.6u l=0.7u
X174 gd a_45884_n1282# VCO_MUX_0.VCO_in gd sg13_lv_nmos ad=0.2375p pd=1.63u as=0.425p ps=3.18u w=1.25u l=0.13u
X175 gd a_45884_n1282# VCO_MUX_0.VCO_in gd sg13_lv_nmos ad=0.2375p pd=1.63u as=0.2375p ps=1.63u w=1.25u l=0.13u
X176 a_44190_7593# vco_core_2_0.out VP VP sg13_lv_pmos ad=0.1275p pd=1.43u as=71.25f ps=0.755u w=0.375u l=0.13u
X177 VP VCO_decoder_cells_0.VCO3_selection_0.inverter_dek_0.out VCO_decoder_cells_0.VCO3_11_sel VP sg13_lv_pmos ad=0.1005p pd=1.34u as=0.1005p ps=1.34u w=0.15u l=0.13u
X178 a_45884_n1282# a_45282_n1282# VP VP sg13_lv_pmos ad=0.425p pd=3.18u as=0.2375p ps=1.63u w=1.25u l=0.13u
X179 a_45734_n11460# a_45132_n11460# VP VP sg13_lv_pmos ad=0.2375p pd=1.63u as=0.2375p ps=1.63u w=1.25u l=0.13u
X180 vco_core_3_0.vco_delay_cell_3_0.in vco_core_3_0.nen11 vco_core_3_0.vco_delay_cell_3_1.out vco_passgate_1.OI sg13_lv_pmos ad=0.102p pd=1.28u as=0.102p ps=1.28u w=0.3u l=0.15u
X181 a_5047_n7189# VCO_decoder_cells_0.101 VCO_decoder_cells_0.VCO_selection_0.NAND_3in_dek_0.c gd sg13_lv_nmos ad=0.1005p pd=1.34u as=0.1005p ps=1.34u w=0.15u l=0.13u
X182 VP VCO_decoder_cells_0.VCO_selection_0.NAND_3in_dek_0.c VCO_MUX_0.VCO_sel VP sg13_lv_pmos ad=0.1005p pd=1.34u as=0.1005p ps=1.34u w=0.15u l=0.13u
X183 a_40662_1826# PFD_passgate_4.B gd gd sg13_lv_nmos ad=76f pd=0.78u as=0.136p ps=1.48u w=0.4u l=1.4u
X184 VCO_decoder_cells_0.VCO2_selection_0.NAND_3in_dek_1.b VCO_decoder_cells_0.011 a_10253_n1982# gd sg13_lv_nmos ad=0.1005p pd=1.34u as=0.1005p ps=1.34u w=0.15u l=0.13u
X185 VP vco_core_2_0.out a_44190_7593# VP sg13_lv_pmos ad=71.25f pd=0.755u as=0.1275p ps=1.43u w=0.375u l=0.13u
X186 vco_core_1_0.vco_delay_cell_1$1_0.in vco_core_1_0.nen11 vco_core_1_0.vco_delay_cell_1$1_6.out vco_passgate_3.OI sg13_lv_pmos ad=0.102p pd=1.28u as=0.102p ps=1.28u w=0.3u l=0.15u
X187 a_40662_2990# PFD_passgate_4.B gd gd sg13_lv_nmos ad=76f pd=0.78u as=0.136p ps=1.48u w=0.4u l=1.4u
X188 a_43928_n10831# a_43326_n10831# VP VP sg13_lv_pmos ad=0.204p pd=1.88u as=0.114p ps=0.98u w=0.6u l=0.13u
X189 vco_core_3_0.vco_delay_cell_3_5.in NOR_2in$1_0.A vco_core_3_0.vco_delay_cell_3_7.out gd sg13_lv_nmos ad=0.102p pd=1.28u as=0.102p ps=1.28u w=0.3u l=0.15u
X190 VP f4 a_4722_154# VP sg13_lv_pmos ad=0.1005p pd=1.34u as=0.1005p ps=1.34u w=0.15u l=0.13u
X191 VP VCO_decoder_cells_0.100 VCO_decoder_cells_0.VCO2_selection_0.NAND_2in_dek_0.y VP sg13_lv_pmos ad=0.1005p pd=1.34u as=0.1005p ps=1.34u w=0.15u l=0.13u
X192 PFD_passgate_3.in_p VCO_MUX_0.VCO3_sel VP VP sg13_lv_pmos ad=0.1005p pd=1.34u as=0.1005p ps=1.34u w=0.15u l=0.13u
X193 gd a_44792_7593# a_45394_7089# gd sg13_lv_nmos ad=0.11875p pd=1.005u as=0.11875p ps=1.005u w=0.625u l=0.13u
X194 VCO_decoder_cells_0.3bit_to_8_outs_0.c1_n c1 gd gd sg13_lv_nmos ad=0.1005p pd=1.34u as=0.1005p ps=1.34u w=0.15u l=0.13u
X195 vco_core_2_0.vco_delay_cell_2$6_0.in vco_core_2_0.vco_delay_cell_2$6_1.in a_40101_6360# gd sg13_lv_nmos ad=0.272p pd=2.28u as=0.272p ps=2.28u w=0.8u l=2.5u
X196 VCO_decoder_cells_0.VCO3_selection_0.NAND_2in_dek_0.y VCO_decoder_cells_0.000 a_10630_3010# gd sg13_lv_nmos ad=0.1005p pd=1.34u as=0.1005p ps=1.34u w=0.15u l=0.13u
X197 vco_passgate_3.OI vco_core_1_0.vco_delay_cell_1$1_0.pgt a_38352_1356# vco_passgate_3.OI sg13_lv_pmos ad=0.204p pd=1.88u as=0.114p ps=0.98u w=0.6u l=1.4u
X198 gd a_46598_6964# VCO_MUX_0.VCO3_in gd sg13_lv_nmos ad=0.2375p pd=1.63u as=0.2375p ps=1.63u w=1.25u l=0.13u
X199 a_36108_1356# vco_core_1_0.vco_delay_cell_1$1_0.in vco_core_1_0.vco_delay_cell_1$1_0.out vco_passgate_3.OI sg13_lv_pmos ad=0.204p pd=1.88u as=0.114p ps=0.98u w=0.6u l=0.7u
X200 VCO_decoder_cells_0.010 VCO_decoder_cells_0.3bit_to_8_outs_0.NAND_3in_dek_6.y VP VP sg13_lv_pmos ad=0.1005p pd=1.34u as=0.1005p ps=1.34u w=0.15u l=0.13u
X201 VP vco_passgate_1.en vco_passgate_1.OI gd sg13_lv_nmos ad=0.11875p pd=1.005u as=0.2125p ps=1.93u w=0.625u l=0.13u
X202 VP a_43535_n5061# a_44137_n5061# VP sg13_lv_pmos ad=0.114p pd=0.98u as=0.204p ps=1.88u w=0.6u l=0.13u
X203 gd a_45943_n5690# 0_buf_0.out gd sg13_lv_nmos ad=0.2375p pd=1.63u as=0.2375p ps=1.63u w=1.25u l=0.13u
X204 vco_core_3_0.vco_delay_cell_3_7.in vco_core_3_0.vco_delay_cell_3_8.in a_30922_n5509# gd sg13_lv_nmos ad=0.272p pd=2.28u as=0.272p ps=2.28u w=0.8u l=8.5u
X205 vco_passgate_3.OI vco_core_1_0.vco_delay_cell_1$1_0.pgt a_38352_3420# vco_passgate_3.OI sg13_lv_pmos ad=0.204p pd=1.88u as=0.114p ps=0.98u w=0.6u l=1.4u
X206 VP a_44078_n653# a_44680_n1157# VP sg13_lv_pmos ad=0.11875p pd=1.005u as=0.2125p ps=1.93u w=0.625u l=0.13u
X207 VP VCO_MUX_0.VCO_sel vco_core_0_0.vp gd sg13_lv_nmos ad=0.11875p pd=1.005u as=0.11875p ps=1.005u w=0.625u l=0.13u
X208 VCO_decoder_cells_0.VCO_selection_0.NAND_3in_dek_0.a VCO_decoder_cells_0.after_000111 VP VP sg13_lv_pmos ad=0.1005p pd=1.34u as=0.1005p ps=1.34u w=0.15u l=0.13u
X209 out VCO_MUX_0.inverter_dek_0.out VCO_MUX_0.VCO_in VP sg13_lv_pmos ad=95f pd=0.88u as=95f ps=0.88u w=0.5u l=0.13u
X210 VP VCO_decoder_cells_0.VCO3_selection_0.NAND_3in_dek_4.b VCO_decoder_cells_0.VCO3_selection_0.inverter_dek_1.in VP sg13_lv_pmos ad=0.1005p pd=1.34u as=0.1005p ps=1.34u w=0.15u l=0.13u
X211 gd a_45943_n5690# 0_buf_0.out gd sg13_lv_nmos ad=0.2375p pd=1.63u as=0.2375p ps=1.63u w=1.25u l=0.13u
X212 a_3850_n4888# VCO_decoder_cells_0.VCO4_selection_0.NAND_3in_dek_0.y a_3634_n4888# gd sg13_lv_nmos ad=0.1005p pd=1.34u as=0.1005p ps=1.34u w=0.15u l=0.13u
X213 a_45996_6964# a_45394_7089# VP VP sg13_lv_pmos ad=0.425p pd=3.18u as=0.2375p ps=1.63u w=1.25u l=0.13u
X214 gd a_44680_n1157# a_45282_n1282# gd sg13_lv_nmos ad=0.2375p pd=1.63u as=0.2375p ps=1.63u w=1.25u l=0.13u
X215 VCO_decoder_cells_0.3bit_to_8_outs_0.inverter_dek_8.in VCO_decoder_cells_0.3bit_to_8_outs_0.c0_n a_3747_n3392# gd sg13_lv_nmos ad=0.1005p pd=1.34u as=0.1005p ps=1.34u w=0.15u l=0.13u
X216 PFD_passgate_1.B vco_passgate_1.en_ vco_in VP sg13_lv_pmos ad=0.102p pd=1.28u as=0.102p ps=1.28u w=0.3u l=0.15u
X217 VCO_decoder_cells_0.row_section_decoding_0.NAND_3in_dek_0.b f5 gd gd sg13_lv_nmos ad=0.1005p pd=1.34u as=0.1005p ps=1.34u w=0.15u l=0.13u
X218 0_buf_1.out a_45734_n11460# gd gd sg13_lv_nmos ad=0.2375p pd=1.63u as=0.2375p ps=1.63u w=1.25u l=0.13u
X219 gd NOR_2in$1_0.A NOR_2in$1_0.Out gd sg13_lv_nmos ad=55.5f pd=0.74u as=0.1005p ps=1.34u w=0.15u l=0.13u
X220 a_45943_n5690# a_45341_n5690# VP VP sg13_lv_pmos ad=0.425p pd=3.18u as=0.2375p ps=1.63u w=1.25u l=0.13u
X221 VP a_45394_7089# a_45996_6964# VP sg13_lv_pmos ad=0.2375p pd=1.63u as=0.425p ps=3.18u w=1.25u l=0.13u
X222 VP VCO_MUX_0.VCO2_sel VCO_MUX_0.passgate_scaled_1.en_ VP sg13_lv_pmos ad=0.1005p pd=1.34u as=0.1005p ps=1.34u w=0.15u l=0.13u
X223 VP PFD_passgate_4.in_p vco_passgate_3.OI VP sg13_lv_pmos ad=0.11875p pd=1.005u as=0.11875p ps=1.005u w=0.625u l=0.13u
X224 gd PFD_passgate_0.B vco_core_4_0.vco_delay_cell_4_6.dn gd sg13_lv_nmos ad=0.272p pd=2.28u as=0.272p ps=2.28u w=0.8u l=30u
X225 a_4246_1132# VCO_decoder_cells_0.row_section_decoding_0.NAND_2in_dek_0.a VCO_decoder_cells_0.after_000011 gd sg13_lv_nmos ad=0.1005p pd=1.34u as=0.1005p ps=1.34u w=0.15u l=0.13u
X226 vco_core_0_0.vco_delay_cell_0$1_0.pgt vco_core_0_0.in gd gd sg13_lv_nmos ad=76f pd=0.78u as=0.136p ps=1.48u w=0.4u l=0.56u
X227 gd vco_passgate_1.en VCO_MUX_0.passgate_scaled_2.en_ gd sg13_lv_nmos ad=0.1005p pd=1.34u as=0.1005p ps=1.34u w=0.15u l=0.13u
X228 PFD_passgate_0.B inverter_x1_2.OUT vco_in VP sg13_lv_pmos ad=0.102p pd=1.28u as=0.102p ps=1.28u w=0.3u l=0.15u
X229 VP VCO_decoder_cells_0.after_001111_n VCO_decoder_cells_0.VCO4_selection_0.NAND_3in_dek_1.y VP sg13_lv_pmos ad=0.1005p pd=1.34u as=0.1005p ps=1.34u w=0.15u l=0.13u
X230 a_45943_n5690# a_45341_n5690# VP VP sg13_lv_pmos ad=0.2375p pd=1.63u as=0.2375p ps=1.63u w=1.25u l=0.13u
X231 a_40664_1356# vco_core_1_0.vco_delay_cell_1$1_4.in vco_core_1_0.vco_delay_cell_1$1_3.in vco_passgate_3.OI sg13_lv_pmos ad=0.204p pd=1.88u as=0.114p ps=0.98u w=0.6u l=0.7u
X232 gd PFD_passgate_3.in_p PFD_passgate_3.B gd sg13_lv_nmos ad=0.102p pd=1.28u as=0.102p ps=1.28u w=0.3u l=0.13u
X233 0_buf_1.out a_45734_n11460# gd gd sg13_lv_nmos ad=0.2375p pd=1.63u as=0.2375p ps=1.63u w=1.25u l=0.13u
X234 VP f3 a_4722_2110# VP sg13_lv_pmos ad=0.1005p pd=1.34u as=0.1005p ps=1.34u w=0.15u l=0.13u
X235 a_46598_6964# a_45996_6964# VP VP sg13_lv_pmos ad=0.2375p pd=1.63u as=0.2375p ps=1.63u w=1.25u l=0.13u
X236 vco_core_1_0.vco_delay_cell_1$1_2.in vco_core_1_0.out a_37196_3420# vco_passgate_3.OI sg13_lv_pmos ad=0.114p pd=0.98u as=0.204p ps=1.88u w=0.6u l=0.7u
X237 a_41855_n914# vco_core_0_0.in gd gd sg13_lv_nmos ad=76f pd=0.78u as=0.136p ps=1.48u w=0.4u l=0.56u
X238 vco_core_4_0.vco_delay_cell_4_1.dn vco_core_4_0.vco_delay_cell_4_1.in vco_core_4_0.vco_delay_cell_4_0.in gd sg13_lv_nmos ad=0.272p pd=2.28u as=0.272p ps=2.28u w=0.8u l=15u
X239 vco_core_3_0.vco_delay_cell_3_9.in vco_core_3_0.out a_23442_n5509# gd sg13_lv_nmos ad=0.272p pd=2.28u as=0.272p ps=2.28u w=0.8u l=8.5u
X240 a_45996_6964# a_45394_7089# gd gd sg13_lv_nmos ad=0.425p pd=3.18u as=0.2375p ps=1.63u w=1.25u l=0.13u
X241 VP a_45996_6964# a_46598_6964# VP sg13_lv_pmos ad=0.2375p pd=1.63u as=0.425p ps=3.18u w=1.25u l=0.13u
X242 a_42467_n486# vco_core_0_0.vco_delay_cell_0$1_0.pgt vco_core_0_0.vp vco_core_0_0.vp sg13_lv_pmos ad=0.114p pd=0.98u as=0.204p ps=1.88u w=0.6u l=0.56u
X243 gd a_45394_7089# a_45996_6964# gd sg13_lv_nmos ad=0.2375p pd=1.63u as=0.425p ps=3.18u w=1.25u l=0.13u
X244 VCO_decoder_cells_0.VCO3_selection_0.NAND_4in_dek_1.d VCO_decoder_cells_0.110 a_10630_n428# gd sg13_lv_nmos ad=0.1005p pd=1.34u as=0.1005p ps=1.34u w=0.15u l=0.13u
X245 out inverter_x1_2.IN 0_buf_1.out gd sg13_lv_nmos ad=0.1005p pd=1.34u as=0.1005p ps=1.34u w=0.15u l=0.13u
X246 VCO_MUX_0.VCO3_in a_46598_6964# VP VP sg13_lv_pmos ad=0.2375p pd=1.63u as=0.2375p ps=1.63u w=1.25u l=0.13u
X247 vco_core_3_0.vco_delay_cell_3_0.in NOR_2in$1_0.A vco_core_3_0.vco_delay_cell_3_1.out gd sg13_lv_nmos ad=0.102p pd=1.28u as=0.102p ps=1.28u w=0.3u l=0.15u
X248 VP a_44362_3221# a_44964_2717# VP sg13_lv_pmos ad=0.11875p pd=1.005u as=0.2125p ps=1.93u w=0.625u l=0.13u
X249 VP c1 VCO_decoder_cells_0.3bit_to_8_outs_0.NAND_3in_dek_6.y VP sg13_lv_pmos ad=0.1005p pd=1.34u as=0.1005p ps=1.34u w=0.15u l=0.13u
X250 VCO_decoder_cells_0.VCO2_selection_0.NAND_4in_dek_1.c VCO_decoder_cells_0.110 a_9993_n3464# gd sg13_lv_nmos ad=0.1005p pd=1.34u as=0.1005p ps=1.34u w=0.15u l=0.13u
X251 0_buf_1.out a_45734_n11460# gd gd sg13_lv_nmos ad=0.425p pd=3.18u as=0.2375p ps=1.63u w=1.25u l=0.13u
X252 vco_core_3_0.vco_delay_cell_3_2.in vco_core_3_0.vco_delay_cell_3_3.in a_30922_n7843# vco_passgate_1.OI sg13_lv_pmos ad=0.408p pd=3.08u as=0.408p ps=3.08u w=1.2u l=8.5u
X253 VP VCO_decoder_cells_0.after_000011 VCO_decoder_cells_0.VCO4_selection_0.NAND_4in_dek_0.b VP sg13_lv_pmos ad=0.1005p pd=1.34u as=0.1005p ps=1.34u w=0.15u l=0.13u
X254 PFD_passgate_3.in_p VCO_MUX_0.VCO3_sel gd gd sg13_lv_nmos ad=0.1005p pd=1.34u as=0.1005p ps=1.34u w=0.15u l=0.13u
X255 VP vco_core_1_0.out a_43760_3221# VP sg13_lv_pmos ad=71.25f pd=0.755u as=0.1275p ps=1.43u w=0.375u l=0.13u
X256 a_11106_3010# VCO_decoder_cells_0.VCO3_selection_0.NAND_3in_dek_0.y gd gd sg13_lv_nmos ad=0.1005p pd=1.34u as=0.1005p ps=1.34u w=0.15u l=0.13u
X257 a_45884_n1282# a_45282_n1282# gd gd sg13_lv_nmos ad=0.425p pd=3.18u as=0.2375p ps=1.63u w=1.25u l=0.13u
X258 VCO_MUX_0.VCO2_in a_46168_2592# VP VP sg13_lv_pmos ad=0.2375p pd=1.63u as=0.2375p ps=1.63u w=1.25u l=0.13u
X259 VP a_45943_n5690# 0_buf_0.out VP sg13_lv_pmos ad=0.2375p pd=1.63u as=0.2375p ps=1.63u w=1.25u l=0.13u
X260 a_10630_3010# VCO_decoder_cells_0.after_001111 gd gd sg13_lv_nmos ad=0.1005p pd=1.34u as=0.1005p ps=1.34u w=0.15u l=0.13u
X261 vco_core_1_0.vco_delay_cell_1$1_0.out vco_core_1_0.vco_delay_cell_1$1_0.in a_36108_1356# vco_passgate_3.OI sg13_lv_pmos ad=0.114p pd=0.98u as=0.204p ps=1.88u w=0.6u l=0.7u
X262 VP VCO_decoder_cells_0.000 VCO_decoder_cells_0.VCO5_selection_0.NAND_2in_dek_0.a VP sg13_lv_pmos ad=0.1005p pd=1.34u as=0.1005p ps=1.34u w=0.15u l=0.13u
X263 VP a_46168_2592# VCO_MUX_0.VCO2_in VP sg13_lv_pmos ad=0.2375p pd=1.63u as=0.425p ps=3.18u w=1.25u l=0.13u
X264 a_11359_n3464# VCO_decoder_cells_0.VCO2_selection_0.NAND_3in_dek_2.y a_11143_n3464# gd sg13_lv_nmos ad=0.1005p pd=1.34u as=0.1005p ps=1.34u w=0.15u l=0.13u
X265 vco_core_1_0.out vco_core_1_0.vco_delay_cell_1$1_5.in a_42228_3420# vco_passgate_3.OI sg13_lv_pmos ad=0.114p pd=0.98u as=0.204p ps=1.88u w=0.6u l=0.7u
X266 a_43476_n653# vco_core_0_0.out gd gd sg13_lv_nmos ad=76f pd=0.78u as=0.136p ps=1.48u w=0.4u l=0.13u
X267 a_45884_n1282# a_45282_n1282# gd gd sg13_lv_nmos ad=0.2375p pd=1.63u as=0.2375p ps=1.63u w=1.25u l=0.13u
X268 vco_core_4_0.vco_delay_cell_4_1.dn PFD_passgate_0.B gd gd sg13_lv_nmos ad=0.272p pd=2.28u as=0.272p ps=2.28u w=0.8u l=30u
X269 vco_passgate_4.OI PFD_passgate_3.in_p VP VP sg13_lv_pmos ad=0.11875p pd=1.005u as=0.11875p ps=1.005u w=0.625u l=0.13u
X270 gd a_46168_2592# VCO_MUX_0.VCO2_in gd sg13_lv_nmos ad=0.2375p pd=1.63u as=0.2375p ps=1.63u w=1.25u l=0.13u
X271 gd VCO_decoder_cells_0.VCO_selection_0.NAND_3in_dek_0.c a_4577_n6871# gd sg13_lv_nmos ad=0.1005p pd=1.34u as=0.1005p ps=1.34u w=0.15u l=0.13u
X272 VP a_45943_n5690# 0_buf_0.out VP sg13_lv_pmos ad=0.2375p pd=1.63u as=0.2375p ps=1.63u w=1.25u l=0.13u
X273 VCO_decoder_cells_0.VCO2_selection_0.NAND_4in_dek_0.b VCO_decoder_cells_0.f5_n VP VP sg13_lv_pmos ad=0.1005p pd=1.34u as=0.1005p ps=1.34u w=0.15u l=0.13u
X274 inverter_x1_2.IN VCO_decoder_cells_0.VCO5_selection_0.NAND_2in_dek_0.b VP VP sg13_lv_pmos ad=0.1005p pd=1.34u as=0.1005p ps=1.34u w=0.15u l=0.13u
X275 PFD_passgate_3.B VCO_MUX_0.VCO3_sel vco_in gd sg13_lv_nmos ad=0.102p pd=1.28u as=0.102p ps=1.28u w=0.3u l=0.15u
X276 vco_passgate_1.OI vco_core_3_0.vco_delay_cell_3_0.pgt a_38402_n7843# vco_passgate_1.OI sg13_lv_pmos ad=0.408p pd=3.08u as=0.408p ps=3.08u w=1.2u l=17u
X277 a_41855_n486# vco_core_0_0.vco_delay_cell_0$1_1.in vco_core_0_0.vco_delay_cell_0$1_0.in vco_core_0_0.vp sg13_lv_pmos ad=0.204p pd=1.88u as=0.114p ps=0.98u w=0.6u l=0.28u
X278 vco_core_0_0.vco_delay_cell_0$1_3.in vco_core_0_0.out a_42501_n2486# vco_core_0_0.vp sg13_lv_pmos ad=0.114p pd=0.98u as=0.204p ps=1.88u w=0.6u l=0.28u
X279 a_46598_6964# a_45996_6964# gd gd sg13_lv_nmos ad=0.2375p pd=1.63u as=0.2375p ps=1.63u w=1.25u l=0.13u
X280 VP VCO_decoder_cells_0.3bit_to_8_outs_0.c1_n VCO_decoder_cells_0.3bit_to_8_outs_0.inverter_dek_8.in VP sg13_lv_pmos ad=0.1005p pd=1.34u as=0.1005p ps=1.34u w=0.15u l=0.13u
X281 a_45566_2592# a_44964_2717# VP VP sg13_lv_pmos ad=0.425p pd=3.18u as=0.2375p ps=1.63u w=1.25u l=0.13u
X282 VP VCO_decoder_cells_0.after_001111_n VCO_decoder_cells_0.after_001111 VP sg13_lv_pmos ad=0.1005p pd=1.34u as=0.1005p ps=1.34u w=0.15u l=0.13u
X283 vco_core_0_0.vp vco_core_0_0.vco_delay_cell_0$1_0.pgt a_41209_n2486# vco_core_0_0.vp sg13_lv_pmos ad=0.204p pd=1.88u as=0.114p ps=0.98u w=0.6u l=0.56u
X284 gd a_45996_6964# a_46598_6964# gd sg13_lv_nmos ad=0.2375p pd=1.63u as=0.425p ps=3.18u w=1.25u l=0.13u
X285 a_37194_1826# vco_core_1_0.vco_delay_cell_1$1_0.out vco_core_1_0.vco_delay_cell_1$1_1.out gd sg13_lv_nmos ad=0.136p pd=1.48u as=76f ps=0.78u w=0.4u l=0.7u
X286 VP a_45132_n11460# a_45734_n11460# VP sg13_lv_pmos ad=0.2375p pd=1.63u as=0.425p ps=3.18u w=1.25u l=0.13u
X287 VP VCO_decoder_cells_0.000 VCO_decoder_cells_0.VCO4_selection_0.NAND_3in_dek_1.y VP sg13_lv_pmos ad=0.1005p pd=1.34u as=0.1005p ps=1.34u w=0.15u l=0.13u
X288 VCO_decoder_cells_0.VCO3_selection_0.NAND_3in_dek_4.a VCO_decoder_cells_0.001 a_10630_n902# gd sg13_lv_nmos ad=0.1005p pd=1.34u as=0.1005p ps=1.34u w=0.15u l=0.13u
X289 vco_core_3_0.vco_delay_cell_3_5.in vco_core_3_0.nen11 vco_core_3_0.vco_delay_cell_3_7.out vco_passgate_1.OI sg13_lv_pmos ad=0.102p pd=1.28u as=0.102p ps=1.28u w=0.3u l=0.15u
X290 VCO_MUX_0.VCO3_in a_46598_6964# gd gd sg13_lv_nmos ad=0.2375p pd=1.63u as=0.2375p ps=1.63u w=1.25u l=0.13u
X291 VP a_44964_2717# a_45566_2592# VP sg13_lv_pmos ad=0.2375p pd=1.63u as=0.425p ps=3.18u w=1.25u l=0.13u
X292 gd a_46168_2592# VCO_MUX_0.VCO2_in gd sg13_lv_nmos ad=0.2375p pd=1.63u as=0.2375p ps=1.63u w=1.25u l=0.13u
X293 vco_passgate_0.OI vco_core_4_0.pgt vco_core_4_0.pgt vco_passgate_0.OI sg13_lv_pmos ad=0.408p pd=3.08u as=0.408p ps=3.08u w=1.2u l=30u
X294 a_39506_2990# vco_core_1_0.vco_delay_cell_1$1_2.out vco_core_1_0.vco_delay_cell_1$1_6.in gd sg13_lv_nmos ad=0.136p pd=1.48u as=76f ps=0.78u w=0.4u l=0.7u
X295 vco_passgate_3.OI VCO_MUX_0.VCO2_sel VP gd sg13_lv_nmos ad=0.11875p pd=1.005u as=0.11875p ps=1.005u w=0.625u l=0.13u
X296 vco_core_3_0.vco_delay_cell_3_1.out vco_core_3_0.vco_delay_cell_3_1.in a_38402_n6301# gd sg13_lv_nmos ad=0.272p pd=2.28u as=0.272p ps=2.28u w=0.8u l=8.5u
X297 gd VCO_MUX_0.VCO_sel VCO_MUX_0.inverter_dek_0.out gd sg13_lv_nmos ad=0.1005p pd=1.34u as=0.1005p ps=1.34u w=0.15u l=0.13u
X298 vco_core_3_0.vco_delay_cell_3_4.in vco_core_3_0.vco_delay_cell_3_5.out a_23442_n7843# vco_passgate_1.OI sg13_lv_pmos ad=0.408p pd=3.08u as=0.408p ps=3.08u w=1.2u l=8.5u
X299 VP a_45341_n5690# a_45943_n5690# VP sg13_lv_pmos ad=0.2375p pd=1.63u as=0.425p ps=3.18u w=1.25u l=0.13u
X300 vco_core_2_0.vco_delay_cell_2$6_8.in vco_core_2_0.nen5 vco_core_2_0.vco_delay_cell_2$6_9.out vco_passgate_4.OI sg13_lv_pmos ad=0.102p pd=1.28u as=0.102p ps=1.28u w=0.3u l=0.15u
X301 vco_core_4_0.vco_delay_cell_4_10.out vco_core_4_0.vco_delay_cell_4_9.out vco_core_4_0.vco_delay_cell_4_10.up vco_passgate_0.OI sg13_lv_pmos ad=0.408p pd=3.08u as=0.408p ps=3.08u w=1.2u l=15u
X302 VCO_decoder_cells_0.VCO4_selection_0.NAND_4in_dek_0.d VCO_decoder_cells_0.011 VP VP sg13_lv_pmos ad=0.1005p pd=1.34u as=0.1005p ps=1.34u w=0.15u l=0.13u
X303 VCO_decoder_cells_0.3bit_to_8_outs_0.inverter_dek_10.in c0 VP VP sg13_lv_pmos ad=0.1005p pd=1.34u as=0.1005p ps=1.34u w=0.15u l=0.13u
X304 0_buf_1.out a_45734_n11460# VP VP sg13_lv_pmos ad=0.2375p pd=1.63u as=0.2375p ps=1.63u w=1.25u l=0.13u
X305 vco_core_4_0.vco_delay_cell_4_4.dn vco_core_4_0.vco_delay_cell_4_4.in vco_core_4_0.vco_delay_cell_4_3.in gd sg13_lv_nmos ad=0.272p pd=2.28u as=0.272p ps=2.28u w=0.8u l=15u
X306 gd PFD_passgate_1.B a_34662_n5509# gd sg13_lv_nmos ad=0.272p pd=2.28u as=0.272p ps=2.28u w=0.8u l=17u
X307 VP vco_core_0_0.out a_43476_n653# VP sg13_lv_pmos ad=71.25f pd=0.755u as=71.25f ps=0.755u w=0.375u l=0.13u
X308 gd VCO_decoder_cells_0.000000_n a_5000_n4888# gd sg13_lv_nmos ad=0.1005p pd=1.34u as=0.1005p ps=1.34u w=0.15u l=0.13u
X309 gd f5 VCO_decoder_cells_0.f5_n gd sg13_lv_nmos ad=0.1005p pd=1.34u as=0.1005p ps=1.34u w=0.15u l=0.13u
X310 VCO_decoder_cells_0.VCO2_selection_0.NAND_2in_dek_0.y VCO_decoder_cells_0.100 a_10463_n5894# gd sg13_lv_nmos ad=0.1005p pd=1.34u as=0.1005p ps=1.34u w=0.15u l=0.13u
X311 VCO_MUX_0.VCO_in a_45884_n1282# VP VP sg13_lv_pmos ad=0.2375p pd=1.63u as=0.2375p ps=1.63u w=1.25u l=0.13u
X312 gd a_45884_n1282# VCO_MUX_0.VCO_in gd sg13_lv_nmos ad=0.2375p pd=1.63u as=0.2375p ps=1.63u w=1.25u l=0.13u
X313 a_4211_n3392# VCO_decoder_cells_0.3bit_to_8_outs_0.c2_n gd gd sg13_lv_nmos ad=0.1005p pd=1.34u as=0.1005p ps=1.34u w=0.15u l=0.13u
X314 gd a_45132_n11460# a_45734_n11460# gd sg13_lv_nmos ad=0.2375p pd=1.63u as=0.2375p ps=1.63u w=1.25u l=0.13u
X315 a_44137_n5061# a_43535_n5061# gd gd sg13_lv_nmos ad=0.114p pd=0.98u as=0.204p ps=1.88u w=0.6u l=0.13u
X316 VP VCO_decoder_cells_0.after_000011 VCO_decoder_cells_0.VCO2_selection_0.NAND_4in_dek_0.d VP sg13_lv_pmos ad=0.1005p pd=1.34u as=0.1005p ps=1.34u w=0.15u l=0.13u
X317 gd f2 VCO_decoder_cells_0.row_section_decoding_0.NAND_2in_dek_0.a gd sg13_lv_nmos ad=0.1005p pd=1.34u as=0.1005p ps=1.34u w=0.15u l=0.13u
X318 VP a_45884_n1282# VCO_MUX_0.VCO_in VP sg13_lv_pmos ad=0.2375p pd=1.63u as=0.2375p ps=1.63u w=1.25u l=0.13u
X319 vco_passgate_0.OI vco_core_4_0.pgt vco_core_4_0.vco_delay_cell_4_10.up vco_passgate_0.OI sg13_lv_pmos ad=0.408p pd=3.08u as=0.408p ps=3.08u w=1.2u l=30u
X320 VP a_44190_7593# a_44792_7593# VP sg13_lv_pmos ad=0.114p pd=0.98u as=0.114p ps=0.98u w=0.6u l=0.13u
X321 a_44964_2717# a_44362_3221# gd gd sg13_lv_nmos ad=0.11875p pd=1.005u as=0.11875p ps=1.005u w=0.625u l=0.13u
X322 vco_core_0_0.vco_delay_cell_0$1_3.in vco_core_0_0.out a_42501_n2018# gd sg13_lv_nmos ad=76f pd=0.78u as=0.136p ps=1.48u w=0.4u l=0.28u
X323 VP VCO_decoder_cells_0.after_001111_n VCO_decoder_cells_0.VCO2_selection_0.NAND_4in_dek_0.a VP sg13_lv_pmos ad=0.1005p pd=1.34u as=0.1005p ps=1.34u w=0.15u l=0.13u
X324 gd vco_passgate_1.en_ vco_passgate_1.OI gd sg13_lv_nmos ad=0.102p pd=1.28u as=0.102p ps=1.28u w=0.3u l=0.13u
X325 vco_core_1_0.vco_delay_cell_1$1_0.pgt PFD_passgate_4.B gd gd sg13_lv_nmos ad=76f pd=0.78u as=0.136p ps=1.48u w=0.4u l=1.4u
X326 a_10630_n428# VCO_decoder_cells_0.000000 gd gd sg13_lv_nmos ad=0.1005p pd=1.34u as=0.1005p ps=1.34u w=0.15u l=0.13u
X327 a_10673_n3938# VCO_decoder_cells_0.after_000011 a_10457_n3938# gd sg13_lv_nmos ad=0.1005p pd=1.34u as=0.1005p ps=1.34u w=0.15u l=0.13u
X328 VCO_MUX_0.VCO_in VCO_MUX_0.VCO_sel out gd sg13_lv_nmos ad=95f pd=0.88u as=95f ps=0.88u w=0.5u l=0.13u
X329 a_3531_n1748# c2 gd gd sg13_lv_nmos ad=0.1005p pd=1.34u as=0.1005p ps=1.34u w=0.15u l=0.13u
X330 VP VCO_decoder_cells_0.after_000011_n VCO_decoder_cells_0.VCO4_selection_0.NAND_2in_dek_0.y VP sg13_lv_pmos ad=0.1005p pd=1.34u as=0.1005p ps=1.34u w=0.15u l=0.13u
X331 vco_passgate_1.OI vco_passgate_1.en_ VP VP sg13_lv_pmos ad=0.2125p pd=1.93u as=0.11875p ps=1.005u w=0.625u l=0.13u
X332 VP a_44137_n5061# a_44739_n5565# VP sg13_lv_pmos ad=0.11875p pd=1.005u as=0.11875p ps=1.005u w=0.625u l=0.13u
X333 a_37196_1356# vco_core_1_0.vco_delay_cell_1$1_0.pgt vco_passgate_3.OI vco_passgate_3.OI sg13_lv_pmos ad=0.114p pd=0.98u as=0.204p ps=1.88u w=0.6u l=1.4u
X334 VCO_decoder_cells_0.VCO3_selection_0.NAND_3in_dek_4.b VCO_decoder_cells_0.010 VP VP sg13_lv_pmos ad=0.1005p pd=1.34u as=0.1005p ps=1.34u w=0.15u l=0.13u
X335 VP a_45996_6964# a_46598_6964# VP sg13_lv_pmos ad=0.2375p pd=1.63u as=0.2375p ps=1.63u w=1.25u l=0.13u
X336 VCO_decoder_cells_0.VCO3_11_sel VCO_decoder_cells_0.VCO3_selection_0.inverter_dek_0.out a_11526_1054# gd sg13_lv_nmos ad=0.1005p pd=1.34u as=0.1005p ps=1.34u w=0.15u l=0.13u
X337 out VCO_MUX_0.VCO_sel VCO_MUX_0.VCO_in gd sg13_lv_nmos ad=95f pd=0.88u as=0.17p ps=1.68u w=0.5u l=0.13u
X338 0_buf_1.out a_45734_n11460# VP VP sg13_lv_pmos ad=0.2375p pd=1.63u as=0.2375p ps=1.63u w=1.25u l=0.13u
X339 vco_core_4_0.vco_delay_cell_4_0.dn vco_core_4_0.vco_delay_cell_4_0.in vco_core_4_0.vco_delay_cell_4_0.out gd sg13_lv_nmos ad=0.272p pd=2.28u as=0.272p ps=2.28u w=0.8u l=15u
X340 a_9777_n7436# VCO_decoder_cells_0.after_000011_n gd gd sg13_lv_nmos ad=0.1005p pd=1.34u as=0.1005p ps=1.34u w=0.15u l=0.13u
X341 vco_core_2_0.vco_delay_cell_2$6_3.in vco_core_2_0.vco_delay_cell_2$6_6.out a_36021_6360# gd sg13_lv_nmos ad=0.272p pd=2.28u as=0.272p ps=2.28u w=0.8u l=2.5u
X342 PFD_passgate_4.in_p VCO_MUX_0.VCO2_sel VP VP sg13_lv_pmos ad=0.1005p pd=1.34u as=0.1005p ps=1.34u w=0.15u l=0.13u
X343 vco_core_1_0.vco_delay_cell_1$1_0.in VCO_decoder_cells_0.VCO2_11_sel vco_core_1_0.vco_delay_cell_1$1_6.out gd sg13_lv_nmos ad=0.102p pd=1.28u as=0.102p ps=1.28u w=0.3u l=0.15u
X344 VP a_46168_2592# VCO_MUX_0.VCO2_in VP sg13_lv_pmos ad=0.2375p pd=1.63u as=0.2375p ps=1.63u w=1.25u l=0.13u
X345 VCO_decoder_cells_0.VCO_selection_0.NAND_3in_dek_0.c VCO_decoder_cells_0.101 VP VP sg13_lv_pmos ad=0.1005p pd=1.34u as=0.1005p ps=1.34u w=0.15u l=0.13u
X346 gd a_45943_n5690# 0_buf_0.out gd sg13_lv_nmos ad=0.2375p pd=1.63u as=0.2375p ps=1.63u w=1.25u l=0.13u
X347 gd vco_core_2_0.out a_44190_7593# gd sg13_lv_nmos ad=0.136p pd=1.48u as=76f ps=0.78u w=0.4u l=0.13u
X348 a_37196_3420# vco_core_1_0.vco_delay_cell_1$1_0.pgt vco_passgate_3.OI vco_passgate_3.OI sg13_lv_pmos ad=0.114p pd=0.98u as=0.204p ps=1.88u w=0.6u l=1.4u
X349 gd VCO_decoder_cells_0.row_section_decoding_0.NAND_3in_dek_0.c a_3300_n350# gd sg13_lv_nmos ad=0.1005p pd=1.34u as=0.1005p ps=1.34u w=0.15u l=0.13u
X350 gd a_45282_n1282# a_45884_n1282# gd sg13_lv_nmos ad=0.2375p pd=1.63u as=0.2375p ps=1.63u w=1.25u l=0.13u
X351 VP a_44680_n1157# a_45282_n1282# VP sg13_lv_pmos ad=0.2375p pd=1.63u as=0.2375p ps=1.63u w=1.25u l=0.13u
X352 vco_passgate_1.OI vco_core_3_0.vco_delay_cell_3_0.pgt a_39218_n4047# vco_passgate_1.OI sg13_lv_pmos ad=0.408p pd=3.08u as=0.408p ps=3.08u w=1.2u l=17u
X353 0_buf_0.out a_45943_n5690# VP VP sg13_lv_pmos ad=0.2375p pd=1.63u as=0.2375p ps=1.63u w=1.25u l=0.13u
X354 VCO_MUX_0.VCO2_in a_46168_2592# VP VP sg13_lv_pmos ad=0.2375p pd=1.63u as=0.2375p ps=1.63u w=1.25u l=0.13u
X355 vco_passgate_0.OI vco_core_4_0.pgt vco_core_4_0.vco_delay_cell_4_9.up vco_passgate_0.OI sg13_lv_pmos ad=0.408p pd=3.08u as=0.408p ps=3.08u w=1.2u l=30u
X356 VCO_MUX_0.VCO2_in a_46168_2592# gd gd sg13_lv_nmos ad=0.425p pd=3.18u as=0.2375p ps=1.63u w=1.25u l=0.13u
X357 vco_core_4_0.vco_delay_cell_4_5.dn 0_buf_1.in vco_core_4_0.vco_delay_cell_4_4.in gd sg13_lv_nmos ad=0.272p pd=2.28u as=0.272p ps=2.28u w=0.8u l=15u
X358 VCO_decoder_cells_0.VCO2_5_sel VCO_decoder_cells_0.VCO2_selection_0.NAND_4in_dek_0.d VP VP sg13_lv_pmos ad=0.1005p pd=1.34u as=0.1005p ps=1.34u w=0.15u l=0.13u
X359 gd PFD_passgate_3.B a_40101_7152# gd sg13_lv_nmos ad=0.272p pd=2.28u as=0.272p ps=2.28u w=0.8u l=5u
X360 VCO_decoder_cells_0.010 VCO_decoder_cells_0.3bit_to_8_outs_0.NAND_3in_dek_6.y gd gd sg13_lv_nmos ad=0.1005p pd=1.34u as=0.1005p ps=1.34u w=0.15u l=0.13u
X361 VP a_44792_7593# a_45394_7089# VP sg13_lv_pmos ad=0.11875p pd=1.005u as=0.11875p ps=1.005u w=0.625u l=0.13u
X362 a_43760_3221# vco_core_1_0.out gd gd sg13_lv_nmos ad=76f pd=0.78u as=0.136p ps=1.48u w=0.4u l=0.13u
X363 0_buf_0.out a_45943_n5690# VP VP sg13_lv_pmos ad=0.2375p pd=1.63u as=0.2375p ps=1.63u w=1.25u l=0.13u
X364 a_3986_2110# f5 VCO_decoder_cells_0.row_section_decoding_0.NAND_2in_dek_0.b VP sg13_lv_pmos ad=0.1005p pd=1.34u as=0.1005p ps=1.34u w=0.15u l=0.13u
X365 VP PFD_passgate_2.in_p vco_core_0_0.vp VP sg13_lv_pmos ad=0.11875p pd=1.005u as=0.11875p ps=1.005u w=0.625u l=0.13u
X366 VP inverter_x1_2.OUT vco_passgate_0.OI VP sg13_lv_pmos ad=0.11875p pd=1.005u as=0.2125p ps=1.93u w=0.625u l=0.13u
X367 VCO_decoder_cells_0.VCO3_selection_0.inverter_dek_1.in VCO_decoder_cells_0.VCO3_selection_0.NAND_3in_dek_3.y VP VP sg13_lv_pmos ad=0.1005p pd=1.34u as=0.1005p ps=1.34u w=0.15u l=0.13u
X368 a_10630_n902# f5 gd gd sg13_lv_nmos ad=0.1005p pd=1.34u as=0.1005p ps=1.34u w=0.15u l=0.13u
X369 VP vco_core_1_0.out a_43760_3221# VP sg13_lv_pmos ad=71.25f pd=0.755u as=71.25f ps=0.755u w=0.375u l=0.13u
X370 VP VCO_decoder_cells_0.110 VCO_decoder_cells_0.VCO_selection_0.NAND_3in_dek_0.b VP sg13_lv_pmos ad=0.1005p pd=1.34u as=0.1005p ps=1.34u w=0.15u l=0.13u
X371 a_42228_3420# vco_core_1_0.vco_delay_cell_1$1_0.pgt vco_passgate_3.OI vco_passgate_3.OI sg13_lv_pmos ad=0.114p pd=0.98u as=0.204p ps=1.88u w=0.6u l=1.4u
X372 vco_core_1_0.vco_delay_cell_1$1_6.in vco_core_1_0.vco_delay_cell_1$1_2.out a_39506_2990# gd sg13_lv_nmos ad=76f pd=0.78u as=0.136p ps=1.48u w=0.4u l=0.7u
X373 VCO_decoder_cells_0.VCO3_selection_0.NAND_4in_dek_1.a VCO_decoder_cells_0.VCO3_selection_0.inverter_dek_1.in VP VP sg13_lv_pmos ad=0.1005p pd=1.34u as=0.1005p ps=1.34u w=0.15u l=0.13u
X374 gd a_45996_6964# a_46598_6964# gd sg13_lv_nmos ad=0.2375p pd=1.63u as=0.2375p ps=1.63u w=1.25u l=0.13u
X375 VCO_decoder_cells_0.000000_n VCO_decoder_cells_0.row_section_decoding_0.NAND_3in_dek_0.b VP VP sg13_lv_pmos ad=0.1005p pd=1.34u as=0.1005p ps=1.34u w=0.15u l=0.13u
X376 VCO_decoder_cells_0.VCO3_selection_0.NAND_3in_dek_0.y VCO_decoder_cells_0.f5_n VP VP sg13_lv_pmos ad=0.1005p pd=1.34u as=0.1005p ps=1.34u w=0.15u l=0.13u
X377 VP VCO_decoder_cells_0.000000_n VCO_decoder_cells_0.VCO3_selection_0.NAND_4in_dek_1.b VP sg13_lv_pmos ad=0.1005p pd=1.34u as=0.1005p ps=1.34u w=0.15u l=0.13u
X378 a_4784_n4888# VCO_decoder_cells_0.010 VCO_decoder_cells_0.VCO4_selection_0.NAND_3in_dek_0.y gd sg13_lv_nmos ad=0.1005p pd=1.34u as=0.1005p ps=1.34u w=0.15u l=0.13u
X379 VCO_decoder_cells_0.after_000111_n f5 gd gd sg13_lv_nmos ad=0.1005p pd=1.34u as=0.1005p ps=1.34u w=0.15u l=0.13u
X380 VCO_decoder_cells_0.VCO3_11_sel VCO_decoder_cells_0.VCO3_selection_0.NAND_4in_dek_0.d VP VP sg13_lv_pmos ad=0.1005p pd=1.34u as=0.1005p ps=1.34u w=0.15u l=0.13u
X381 VCO_MUX_0.VCO2_sel inverter_x1_12.IN VP VP sg13_lv_pmos ad=0.1005p pd=1.34u as=0.1005p ps=1.34u w=0.15u l=0.13u
X382 gd a_46168_2592# VCO_MUX_0.VCO2_in gd sg13_lv_nmos ad=0.2375p pd=1.63u as=0.2375p ps=1.63u w=1.25u l=0.13u
X383 VP f4 a_3986_2110# VP sg13_lv_pmos ad=0.1005p pd=1.34u as=0.1005p ps=1.34u w=0.15u l=0.13u
X384 VCO_decoder_cells_0.VCO3_selection_0.NAND_3in_dek_3.y VCO_decoder_cells_0.011 VP VP sg13_lv_pmos ad=0.1005p pd=1.34u as=0.1005p ps=1.34u w=0.15u l=0.13u
X385 VCO_decoder_cells_0.3bit_to_8_outs_0.NAND_3in_dek_3.y c0 a_4427_n1748# gd sg13_lv_nmos ad=0.1005p pd=1.34u as=0.1005p ps=1.34u w=0.15u l=0.13u
X386 a_9777_n5420# VCO_decoder_cells_0.after_000111_n gd gd sg13_lv_nmos ad=0.1005p pd=1.34u as=0.1005p ps=1.34u w=0.15u l=0.13u
X387 VCO_MUX_0.VCO_in a_45884_n1282# gd gd sg13_lv_nmos ad=0.2375p pd=1.63u as=0.2375p ps=1.63u w=1.25u l=0.13u
X388 gd a_44739_n5565# a_45341_n5690# gd sg13_lv_nmos ad=0.2375p pd=1.63u as=0.425p ps=3.18u w=1.25u l=0.13u
X389 VP vco_passgate_1.en VCO_MUX_0.passgate_scaled_2.en_ VP sg13_lv_pmos ad=0.1005p pd=1.34u as=0.1005p ps=1.34u w=0.15u l=0.13u
X390 VP a_45884_n1282# VCO_MUX_0.VCO_in VP sg13_lv_pmos ad=0.2375p pd=1.63u as=0.2375p ps=1.63u w=1.25u l=0.13u
X391 a_41209_n2486# vco_core_0_0.vco_delay_cell_0$1_0.pgt vco_core_0_0.vp vco_core_0_0.vp sg13_lv_pmos ad=0.114p pd=0.98u as=0.204p ps=1.88u w=0.6u l=0.56u
X392 VCO_decoder_cells_0.000 VCO_decoder_cells_0.3bit_to_8_outs_0.inverter_dek_8.in VP VP sg13_lv_pmos ad=0.1005p pd=1.34u as=0.1005p ps=1.34u w=0.15u l=0.13u
X393 a_44739_n5565# a_44137_n5061# VP VP sg13_lv_pmos ad=0.11875p pd=1.005u as=0.11875p ps=1.005u w=0.625u l=0.13u
X394 VP VCO_decoder_cells_0.after_000111 VCO_decoder_cells_0.VCO3_selection_0.NAND_3in_dek_3.y VP sg13_lv_pmos ad=0.1005p pd=1.34u as=0.1005p ps=1.34u w=0.15u l=0.13u
X395 VCO_MUX_0.VCO_in a_45884_n1282# gd gd sg13_lv_nmos ad=0.2375p pd=1.63u as=0.2375p ps=1.63u w=1.25u l=0.13u
X396 VCO_MUX_0.VCO_in a_45884_n1282# VP VP sg13_lv_pmos ad=0.2375p pd=1.63u as=0.2375p ps=1.63u w=1.25u l=0.13u
X397 gd PFD_passgate_1.B a_38402_n6301# gd sg13_lv_nmos ad=0.272p pd=2.28u as=0.272p ps=2.28u w=0.8u l=17u
X398 VP a_43760_3221# a_44362_3221# VP sg13_lv_pmos ad=0.114p pd=0.98u as=0.114p ps=0.98u w=0.6u l=0.13u
X399 VCO_decoder_cells_0.VCO3_selection_0.NAND_4in_dek_0.d VCO_decoder_cells_0.100 a_11310_1528# gd sg13_lv_nmos ad=0.1005p pd=1.34u as=0.1005p ps=1.34u w=0.15u l=0.13u
X400 VCO_decoder_cells_0.110 VCO_decoder_cells_0.3bit_to_8_outs_0.inverter_dek_1.in VP VP sg13_lv_pmos ad=0.1005p pd=1.34u as=0.1005p ps=1.34u w=0.15u l=0.13u
X401 vco_core_0_0.vp vco_core_0_0.vco_delay_cell_0$1_0.pgt a_42501_n2486# vco_core_0_0.vp sg13_lv_pmos ad=0.204p pd=1.88u as=0.114p ps=0.98u w=0.6u l=0.56u
X402 a_9993_n3938# VCO_decoder_cells_0.after_000111 a_9777_n3938# gd sg13_lv_nmos ad=0.1005p pd=1.34u as=0.1005p ps=1.34u w=0.15u l=0.13u
X403 a_45132_n11460# a_44530_n11335# VP VP sg13_lv_pmos ad=0.425p pd=3.18u as=0.2375p ps=1.63u w=1.25u l=0.13u
X404 inverter_x1_12.IN VCO_decoder_cells_0.VCO2_5_sel a_31345_3300# VP sg13_lv_pmos ad=0.1005p pd=1.34u as=55.5f ps=0.74u w=0.15u l=0.13u
X405 VCO_MUX_0.VCO_in a_45884_n1282# gd gd sg13_lv_nmos ad=0.2375p pd=1.63u as=0.2375p ps=1.63u w=1.25u l=0.13u
X406 VCO_decoder_cells_0.VCO3_selection_0.NAND_3in_dek_0.y VCO_decoder_cells_0.001 VP VP sg13_lv_pmos ad=0.1005p pd=1.34u as=0.1005p ps=1.34u w=0.15u l=0.13u
X407 vco_core_1_0.vco_delay_cell_1$1_7.in vco_core_1_0.vco_delay_cell_1$1_1.out a_38352_1356# vco_passgate_3.OI sg13_lv_pmos ad=0.114p pd=0.98u as=0.204p ps=1.88u w=0.6u l=0.7u
X408 a_43326_n10831# 0_buf_1.in VP VP sg13_lv_pmos ad=0.1275p pd=1.43u as=71.25f ps=0.755u w=0.375u l=0.13u
X409 VP vco_passgate_1.en_ vco_passgate_1.OI VP sg13_lv_pmos ad=0.11875p pd=1.005u as=0.2125p ps=1.93u w=0.625u l=0.13u
X410 0_buf_0.out a_45943_n5690# gd gd sg13_lv_nmos ad=0.425p pd=3.18u as=0.2375p ps=1.63u w=1.25u l=0.13u
X411 gd VCO_decoder_cells_0.after_001111_n a_5000_n5362# gd sg13_lv_nmos ad=0.1005p pd=1.34u as=0.1005p ps=1.34u w=0.15u l=0.13u
X412 VP a_45566_2592# a_46168_2592# VP sg13_lv_pmos ad=0.2375p pd=1.63u as=0.2375p ps=1.63u w=1.25u l=0.13u
X413 VCO_decoder_cells_0.3bit_to_8_outs_0.NAND_3in_dek_6.y VCO_decoder_cells_0.3bit_to_8_outs_0.c2_n VP VP sg13_lv_pmos ad=0.1005p pd=1.34u as=0.1005p ps=1.34u w=0.15u l=0.13u
X414 vco_core_4_0.vco_delay_cell_4_0.up vco_core_4_0.pgt vco_passgate_0.OI vco_passgate_0.OI sg13_lv_pmos ad=0.408p pd=3.08u as=0.408p ps=3.08u w=1.2u l=30u
X415 a_3300_n350# VCO_decoder_cells_0.row_section_decoding_0.NAND_3in_dek_0.b a_3084_n350# gd sg13_lv_nmos ad=0.1005p pd=1.34u as=0.1005p ps=1.34u w=0.15u l=0.13u
X416 a_45734_n11460# a_45132_n11460# gd gd sg13_lv_nmos ad=0.2375p pd=1.63u as=0.2375p ps=1.63u w=1.25u l=0.13u
X417 VCO_decoder_cells_0.3bit_to_8_outs_0.c2_n c2 gd gd sg13_lv_nmos ad=0.1005p pd=1.34u as=0.1005p ps=1.34u w=0.15u l=0.13u
X418 a_4427_n3074# c1 a_4211_n3074# gd sg13_lv_nmos ad=0.1005p pd=1.34u as=0.1005p ps=1.34u w=0.15u l=0.13u
X419 a_43535_n5061# vco_core_3_0.out VP VP sg13_lv_pmos ad=0.1275p pd=1.43u as=71.25f ps=0.755u w=0.375u l=0.13u
X420 vco_core_3_0.vco_delay_cell_3_7.out vco_core_3_0.vco_delay_cell_3_7.in a_34662_n4047# vco_passgate_1.OI sg13_lv_pmos ad=0.408p pd=3.08u as=0.408p ps=3.08u w=1.2u l=8.5u
X421 VP VCO_decoder_cells_0.111 VCO_decoder_cells_0.VCO2_selection_0.NAND_4in_dek_1.d VP sg13_lv_pmos ad=0.1005p pd=1.34u as=0.1005p ps=1.34u w=0.15u l=0.13u
X422 a_45132_n11460# a_44530_n11335# VP VP sg13_lv_pmos ad=0.2375p pd=1.63u as=0.2375p ps=1.63u w=1.25u l=0.13u
X423 0_buf_0.out a_45943_n5690# gd gd sg13_lv_nmos ad=0.2375p pd=1.63u as=0.2375p ps=1.63u w=1.25u l=0.13u
X424 a_38350_2990# vco_core_1_0.vco_delay_cell_1$1_2.in vco_core_1_0.vco_delay_cell_1$1_2.out gd sg13_lv_nmos ad=0.136p pd=1.48u as=76f ps=0.78u w=0.4u l=0.7u
X425 VP a_45734_n11460# 0_buf_1.out VP sg13_lv_pmos ad=0.2375p pd=1.63u as=0.425p ps=3.18u w=1.25u l=0.13u
X426 vco_passgate_4.OI VCO_MUX_0.VCO3_sel VP gd sg13_lv_nmos ad=0.11875p pd=1.005u as=0.11875p ps=1.005u w=0.625u l=0.13u
X427 gd a_44078_n653# a_44680_n1157# gd sg13_lv_nmos ad=0.11875p pd=1.005u as=0.11875p ps=1.005u w=0.625u l=0.13u
X428 vco_core_4_0.vco_delay_cell_4_9.out vco_core_4_0.vco_delay_cell_4_0.out vco_core_4_0.vco_delay_cell_4_9.up vco_passgate_0.OI sg13_lv_pmos ad=0.408p pd=3.08u as=0.408p ps=3.08u w=1.2u l=15u
X429 gd PFD_passgate_4.B a_42226_2990# gd sg13_lv_nmos ad=0.136p pd=1.48u as=76f ps=0.78u w=0.4u l=1.4u
X430 VCO_decoder_cells_0.VCO3_selection_0.NAND_4in_dek_1.c VCO_decoder_cells_0.101 a_10630_1054# gd sg13_lv_nmos ad=0.1005p pd=1.34u as=0.1005p ps=1.34u w=0.15u l=0.13u
X431 gd vco_core_0_0.in a_42467_n914# gd sg13_lv_nmos ad=0.136p pd=1.48u as=76f ps=0.78u w=0.4u l=0.56u
X432 VP a_45566_2592# a_46168_2592# VP sg13_lv_pmos ad=0.2375p pd=1.63u as=0.2375p ps=1.63u w=1.25u l=0.13u
X433 VCO_MUX_0.VCO_sel VCO_decoder_cells_0.VCO_selection_0.NAND_3in_dek_0.b VP VP sg13_lv_pmos ad=0.1005p pd=1.34u as=0.1005p ps=1.34u w=0.15u l=0.13u
X434 vco_core_3_0.vco_delay_cell_3_0.in vco_core_3_0.nen5 vco_core_3_0.vco_delay_cell_3_7.out vco_passgate_1.OI sg13_lv_pmos ad=0.102p pd=1.28u as=0.102p ps=1.28u w=0.3u l=0.15u
X435 a_39506_1826# PFD_passgate_4.B gd gd sg13_lv_nmos ad=76f pd=0.78u as=0.136p ps=1.48u w=0.4u l=1.4u
X436 a_44530_n11335# a_43928_n10831# gd gd sg13_lv_nmos ad=0.2125p pd=1.93u as=0.11875p ps=1.005u w=0.625u l=0.13u
X437 a_39506_2990# PFD_passgate_4.B gd gd sg13_lv_nmos ad=76f pd=0.78u as=0.136p ps=1.48u w=0.4u l=1.4u
X438 vco_core_1_0.vco_delay_cell_1$1_3.in vco_core_1_0.vco_delay_cell_1$1_4.in a_40662_1826# gd sg13_lv_nmos ad=76f pd=0.78u as=0.136p ps=1.48u w=0.4u l=0.7u
X439 VCO_decoder_cells_0.after_000011 VCO_decoder_cells_0.row_section_decoding_0.NAND_2in_dek_0.a VP VP sg13_lv_pmos ad=0.1005p pd=1.34u as=0.1005p ps=1.34u w=0.15u l=0.13u
X440 VCO_decoder_cells_0.VCO5_selection_0.NAND_2in_dek_0.b VCO_decoder_cells_0.010 a_10253_n7436# gd sg13_lv_nmos ad=0.1005p pd=1.34u as=0.1005p ps=1.34u w=0.15u l=0.13u
X441 a_44739_n5565# a_44137_n5061# gd gd sg13_lv_nmos ad=0.2125p pd=1.93u as=0.11875p ps=1.005u w=0.625u l=0.13u
X442 gd VCO_decoder_cells_0.after_000011 a_4269_n5362# gd sg13_lv_nmos ad=0.1005p pd=1.34u as=0.1005p ps=1.34u w=0.15u l=0.13u
X443 VCO_MUX_0.VCO3_in a_46598_6964# VP VP sg13_lv_pmos ad=0.2375p pd=1.63u as=0.2375p ps=1.63u w=1.25u l=0.13u
X444 NOR_2in$1_1.Out VCO_decoder_cells_0.VCO3_5_sel gd gd sg13_lv_nmos ad=0.1005p pd=1.34u as=55.5f ps=0.74u w=0.15u l=0.13u
X445 a_46168_2592# a_45566_2592# gd gd sg13_lv_nmos ad=0.2375p pd=1.63u as=0.2375p ps=1.63u w=1.25u l=0.13u
X446 a_10840_1528# VCO_decoder_cells_0.after_000111_n a_10624_1528# gd sg13_lv_nmos ad=0.1005p pd=1.34u as=0.1005p ps=1.34u w=0.15u l=0.13u
X447 VCO_decoder_cells_0.3bit_to_8_outs_0.inverter_dek_1.in c2 VP VP sg13_lv_pmos ad=0.1005p pd=1.34u as=0.1005p ps=1.34u w=0.15u l=0.13u
X448 VP a_45734_n11460# 0_buf_1.out VP sg13_lv_pmos ad=0.2375p pd=1.63u as=0.2375p ps=1.63u w=1.25u l=0.13u
X449 a_9993_n5894# VCO_decoder_cells_0.after_001111_n a_9777_n5894# gd sg13_lv_nmos ad=0.1005p pd=1.34u as=0.1005p ps=1.34u w=0.15u l=0.13u
X450 VCO_decoder_cells_0.VCO2_selection_0.NAND_4in_dek_0.b VCO_decoder_cells_0.101 a_10692_n5420# gd sg13_lv_nmos ad=0.1005p pd=1.34u as=0.1005p ps=1.34u w=0.15u l=0.13u
X451 gd a_45734_n11460# 0_buf_1.out gd sg13_lv_nmos ad=0.2375p pd=1.63u as=0.2375p ps=1.63u w=1.25u l=0.13u
X452 a_45341_n5690# a_44739_n5565# gd gd sg13_lv_nmos ad=0.2375p pd=1.63u as=0.2375p ps=1.63u w=1.25u l=0.13u
X453 a_44078_n653# a_43476_n653# VP VP sg13_lv_pmos ad=0.114p pd=0.98u as=0.114p ps=0.98u w=0.6u l=0.13u
X454 a_44530_n11335# a_43928_n10831# gd gd sg13_lv_nmos ad=0.11875p pd=1.005u as=0.11875p ps=1.005u w=0.625u l=0.13u
X455 NOR_2in$1_0.B VCO_decoder_cells_0.VCO4_selection_0.NAND_3in_dek_0.y VP VP sg13_lv_pmos ad=0.1005p pd=1.34u as=0.1005p ps=1.34u w=0.15u l=0.13u
X456 a_9944_1528# VCO_decoder_cells_0.after_000111_n gd gd sg13_lv_nmos ad=0.1005p pd=1.34u as=0.1005p ps=1.34u w=0.15u l=0.13u
X457 VCO_decoder_cells_0.VCO3_selection_0.inverter_dek_1.in VCO_decoder_cells_0.VCO3_selection_0.NAND_3in_dek_4.a a_11327_n902# gd sg13_lv_nmos ad=0.1005p pd=1.34u as=0.1005p ps=1.34u w=0.15u l=0.13u
X458 gd VCO_decoder_cells_0.110 a_5047_n6871# gd sg13_lv_nmos ad=0.1005p pd=1.34u as=0.1005p ps=1.34u w=0.15u l=0.13u
X459 VCO_MUX_0.VCO3_in a_46598_6964# VP VP sg13_lv_pmos ad=0.2375p pd=1.63u as=0.2375p ps=1.63u w=1.25u l=0.13u
X460 gd f4 VCO_decoder_cells_0.after_001111_n gd sg13_lv_nmos ad=0.1005p pd=1.34u as=0.1005p ps=1.34u w=0.15u l=0.13u
X461 VP VCO_MUX_0.VCO_sel VCO_MUX_0.inverter_dek_0.out VP sg13_lv_pmos ad=0.1005p pd=1.34u as=0.1005p ps=1.34u w=0.15u l=0.13u
X462 VCO_decoder_cells_0.3bit_to_8_outs_0.inverter_dek_10.in c0 a_3747_n3074# gd sg13_lv_nmos ad=0.1005p pd=1.34u as=0.1005p ps=1.34u w=0.15u l=0.13u
X463 a_3747_n3392# VCO_decoder_cells_0.3bit_to_8_outs_0.c1_n a_3531_n3392# gd sg13_lv_nmos ad=0.1005p pd=1.34u as=0.1005p ps=1.34u w=0.15u l=0.13u
X464 gd PFD_passgate_4.B a_40662_1826# gd sg13_lv_nmos ad=0.136p pd=1.48u as=76f ps=0.78u w=0.4u l=1.4u
X465 VP a_46598_6964# VCO_MUX_0.VCO3_in VP sg13_lv_pmos ad=0.2375p pd=1.63u as=0.2375p ps=1.63u w=1.25u l=0.13u
X466 gd PFD_passgate_4.B a_40662_2990# gd sg13_lv_nmos ad=0.136p pd=1.48u as=76f ps=0.78u w=0.4u l=1.4u
X467 gd inverter_x1_2.IN VCO_MUX_0.passgate_scaled_0.en_ gd sg13_lv_nmos ad=0.1005p pd=1.34u as=0.1005p ps=1.34u w=0.15u l=0.13u
X468 a_4784_n5362# VCO_decoder_cells_0.000 VCO_decoder_cells_0.VCO4_selection_0.NAND_3in_dek_1.y gd sg13_lv_nmos ad=0.1005p pd=1.34u as=0.1005p ps=1.34u w=0.15u l=0.13u
X469 vco_core_2_0.vco_delay_cell_2$6_5.out vco_core_2_0.vco_delay_cell_2$6_5.in a_38741_7152# gd sg13_lv_nmos ad=0.272p pd=2.28u as=0.272p ps=2.28u w=0.8u l=2.5u
X470 gd a_45734_n11460# 0_buf_1.out gd sg13_lv_nmos ad=0.2375p pd=1.63u as=0.2375p ps=1.63u w=1.25u l=0.13u
X471 a_10996_n5894# VCO_decoder_cells_0.VCO2_selection_0.NAND_4in_dek_0.d gd gd sg13_lv_nmos ad=0.1005p pd=1.34u as=0.1005p ps=1.34u w=0.15u l=0.13u
X472 a_45394_7089# a_44792_7593# gd gd sg13_lv_nmos ad=0.2125p pd=1.93u as=0.11875p ps=1.005u w=0.625u l=0.13u
X473 VP VCO_decoder_cells_0.after_000111 VCO_decoder_cells_0.VCO3_selection_0.NAND_3in_dek_0.y VP sg13_lv_pmos ad=0.1005p pd=1.34u as=0.1005p ps=1.34u w=0.15u l=0.13u
X474 gd NOR_2in$1_0.A vco_core_3_0.nen11 gd sg13_lv_nmos ad=0.1005p pd=1.34u as=0.1005p ps=1.34u w=0.15u l=0.13u
X475 PFD_passgate_4.B PFD_passgate_4.in_p vco_in VP sg13_lv_pmos ad=0.102p pd=1.28u as=0.102p ps=1.28u w=0.3u l=0.15u
X476 vco_passgate_1.OI vco_core_3_0.vco_delay_cell_3_0.pgt a_30922_n4047# vco_passgate_1.OI sg13_lv_pmos ad=0.408p pd=3.08u as=0.408p ps=3.08u w=1.2u l=17u
X477 VCO_MUX_0.VCO3_in a_46598_6964# gd gd sg13_lv_nmos ad=0.2375p pd=1.63u as=0.2375p ps=1.63u w=1.25u l=0.13u
X478 VP a_45282_n1282# a_45884_n1282# VP sg13_lv_pmos ad=0.2375p pd=1.63u as=0.2375p ps=1.63u w=1.25u l=0.13u
X479 gd a_45282_n1282# a_45884_n1282# gd sg13_lv_nmos ad=0.2375p pd=1.63u as=0.425p ps=3.18u w=1.25u l=0.13u
X480 vco_core_4_0.vco_delay_cell_4_3.up vco_core_4_0.vco_delay_cell_4_3.in vco_core_4_0.vco_delay_cell_4_2.in vco_passgate_0.OI sg13_lv_pmos ad=0.408p pd=3.08u as=0.408p ps=3.08u w=1.2u l=15u
X481 vco_core_4_0.vco_delay_cell_4_7.out vco_core_4_0.vco_delay_cell_4_8.out vco_core_4_0.vco_delay_cell_4_7.up vco_passgate_0.OI sg13_lv_pmos ad=0.408p pd=3.08u as=0.408p ps=3.08u w=1.2u l=15u
X482 vco_core_2_0.vco_delay_cell_2$6_8.in VCO_decoder_cells_0.VCO3_5_sel vco_core_2_0.vco_delay_cell_2$6_9.out gd sg13_lv_nmos ad=0.102p pd=1.28u as=0.102p ps=1.28u w=0.3u l=0.15u
X483 vco_core_2_0.vco_delay_cell_2$6_1.in vco_core_2_0.vco_delay_cell_2$6_2.in a_38741_4818# vco_passgate_4.OI sg13_lv_pmos ad=0.408p pd=3.08u as=0.408p ps=3.08u w=1.2u l=2.5u
X484 a_3084_n350# VCO_decoder_cells_0.row_section_decoding_0.NAND_3in_dek_0.a VCO_decoder_cells_0.000000_n gd sg13_lv_nmos ad=0.1005p pd=1.34u as=0.1005p ps=1.34u w=0.15u l=0.13u
X485 0_buf_0.out a_45943_n5690# VP VP sg13_lv_pmos ad=0.2375p pd=1.63u as=0.2375p ps=1.63u w=1.25u l=0.13u
X486 a_45884_n1282# a_45282_n1282# VP VP sg13_lv_pmos ad=0.2375p pd=1.63u as=0.2375p ps=1.63u w=1.25u l=0.13u
X487 vco_core_0_0.in PFD_passgate_2.in_p vco_in VP sg13_lv_pmos ad=0.102p pd=1.28u as=0.102p ps=1.28u w=0.3u l=0.15u
X488 vco_core_1_0.vco_delay_cell_1$1_2.out vco_core_1_0.vco_delay_cell_1$1_2.in a_38350_2990# gd sg13_lv_nmos ad=76f pd=0.78u as=0.136p ps=1.48u w=0.4u l=0.7u
X489 VCO_decoder_cells_0.VCO3_selection_0.NAND_4in_dek_0.b VCO_decoder_cells_0.010 a_10160_1528# gd sg13_lv_nmos ad=0.1005p pd=1.34u as=0.1005p ps=1.34u w=0.15u l=0.13u
X490 VCO_decoder_cells_0.VCO3_selection_0.NAND_4in_dek_1.b VCO_decoder_cells_0.after_000111_n VP VP sg13_lv_pmos ad=0.1005p pd=1.34u as=0.1005p ps=1.34u w=0.15u l=0.13u
X491 gd PFD_passgate_3.B a_36021_7152# gd sg13_lv_nmos ad=0.272p pd=2.28u as=0.272p ps=2.28u w=0.8u l=5u
X492 VP vco_core_3_0.out a_43535_n5061# VP sg13_lv_pmos ad=71.25f pd=0.755u as=0.1275p ps=1.43u w=0.375u l=0.13u
X493 vco_core_3_0.vco_delay_cell_3_8.in vco_core_3_0.vco_delay_cell_3_9.in a_27182_n5509# gd sg13_lv_nmos ad=0.272p pd=2.28u as=0.272p ps=2.28u w=0.8u l=8.5u
X494 vco_core_2_0.vco_delay_cell_2$6_9.out vco_core_2_0.vco_delay_cell_2$6_5.out a_40101_7152# gd sg13_lv_nmos ad=0.272p pd=2.28u as=0.272p ps=2.28u w=0.8u l=2.5u
X495 a_39508_3420# vco_core_1_0.vco_delay_cell_1$1_2.out vco_core_1_0.vco_delay_cell_1$1_6.in vco_passgate_3.OI sg13_lv_pmos ad=0.204p pd=1.88u as=0.114p ps=0.98u w=0.6u l=0.7u
X496 a_45996_6964# a_45394_7089# VP VP sg13_lv_pmos ad=0.2375p pd=1.63u as=0.2375p ps=1.63u w=1.25u l=0.13u
X497 vco_passgate_3.OI PFD_passgate_4.in_p VP VP sg13_lv_pmos ad=0.2125p pd=1.93u as=0.11875p ps=1.005u w=0.625u l=0.13u
X498 a_10630_1054# VCO_decoder_cells_0.after_000011_n gd gd sg13_lv_nmos ad=0.1005p pd=1.34u as=0.1005p ps=1.34u w=0.15u l=0.13u
X499 out VCO_MUX_0.passgate_scaled_0.en_ 0_buf_1.out VP sg13_lv_pmos ad=0.1005p pd=1.34u as=0.1005p ps=1.34u w=0.15u l=0.13u
X500 VCO_MUX_0.VCO3_in a_46598_6964# gd gd sg13_lv_nmos ad=0.2375p pd=1.63u as=0.2375p ps=1.63u w=1.25u l=0.13u
X501 gd a_45341_n5690# a_45943_n5690# gd sg13_lv_nmos ad=0.2375p pd=1.63u as=0.2375p ps=1.63u w=1.25u l=0.13u
X502 vco_core_2_0.vco_delay_cell_2$6_0.in vco_core_2_0.vco_delay_cell_2$6_1.in a_40101_4818# vco_passgate_4.OI sg13_lv_pmos ad=0.408p pd=3.08u as=0.408p ps=3.08u w=1.2u l=2.5u
X503 VP PFD_passgate_4.in_p vco_passgate_3.OI VP sg13_lv_pmos ad=0.11875p pd=1.005u as=0.2125p ps=1.93u w=0.625u l=0.13u
X504 gd vco_core_0_0.in a_41209_n2018# gd sg13_lv_nmos ad=0.136p pd=1.48u as=76f ps=0.78u w=0.4u l=0.56u
X505 gd a_46598_6964# VCO_MUX_0.VCO3_in gd sg13_lv_nmos ad=0.2375p pd=1.63u as=0.2375p ps=1.63u w=1.25u l=0.13u
X506 gd VCO_decoder_cells_0.after_000011_n a_3583_n5362# gd sg13_lv_nmos ad=0.1005p pd=1.34u as=0.1005p ps=1.34u w=0.15u l=0.13u
X507 VCO_decoder_cells_0.VCO4_selection_0.NAND_4in_dek_0.b VCO_decoder_cells_0.after_000111_n VP VP sg13_lv_pmos ad=0.1005p pd=1.34u as=0.1005p ps=1.34u w=0.15u l=0.13u
X508 VP a_45884_n1282# VCO_MUX_0.VCO_in VP sg13_lv_pmos ad=0.2375p pd=1.63u as=0.425p ps=3.18u w=1.25u l=0.13u
X509 gd a_45341_n5690# a_45943_n5690# gd sg13_lv_nmos ad=0.2375p pd=1.63u as=0.2375p ps=1.63u w=1.25u l=0.13u
X510 VP a_44190_7593# a_44792_7593# VP sg13_lv_pmos ad=0.114p pd=0.98u as=0.204p ps=1.88u w=0.6u l=0.13u
X511 VCO_decoder_cells_0.VCO5_selection_0.NAND_2in_dek_0.a VCO_decoder_cells_0.after_000011_n VP VP sg13_lv_pmos ad=0.1005p pd=1.34u as=0.1005p ps=1.34u w=0.15u l=0.13u
X512 a_45341_n5690# a_44739_n5565# VP VP sg13_lv_pmos ad=0.425p pd=3.18u as=0.2375p ps=1.63u w=1.25u l=0.13u
X513 vco_passgate_1.OI vco_core_3_0.vco_delay_cell_3_0.pgt a_23442_n4047# vco_passgate_1.OI sg13_lv_pmos ad=0.408p pd=3.08u as=0.408p ps=3.08u w=1.2u l=17u
X514 a_43326_n10831# 0_buf_1.in gd gd sg13_lv_nmos ad=76f pd=0.78u as=0.136p ps=1.48u w=0.4u l=0.13u
X515 0_buf_1.in vco_core_4_0.vco_delay_cell_4_7.out vco_core_4_0.vco_delay_cell_4_6.up vco_passgate_0.OI sg13_lv_pmos ad=0.408p pd=3.08u as=0.408p ps=3.08u w=1.2u l=15u
X516 a_11526_n428# VCO_decoder_cells_0.VCO3_selection_0.NAND_4in_dek_1.b a_11310_n428# gd sg13_lv_nmos ad=0.1005p pd=1.34u as=0.1005p ps=1.34u w=0.15u l=0.13u
X517 vco_core_0_0.vco_delay_cell_0$1_0.in vco_core_0_0.vco_delay_cell_0$1_1.in a_41855_n914# gd sg13_lv_nmos ad=76f pd=0.78u as=0.136p ps=1.48u w=0.4u l=0.28u
X518 a_45734_n11460# a_45132_n11460# VP VP sg13_lv_pmos ad=0.425p pd=3.18u as=0.2375p ps=1.63u w=1.25u l=0.13u
X519 a_4577_n6871# VCO_decoder_cells_0.VCO_selection_0.NAND_3in_dek_0.b a_4361_n6871# gd sg13_lv_nmos ad=0.1005p pd=1.34u as=0.1005p ps=1.34u w=0.15u l=0.13u
X520 a_9944_3010# VCO_decoder_cells_0.f5_n gd gd sg13_lv_nmos ad=0.1005p pd=1.34u as=0.1005p ps=1.34u w=0.15u l=0.13u
X521 VP f5 VCO_decoder_cells_0.f5_n VP sg13_lv_pmos ad=0.1005p pd=1.34u as=0.1005p ps=1.34u w=0.15u l=0.13u
X522 a_46598_6964# a_45996_6964# VP VP sg13_lv_pmos ad=0.2375p pd=1.63u as=0.2375p ps=1.63u w=1.25u l=0.13u
X523 a_4722_628# f3 VCO_decoder_cells_0.row_section_decoding_0.NAND_2in_dek_0.a VP sg13_lv_pmos ad=0.1005p pd=1.34u as=0.1005p ps=1.34u w=0.15u l=0.13u
X524 a_42467_n914# vco_core_0_0.in gd gd sg13_lv_nmos ad=76f pd=0.78u as=0.136p ps=1.48u w=0.4u l=0.56u
X525 VCO_MUX_0.VCO_in a_45884_n1282# gd gd sg13_lv_nmos ad=0.2375p pd=1.63u as=0.2375p ps=1.63u w=1.25u l=0.13u
X526 VP a_46598_6964# VCO_MUX_0.VCO3_in VP sg13_lv_pmos ad=0.2375p pd=1.63u as=0.2375p ps=1.63u w=1.25u l=0.13u
X527 a_45996_6964# a_45394_7089# gd gd sg13_lv_nmos ad=0.2375p pd=1.63u as=0.2375p ps=1.63u w=1.25u l=0.13u
X528 gd f1 VCO_decoder_cells_0.row_section_decoding_0.NAND_3in_dek_0.c gd sg13_lv_nmos ad=0.1005p pd=1.34u as=0.1005p ps=1.34u w=0.15u l=0.13u
X529 gd a_44530_n11335# a_45132_n11460# gd sg13_lv_nmos ad=0.2375p pd=1.63u as=0.2375p ps=1.63u w=1.25u l=0.13u
X530 0_buf_1.out a_45734_n11460# gd gd sg13_lv_nmos ad=0.2375p pd=1.63u as=0.2375p ps=1.63u w=1.25u l=0.13u
X531 a_44964_2717# a_44362_3221# VP VP sg13_lv_pmos ad=0.11875p pd=1.005u as=0.11875p ps=1.005u w=0.625u l=0.13u
X532 VCO_MUX_0.VCO2_in a_46168_2592# VP VP sg13_lv_pmos ad=0.2375p pd=1.63u as=0.2375p ps=1.63u w=1.25u l=0.13u
X533 PFD_passgate_2.in_p VCO_MUX_0.VCO_sel VP VP sg13_lv_pmos ad=0.1005p pd=1.34u as=0.1005p ps=1.34u w=0.15u l=0.13u
X534 VP VCO_decoder_cells_0.after_000011 VCO_decoder_cells_0.VCO2_selection_0.NAND_3in_dek_2.y VP sg13_lv_pmos ad=0.1005p pd=1.34u as=0.1005p ps=1.34u w=0.15u l=0.13u
X535 vco_core_3_0.vco_delay_cell_3_3.in vco_core_3_0.vco_delay_cell_3_4.in a_27182_n7843# vco_passgate_1.OI sg13_lv_pmos ad=0.408p pd=3.08u as=0.408p ps=3.08u w=1.2u l=8.5u
X536 VP a_46168_2592# VCO_MUX_0.VCO2_in VP sg13_lv_pmos ad=0.2375p pd=1.63u as=0.2375p ps=1.63u w=1.25u l=0.13u
X537 VP VCO_decoder_cells_0.VCO2_11_sel vco_core_1_0.nen11 VP sg13_lv_pmos ad=0.1005p pd=1.34u as=0.1005p ps=1.34u w=0.15u l=0.13u
X538 VCO_decoder_cells_0.3bit_to_8_outs_0.inverter_dek_6.in c2 VP VP sg13_lv_pmos ad=0.1005p pd=1.34u as=0.1005p ps=1.34u w=0.15u l=0.13u
X539 VP VCO_decoder_cells_0.after_000011 VCO_decoder_cells_0.after_000011_n VP sg13_lv_pmos ad=0.1005p pd=1.34u as=0.1005p ps=1.34u w=0.15u l=0.13u
X540 VP VCO_decoder_cells_0.after_000111_n VCO_decoder_cells_0.VCO2_selection_0.NAND_4in_dek_1.c VP sg13_lv_pmos ad=0.1005p pd=1.34u as=0.1005p ps=1.34u w=0.15u l=0.13u
X541 vco_passgate_1.OI vco_core_3_0.vco_delay_cell_3_0.pgt vco_core_3_0.vco_delay_cell_3_0.pgt vco_passgate_1.OI sg13_lv_pmos ad=0.408p pd=3.08u as=0.408p ps=3.08u w=1.2u l=17u
X542 a_45734_n11460# a_45132_n11460# VP VP sg13_lv_pmos ad=0.2375p pd=1.63u as=0.2375p ps=1.63u w=1.25u l=0.13u
X543 VCO_MUX_0.VCO2_in a_46168_2592# VP VP sg13_lv_pmos ad=0.2375p pd=1.63u as=0.2375p ps=1.63u w=1.25u l=0.13u
X544 vco_passgate_0.OI inverter_x1_2.OUT VP VP sg13_lv_pmos ad=0.11875p pd=1.005u as=0.11875p ps=1.005u w=0.625u l=0.13u
X545 vco_passgate_1.OI vco_core_3_0.vco_delay_cell_3_0.pgt a_30922_n7843# vco_passgate_1.OI sg13_lv_pmos ad=0.408p pd=3.08u as=0.408p ps=3.08u w=1.2u l=17u
X546 vco_passgate_1.OI vco_passgate_1.en VP gd sg13_lv_nmos ad=0.11875p pd=1.005u as=0.11875p ps=1.005u w=0.625u l=0.13u
X547 a_44137_n5061# a_43535_n5061# VP VP sg13_lv_pmos ad=0.114p pd=0.98u as=0.114p ps=0.98u w=0.6u l=0.13u
X548 VP VCO_decoder_cells_0.000000_n VCO_decoder_cells_0.VCO4_selection_0.NAND_3in_dek_0.y VP sg13_lv_pmos ad=0.1005p pd=1.34u as=0.1005p ps=1.34u w=0.15u l=0.13u
X549 VP PFD_passgate_3.in_p vco_passgate_4.OI VP sg13_lv_pmos ad=0.11875p pd=1.005u as=0.11875p ps=1.005u w=0.625u l=0.13u
X550 0_buf_0.out a_45943_n5690# gd gd sg13_lv_nmos ad=0.2375p pd=1.63u as=0.2375p ps=1.63u w=1.25u l=0.13u
X551 a_10160_1528# VCO_decoder_cells_0.after_000011 a_9944_1528# gd sg13_lv_nmos ad=0.1005p pd=1.34u as=0.1005p ps=1.34u w=0.15u l=0.13u
X552 gd a_44530_n11335# a_45132_n11460# gd sg13_lv_nmos ad=0.2375p pd=1.63u as=0.425p ps=3.18u w=1.25u l=0.13u
X553 VCO_decoder_cells_0.VCO3_selection_0.NAND_3in_dek_0.y VCO_decoder_cells_0.001 a_10160_3010# gd sg13_lv_nmos ad=0.1005p pd=1.34u as=0.1005p ps=1.34u w=0.15u l=0.13u
X554 VP c1 VCO_decoder_cells_0.3bit_to_8_outs_0.inverter_dek_10.in VP sg13_lv_pmos ad=0.1005p pd=1.34u as=0.1005p ps=1.34u w=0.15u l=0.13u
X555 VP a_45943_n5690# 0_buf_0.out VP sg13_lv_pmos ad=0.2375p pd=1.63u as=0.2375p ps=1.63u w=1.25u l=0.13u
X556 vco_core_3_0.out vco_core_3_0.vco_delay_cell_3_0.in a_39218_n5509# gd sg13_lv_nmos ad=0.272p pd=2.28u as=0.272p ps=2.28u w=0.8u l=8.5u
X557 vco_core_0_0.vp VCO_MUX_0.VCO_sel VP gd sg13_lv_nmos ad=0.2125p pd=1.93u as=0.11875p ps=1.005u w=0.625u l=0.13u
X558 0_buf_1.out a_45734_n11460# gd gd sg13_lv_nmos ad=0.2375p pd=1.63u as=0.2375p ps=1.63u w=1.25u l=0.13u
X559 vco_core_1_0.vco_delay_cell_1$1_6.in vco_core_1_0.vco_delay_cell_1$1_2.out a_39508_3420# vco_passgate_3.OI sg13_lv_pmos ad=0.114p pd=0.98u as=0.204p ps=1.88u w=0.6u l=0.7u
X560 a_4211_n3074# VCO_decoder_cells_0.3bit_to_8_outs_0.c2_n gd gd sg13_lv_nmos ad=0.1005p pd=1.34u as=0.1005p ps=1.34u w=0.15u l=0.13u
X561 vco_passgate_0.OI vco_core_4_0.pgt vco_core_4_0.vco_delay_cell_4_7.up vco_passgate_0.OI sg13_lv_pmos ad=0.408p pd=3.08u as=0.408p ps=3.08u w=1.2u l=30u
X562 0_buf_0.out a_45943_n5690# gd gd sg13_lv_nmos ad=0.2375p pd=1.63u as=0.2375p ps=1.63u w=1.25u l=0.13u
X563 a_45282_n1282# a_44680_n1157# gd gd sg13_lv_nmos ad=0.425p pd=3.18u as=0.2375p ps=1.63u w=1.25u l=0.13u
X564 VCO_decoder_cells_0.000 VCO_decoder_cells_0.3bit_to_8_outs_0.inverter_dek_8.in gd gd sg13_lv_nmos ad=0.1005p pd=1.34u as=0.1005p ps=1.34u w=0.15u l=0.13u
X565 VCO_decoder_cells_0.VCO2_selection_0.NAND_4in_dek_0.d VCO_decoder_cells_0.after_000111_n VP VP sg13_lv_pmos ad=0.1005p pd=1.34u as=0.1005p ps=1.34u w=0.15u l=0.13u
X566 VCO_decoder_cells_0.101 VCO_decoder_cells_0.3bit_to_8_outs_0.NAND_3in_dek_3.y gd gd sg13_lv_nmos ad=0.1005p pd=1.34u as=0.1005p ps=1.34u w=0.15u l=0.13u
X567 a_46598_6964# a_45996_6964# gd gd sg13_lv_nmos ad=0.2375p pd=1.63u as=0.2375p ps=1.63u w=1.25u l=0.13u
X568 VP VCO_decoder_cells_0.row_section_decoding_0.NAND_3in_dek_0.c VCO_decoder_cells_0.000000_n VP sg13_lv_pmos ad=0.1005p pd=1.34u as=0.1005p ps=1.34u w=0.15u l=0.13u
X569 vco_core_0_0.vp vco_core_0_0.vco_delay_cell_0$1_0.pgt a_41821_n2486# vco_core_0_0.vp sg13_lv_pmos ad=0.204p pd=1.88u as=0.114p ps=0.98u w=0.6u l=0.56u
X570 VCO_decoder_cells_0.VCO2_selection_0.NAND_4in_dek_1.d VCO_decoder_cells_0.111 a_10463_n3464# gd sg13_lv_nmos ad=0.1005p pd=1.34u as=0.1005p ps=1.34u w=0.15u l=0.13u
X571 vco_passgate_0.OI inverter_x1_2.OUT VP VP sg13_lv_pmos ad=0.2125p pd=1.93u as=0.11875p ps=1.005u w=0.625u l=0.13u
X572 vco_core_3_0.vco_delay_cell_3_2.in vco_core_3_0.vco_delay_cell_3_3.in a_30922_n6301# gd sg13_lv_nmos ad=0.272p pd=2.28u as=0.272p ps=2.28u w=0.8u l=8.5u
X573 gd a_46598_6964# VCO_MUX_0.VCO3_in gd sg13_lv_nmos ad=0.2375p pd=1.63u as=0.2375p ps=1.63u w=1.25u l=0.13u
X574 a_45566_2592# a_44964_2717# VP VP sg13_lv_pmos ad=0.2375p pd=1.63u as=0.2375p ps=1.63u w=1.25u l=0.13u
X575 VCO_decoder_cells_0.VCO3_selection_0.NAND_4in_dek_1.b VCO_decoder_cells_0.100 VP VP sg13_lv_pmos ad=0.1005p pd=1.34u as=0.1005p ps=1.34u w=0.15u l=0.13u
X576 gd PFD_passgate_2.in_p vco_core_0_0.vp gd sg13_lv_nmos ad=0.102p pd=1.28u as=0.102p ps=1.28u w=0.3u l=0.13u
X577 a_10457_n3938# VCO_decoder_cells_0.after_000111_n gd gd sg13_lv_nmos ad=0.1005p pd=1.34u as=0.1005p ps=1.34u w=0.15u l=0.13u
X578 VCO_decoder_cells_0.VCO2_selection_0.NAND_4in_dek_0.a VCO_decoder_cells_0.after_000111 VP VP sg13_lv_pmos ad=0.1005p pd=1.34u as=0.1005p ps=1.34u w=0.15u l=0.13u
X579 a_3531_n1430# c2 gd gd sg13_lv_nmos ad=0.1005p pd=1.34u as=0.1005p ps=1.34u w=0.15u l=0.13u
X580 VCO_MUX_0.VCO2_in a_46168_2592# gd gd sg13_lv_nmos ad=0.2375p pd=1.63u as=0.2375p ps=1.63u w=1.25u l=0.13u
X581 VP VCO_decoder_cells_0.VCO3_selection_0.NAND_4in_dek_0.c VCO_decoder_cells_0.VCO3_11_sel VP sg13_lv_pmos ad=0.1005p pd=1.34u as=0.1005p ps=1.34u w=0.15u l=0.13u
X582 VP VCO_MUX_0.VCO2_sel vco_passgate_3.OI gd sg13_lv_nmos ad=0.11875p pd=1.005u as=0.11875p ps=1.005u w=0.625u l=0.13u
X583 VP a_45341_n5690# a_45943_n5690# VP sg13_lv_pmos ad=0.2375p pd=1.63u as=0.2375p ps=1.63u w=1.25u l=0.13u
X584 gd a_46168_2592# VCO_MUX_0.VCO2_in gd sg13_lv_nmos ad=0.2375p pd=1.63u as=0.425p ps=3.18u w=1.25u l=0.13u
X585 0_buf_1.out a_45734_n11460# gd gd sg13_lv_nmos ad=0.2375p pd=1.63u as=0.2375p ps=1.63u w=1.25u l=0.13u
X586 a_9944_n428# VCO_decoder_cells_0.after_001111_n gd gd sg13_lv_nmos ad=0.1005p pd=1.34u as=0.1005p ps=1.34u w=0.15u l=0.13u
X587 vco_core_0_0.vco_delay_cell_0$1_2.in vco_core_0_0.vco_delay_cell_0$1_3.in a_41821_n2486# vco_core_0_0.vp sg13_lv_pmos ad=0.114p pd=0.98u as=0.204p ps=1.88u w=0.6u l=0.28u
X588 gd a_43326_n10831# a_43928_n10831# gd sg13_lv_nmos ad=0.204p pd=1.88u as=0.114p ps=0.98u w=0.6u l=0.13u
X589 a_44680_n1157# a_44078_n653# VP VP sg13_lv_pmos ad=0.2125p pd=1.93u as=0.11875p ps=1.005u w=0.625u l=0.13u
X590 VCO_MUX_0.VCO_in a_45884_n1282# VP VP sg13_lv_pmos ad=0.2375p pd=1.63u as=0.2375p ps=1.63u w=1.25u l=0.13u
X591 VP VCO_decoder_cells_0.110 VCO_decoder_cells_0.VCO3_selection_0.NAND_4in_dek_1.d VP sg13_lv_pmos ad=0.1005p pd=1.34u as=0.1005p ps=1.34u w=0.15u l=0.13u
X592 a_4722_2110# f5 a_4506_2110# VP sg13_lv_pmos ad=0.1005p pd=1.34u as=0.1005p ps=1.34u w=0.15u l=0.13u
X593 VP a_45884_n1282# VCO_MUX_0.VCO_in VP sg13_lv_pmos ad=0.2375p pd=1.63u as=0.2375p ps=1.63u w=1.25u l=0.13u
X594 VCO_decoder_cells_0.3bit_to_8_outs_0.NAND_3in_dek_0.y c0 VP VP sg13_lv_pmos ad=0.1005p pd=1.34u as=0.1005p ps=1.34u w=0.15u l=0.13u
X595 gd PFD_passgate_0.B vco_core_4_0.vco_delay_cell_4_8.dn gd sg13_lv_nmos ad=0.272p pd=2.28u as=0.272p ps=2.28u w=0.8u l=30u
X596 vco_core_1_0.vco_delay_cell_1$1_3.in vco_core_1_0.vco_delay_cell_1$1_4.in a_40664_1356# vco_passgate_3.OI sg13_lv_pmos ad=0.114p pd=0.98u as=0.204p ps=1.88u w=0.6u l=0.7u
X597 VCO_decoder_cells_0.3bit_to_8_outs_0.NAND_3in_dek_3.y c0 VP VP sg13_lv_pmos ad=0.1005p pd=1.34u as=0.1005p ps=1.34u w=0.15u l=0.13u
X598 vco_passgate_1.OI vco_core_3_0.vco_delay_cell_3_0.pgt a_23442_n7843# vco_passgate_1.OI sg13_lv_pmos ad=0.408p pd=3.08u as=0.408p ps=3.08u w=1.2u l=17u
X599 a_44792_7593# a_44190_7593# VP VP sg13_lv_pmos ad=0.204p pd=1.88u as=0.114p ps=0.98u w=0.6u l=0.13u
X600 VCO_MUX_0.VCO_in a_45884_n1282# VP VP sg13_lv_pmos ad=0.2375p pd=1.63u as=0.2375p ps=1.63u w=1.25u l=0.13u
X601 gd a_45884_n1282# VCO_MUX_0.VCO_in gd sg13_lv_nmos ad=0.2375p pd=1.63u as=0.2375p ps=1.63u w=1.25u l=0.13u
X602 VCO_decoder_cells_0.VCO2_selection_0.NAND_3in_dek_1.b VCO_decoder_cells_0.after_001111 VP VP sg13_lv_pmos ad=0.1005p pd=1.34u as=0.1005p ps=1.34u w=0.15u l=0.13u
X603 gd a_44362_3221# a_44964_2717# gd sg13_lv_nmos ad=0.11875p pd=1.005u as=0.11875p ps=1.005u w=0.625u l=0.13u
X604 a_45566_2592# a_44964_2717# gd gd sg13_lv_nmos ad=0.425p pd=3.18u as=0.2375p ps=1.63u w=1.25u l=0.13u
X605 VCO_decoder_cells_0.VCO3_selection_0.NAND_4in_dek_1.d VCO_decoder_cells_0.000000 VP VP sg13_lv_pmos ad=0.1005p pd=1.34u as=0.1005p ps=1.34u w=0.15u l=0.13u
X606 vco_core_0_0.out vco_core_0_0.vco_delay_cell_0$1_0.in a_42467_n914# gd sg13_lv_nmos ad=76f pd=0.78u as=0.136p ps=1.48u w=0.4u l=0.28u
X607 a_29701_7737# VCO_decoder_cells_0.VCO3_11_sel VP VP sg13_lv_pmos ad=55.5f pd=0.74u as=0.1005p ps=1.34u w=0.15u l=0.13u
X608 gd a_44964_2717# a_45566_2592# gd sg13_lv_nmos ad=0.2375p pd=1.63u as=0.425p ps=3.18u w=1.25u l=0.13u
X609 out VCO_MUX_0.VCO_sel VCO_MUX_0.VCO_in gd sg13_lv_nmos ad=0.17p pd=1.68u as=95f ps=0.88u w=0.5u l=0.13u
X610 a_41209_n2018# vco_core_0_0.in gd gd sg13_lv_nmos ad=76f pd=0.78u as=0.136p ps=1.48u w=0.4u l=0.56u
X611 a_40662_2990# vco_core_1_0.vco_delay_cell_1$1_6.in vco_core_1_0.vco_delay_cell_1$1_6.out gd sg13_lv_nmos ad=0.136p pd=1.48u as=76f ps=0.78u w=0.4u l=0.7u
X612 VCO_MUX_0.VCO_in VCO_MUX_0.VCO_sel out gd sg13_lv_nmos ad=95f pd=0.88u as=95f ps=0.88u w=0.5u l=0.13u
X613 a_3418_n4888# VCO_decoder_cells_0.VCO4_selection_0.NAND_3in_dek_1.y NOR_2in$1_0.B gd sg13_lv_nmos ad=0.1005p pd=1.34u as=0.1005p ps=1.34u w=0.15u l=0.13u
X614 VP VCO_decoder_cells_0.100 VCO_decoder_cells_0.VCO3_selection_0.NAND_4in_dek_0.d VP sg13_lv_pmos ad=0.1005p pd=1.34u as=0.1005p ps=1.34u w=0.15u l=0.13u
X615 vco_passgate_3.OI vco_core_1_0.vco_delay_cell_1$1_0.pgt a_37196_1356# vco_passgate_3.OI sg13_lv_pmos ad=0.204p pd=1.88u as=0.114p ps=0.98u w=0.6u l=1.4u
X616 vco_core_3_0.vco_delay_cell_3_4.in vco_core_3_0.vco_delay_cell_3_5.out a_23442_n6301# gd sg13_lv_nmos ad=0.272p pd=2.28u as=0.272p ps=2.28u w=0.8u l=8.5u
X617 VCO_decoder_cells_0.VCO_selection_0.NAND_3in_dek_0.b VCO_decoder_cells_0.after_001111 VP VP sg13_lv_pmos ad=0.1005p pd=1.34u as=0.1005p ps=1.34u w=0.15u l=0.13u
X618 a_38352_3420# vco_core_1_0.vco_delay_cell_1$1_2.in vco_core_1_0.vco_delay_cell_1$1_2.out vco_passgate_3.OI sg13_lv_pmos ad=0.204p pd=1.88u as=0.114p ps=0.98u w=0.6u l=0.7u
X619 VCO_decoder_cells_0.VCO3_selection_0.NAND_3in_dek_3.y VCO_decoder_cells_0.011 a_10160_n428# gd sg13_lv_nmos ad=0.1005p pd=1.34u as=0.1005p ps=1.34u w=0.15u l=0.13u
X620 gd vco_core_0_0.in a_42501_n2018# gd sg13_lv_nmos ad=0.136p pd=1.48u as=76f ps=0.78u w=0.4u l=0.56u
X621 VP VCO_decoder_cells_0.010 VCO_decoder_cells_0.VCO4_selection_0.NAND_3in_dek_0.y VP sg13_lv_pmos ad=0.1005p pd=1.34u as=0.1005p ps=1.34u w=0.15u l=0.13u
X622 a_44530_n11335# a_43928_n10831# VP VP sg13_lv_pmos ad=0.2125p pd=1.93u as=0.11875p ps=1.005u w=0.625u l=0.13u
X623 VP VCO_decoder_cells_0.after_000111 VCO_decoder_cells_0.VCO2_selection_0.NAND_3in_dek_0.y VP sg13_lv_pmos ad=0.1005p pd=1.34u as=0.1005p ps=1.34u w=0.15u l=0.13u
X624 VCO_MUX_0.VCO2_in a_46168_2592# VP VP sg13_lv_pmos ad=0.2375p pd=1.63u as=0.2375p ps=1.63u w=1.25u l=0.13u
X625 gd VCO_decoder_cells_0.after_000111_n VCO_decoder_cells_0.after_000111 gd sg13_lv_nmos ad=0.1005p pd=1.34u as=0.1005p ps=1.34u w=0.15u l=0.13u
X626 0_buf_0.out a_45943_n5690# VP VP sg13_lv_pmos ad=0.2375p pd=1.63u as=0.2375p ps=1.63u w=1.25u l=0.13u
X627 a_45282_n1282# a_44680_n1157# VP VP sg13_lv_pmos ad=0.425p pd=3.18u as=0.2375p ps=1.63u w=1.25u l=0.13u
X628 a_9944_n902# VCO_decoder_cells_0.f5_n gd gd sg13_lv_nmos ad=0.1005p pd=1.34u as=0.1005p ps=1.34u w=0.15u l=0.13u
X629 vco_core_0_0.vco_delay_cell_0$1_2.in vco_core_0_0.vco_delay_cell_0$1_3.in a_41821_n2018# gd sg13_lv_nmos ad=76f pd=0.78u as=0.136p ps=1.48u w=0.4u l=0.28u
X630 vco_passgate_1.OI vco_core_3_0.vco_delay_cell_3_0.pgt a_19702_n7843# vco_passgate_1.OI sg13_lv_pmos ad=0.408p pd=3.08u as=0.408p ps=3.08u w=1.2u l=17u
X631 VP VCO_decoder_cells_0.010 VCO_decoder_cells_0.VCO5_selection_0.NAND_2in_dek_0.b VP sg13_lv_pmos ad=0.1005p pd=1.34u as=0.1005p ps=1.34u w=0.15u l=0.13u
X632 vco_passgate_4.OI vco_core_2_0.vco_delay_cell_2$6_0.pgt a_40101_4818# vco_passgate_4.OI sg13_lv_pmos ad=0.408p pd=3.08u as=0.408p ps=3.08u w=1.2u l=5u
X633 vco_passgate_3.OI vco_core_1_0.vco_delay_cell_1$1_0.pgt a_37196_3420# vco_passgate_3.OI sg13_lv_pmos ad=0.204p pd=1.88u as=0.114p ps=0.98u w=0.6u l=1.4u
X634 VP a_46168_2592# VCO_MUX_0.VCO2_in VP sg13_lv_pmos ad=0.2375p pd=1.63u as=0.2375p ps=1.63u w=1.25u l=0.13u
X635 vco_core_0_0.vp vco_core_0_0.vco_delay_cell_0$1_0.pgt a_42467_n486# vco_core_0_0.vp sg13_lv_pmos ad=0.204p pd=1.88u as=0.114p ps=0.98u w=0.6u l=0.56u
X636 vco_core_4_0.vco_delay_cell_4_0.dn PFD_passgate_0.B gd gd sg13_lv_nmos ad=0.272p pd=2.28u as=0.272p ps=2.28u w=0.8u l=30u
X637 VCO_decoder_cells_0.3bit_to_8_outs_0.inverter_dek_1.in VCO_decoder_cells_0.3bit_to_8_outs_0.c0_n a_4427_n1430# gd sg13_lv_nmos ad=0.1005p pd=1.34u as=0.1005p ps=1.34u w=0.15u l=0.13u
X638 a_44792_7593# a_44190_7593# gd gd sg13_lv_nmos ad=0.114p pd=0.98u as=0.204p ps=1.88u w=0.6u l=0.13u
X639 a_10160_3010# VCO_decoder_cells_0.after_000111 a_9944_3010# gd sg13_lv_nmos ad=0.1005p pd=1.34u as=0.1005p ps=1.34u w=0.15u l=0.13u
X640 gd vco_core_0_0.out a_43476_n653# gd sg13_lv_nmos ad=0.136p pd=1.48u as=76f ps=0.78u w=0.4u l=0.13u
X641 a_4427_n1748# VCO_decoder_cells_0.3bit_to_8_outs_0.c1_n a_4211_n1748# gd sg13_lv_nmos ad=0.1005p pd=1.34u as=0.1005p ps=1.34u w=0.15u l=0.13u
X642 VCO_decoder_cells_0.3bit_to_8_outs_0.c2_n c2 VP VP sg13_lv_pmos ad=0.1005p pd=1.34u as=0.1005p ps=1.34u w=0.15u l=0.13u
X643 VCO_decoder_cells_0.VCO2_selection_0.NAND_4in_dek_0.b VCO_decoder_cells_0.101 VP VP sg13_lv_pmos ad=0.1005p pd=1.34u as=0.1005p ps=1.34u w=0.15u l=0.13u
X644 vco_core_2_0.vco_delay_cell_2$6_6.in VCO_decoder_cells_0.VCO3_11_sel vco_core_2_0.vco_delay_cell_2$6_9.out gd sg13_lv_nmos ad=0.102p pd=1.28u as=0.102p ps=1.28u w=0.3u l=0.15u
X645 vco_core_1_0.vco_delay_cell_1$1_5.in VCO_decoder_cells_0.VCO2_11_sel vco_core_1_0.vco_delay_cell_1$1_3.out gd sg13_lv_nmos ad=0.102p pd=1.28u as=0.102p ps=1.28u w=0.3u l=0.15u
X646 vco_core_2_0.vco_delay_cell_2$6_4.out vco_core_2_0.out a_36021_7152# gd sg13_lv_nmos ad=0.272p pd=2.28u as=0.272p ps=2.28u w=0.8u l=2.5u
X647 a_45394_7089# a_44792_7593# VP VP sg13_lv_pmos ad=0.2125p pd=1.93u as=0.11875p ps=1.005u w=0.625u l=0.13u
X648 vco_core_2_0.vco_delay_cell_2$6_0.out vco_core_2_0.vco_delay_cell_2$6_0.in a_41461_6360# gd sg13_lv_nmos ad=0.272p pd=2.28u as=0.272p ps=2.28u w=0.8u l=2.5u
X649 gd PFD_passgate_0.B vco_core_4_0.vco_delay_cell_4_7.dn gd sg13_lv_nmos ad=0.272p pd=2.28u as=0.272p ps=2.28u w=0.8u l=30u
X650 VP VCO_MUX_0.VCO_sel vco_core_0_0.vp gd sg13_lv_nmos ad=0.11875p pd=1.005u as=0.2125p ps=1.93u w=0.625u l=0.13u
X651 a_44530_n11335# a_43928_n10831# VP VP sg13_lv_pmos ad=0.11875p pd=1.005u as=0.11875p ps=1.005u w=0.625u l=0.13u
X652 vco_core_0_0.vco_delay_cell_0$1_0.in vco_core_0_0.vco_delay_cell_0$1_1.in a_41855_n486# vco_core_0_0.vp sg13_lv_pmos ad=0.114p pd=0.98u as=0.204p ps=1.88u w=0.6u l=0.28u
X653 gd PFD_passgate_3.B a_37381_7152# gd sg13_lv_nmos ad=0.272p pd=2.28u as=0.272p ps=2.28u w=0.8u l=5u
X654 vco_core_2_0.vco_delay_cell_2$6_3.in vco_core_2_0.vco_delay_cell_2$6_6.out a_36021_4818# vco_passgate_4.OI sg13_lv_pmos ad=0.408p pd=3.08u as=0.408p ps=3.08u w=1.2u l=2.5u
X655 a_43760_3221# vco_core_1_0.out VP VP sg13_lv_pmos ad=0.1275p pd=1.43u as=71.25f ps=0.755u w=0.375u l=0.13u
X656 gd a_45943_n5690# 0_buf_0.out gd sg13_lv_nmos ad=0.2375p pd=1.63u as=0.425p ps=3.18u w=1.25u l=0.13u
X657 gd a_44680_n1157# a_45282_n1282# gd sg13_lv_nmos ad=0.2375p pd=1.63u as=0.425p ps=3.18u w=1.25u l=0.13u
X658 VP VCO_decoder_cells_0.001 VCO_decoder_cells_0.VCO3_selection_0.NAND_3in_dek_4.a VP sg13_lv_pmos ad=0.1005p pd=1.34u as=0.1005p ps=1.34u w=0.15u l=0.13u
X659 a_39508_1356# vco_core_1_0.vco_delay_cell_1$1_0.pgt vco_passgate_3.OI vco_passgate_3.OI sg13_lv_pmos ad=0.114p pd=0.98u as=0.204p ps=1.88u w=0.6u l=1.4u
X660 vco_core_4_0.vco_delay_cell_4_5.up vco_core_4_0.pgt vco_passgate_0.OI vco_passgate_0.OI sg13_lv_pmos ad=0.408p pd=3.08u as=0.408p ps=3.08u w=1.2u l=30u
X661 a_45943_n5690# a_45341_n5690# VP VP sg13_lv_pmos ad=0.2375p pd=1.63u as=0.2375p ps=1.63u w=1.25u l=0.13u
X662 a_44680_n1157# a_44078_n653# gd gd sg13_lv_nmos ad=0.2125p pd=1.93u as=0.11875p ps=1.005u w=0.625u l=0.13u
X663 vco_core_2_0.vco_delay_cell_2$6_8.in VCO_decoder_cells_0.VCO3_11_sel vco_core_2_0.vco_delay_cell_2$6_0.out gd sg13_lv_nmos ad=0.102p pd=1.28u as=0.102p ps=1.28u w=0.3u l=0.15u
X664 vco_passgate_3.OI vco_core_1_0.vco_delay_cell_1$1_0.pgt a_42228_3420# vco_passgate_3.OI sg13_lv_pmos ad=0.204p pd=1.88u as=0.114p ps=0.98u w=0.6u l=1.4u
X665 gd a_46168_2592# VCO_MUX_0.VCO2_in gd sg13_lv_nmos ad=0.2375p pd=1.63u as=0.2375p ps=1.63u w=1.25u l=0.13u
X666 a_9777_n3938# VCO_decoder_cells_0.f5_n gd gd sg13_lv_nmos ad=0.1005p pd=1.34u as=0.1005p ps=1.34u w=0.15u l=0.13u
X667 gd PFD_passgate_0.B vco_core_4_0.vco_delay_cell_4_10.dn gd sg13_lv_nmos ad=0.272p pd=2.28u as=0.272p ps=2.28u w=0.8u l=30u
X668 gd VCO_decoder_cells_0.111 a_4571_n7189# gd sg13_lv_nmos ad=0.1005p pd=1.34u as=0.1005p ps=1.34u w=0.15u l=0.13u
X669 VCO_decoder_cells_0.VCO3_selection_0.NAND_3in_dek_4.b VCO_decoder_cells_0.010 a_10160_n902# gd sg13_lv_nmos ad=0.1005p pd=1.34u as=0.1005p ps=1.34u w=0.15u l=0.13u
X670 VP VCO_decoder_cells_0.VCO2_selection_0.NAND_4in_dek_1.c VCO_decoder_cells_0.VCO2_11_sel VP sg13_lv_pmos ad=0.1005p pd=1.34u as=0.1005p ps=1.34u w=0.15u l=0.13u
X671 vco_core_1_0.vco_delay_cell_1$1_1.out vco_core_1_0.vco_delay_cell_1$1_0.out a_37194_1826# gd sg13_lv_nmos ad=76f pd=0.78u as=0.136p ps=1.48u w=0.4u l=0.7u
X672 a_41752_1356# vco_core_1_0.vco_delay_cell_1$1_0.pgt vco_passgate_3.OI vco_passgate_3.OI sg13_lv_pmos ad=0.114p pd=0.98u as=0.204p ps=1.88u w=0.6u l=1.4u
X673 0_buf_1.out a_45734_n11460# VP VP sg13_lv_pmos ad=0.2375p pd=1.63u as=0.2375p ps=1.63u w=1.25u l=0.13u
X674 a_45943_n5690# a_45341_n5690# VP VP sg13_lv_pmos ad=0.2375p pd=1.63u as=0.2375p ps=1.63u w=1.25u l=0.13u
X675 a_39508_3420# vco_core_1_0.vco_delay_cell_1$1_0.pgt vco_passgate_3.OI vco_passgate_3.OI sg13_lv_pmos ad=0.114p pd=0.98u as=0.204p ps=1.88u w=0.6u l=1.4u
X676 VCO_MUX_0.VCO2_in a_46168_2592# gd gd sg13_lv_nmos ad=0.2375p pd=1.63u as=0.2375p ps=1.63u w=1.25u l=0.13u
X677 VP VCO_decoder_cells_0.after_000111_n VCO_decoder_cells_0.VCO3_selection_0.NAND_4in_dek_0.c VP sg13_lv_pmos ad=0.1005p pd=1.34u as=0.1005p ps=1.34u w=0.15u l=0.13u
X678 VCO_decoder_cells_0.011 VCO_decoder_cells_0.3bit_to_8_outs_0.inverter_dek_10.in VP VP sg13_lv_pmos ad=0.1005p pd=1.34u as=0.1005p ps=1.34u w=0.15u l=0.13u
X679 VP a_46598_6964# VCO_MUX_0.VCO3_in VP sg13_lv_pmos ad=0.2375p pd=1.63u as=0.2375p ps=1.63u w=1.25u l=0.13u
X680 vco_core_4_0.vco_delay_cell_4_10.out vco_core_4_0.vco_delay_cell_4_9.out vco_core_4_0.vco_delay_cell_4_10.dn gd sg13_lv_nmos ad=0.272p pd=2.28u as=0.272p ps=2.28u w=0.8u l=15u
X681 gd a_45132_n11460# a_45734_n11460# gd sg13_lv_nmos ad=0.2375p pd=1.63u as=0.2375p ps=1.63u w=1.25u l=0.13u
X682 gd PFD_passgate_1.B a_30922_n6301# gd sg13_lv_nmos ad=0.272p pd=2.28u as=0.272p ps=2.28u w=0.8u l=17u
X683 VCO_MUX_0.VCO_in a_45884_n1282# VP VP sg13_lv_pmos ad=0.425p pd=3.18u as=0.2375p ps=1.63u w=1.25u l=0.13u
X684 gd a_43535_n5061# a_44137_n5061# gd sg13_lv_nmos ad=0.204p pd=1.88u as=0.114p ps=0.98u w=0.6u l=0.13u
X685 VCO_decoder_cells_0.VCO3_selection_0.NAND_4in_dek_0.b VCO_decoder_cells_0.after_000111_n VP VP sg13_lv_pmos ad=0.1005p pd=1.34u as=0.1005p ps=1.34u w=0.15u l=0.13u
X686 VP a_45884_n1282# VCO_MUX_0.VCO_in VP sg13_lv_pmos ad=0.2375p pd=1.63u as=0.2375p ps=1.63u w=1.25u l=0.13u
X687 VP VCO_decoder_cells_0.VCO2_selection_0.NAND_3in_dek_1.b VCO_decoder_cells_0.VCO2_selection_0.NAND_3in_dek_1.y VP sg13_lv_pmos ad=0.1005p pd=1.34u as=0.1005p ps=1.34u w=0.15u l=0.13u
X688 VCO_decoder_cells_0.row_section_decoding_0.NAND_2in_dek_0.a f3 gd gd sg13_lv_nmos ad=0.1005p pd=1.34u as=0.1005p ps=1.34u w=0.15u l=0.13u
X689 0_buf_1.out a_45734_n11460# VP VP sg13_lv_pmos ad=0.2375p pd=1.63u as=0.2375p ps=1.63u w=1.25u l=0.13u
X690 a_44362_3221# a_43760_3221# VP VP sg13_lv_pmos ad=0.204p pd=1.88u as=0.114p ps=0.98u w=0.6u l=0.13u
X691 VP f4 a_3510_2110# VP sg13_lv_pmos ad=0.1005p pd=1.34u as=0.1005p ps=1.34u w=0.15u l=0.13u
X692 vco_core_2_0.vco_delay_cell_2$6_5.out vco_core_2_0.vco_delay_cell_2$6_5.in a_38741_8614# vco_passgate_4.OI sg13_lv_pmos ad=0.408p pd=3.08u as=0.408p ps=3.08u w=1.2u l=2.5u
X693 vco_passgate_3.OI vco_core_1_0.vco_delay_cell_1$1_0.pgt a_40664_1356# vco_passgate_3.OI sg13_lv_pmos ad=0.204p pd=1.88u as=0.114p ps=0.98u w=0.6u l=1.4u
X694 a_3770_154# f3 VCO_decoder_cells_0.row_section_decoding_0.NAND_3in_dek_0.a VP sg13_lv_pmos ad=0.1005p pd=1.34u as=0.1005p ps=1.34u w=0.15u l=0.13u
X695 VCO_decoder_cells_0.3bit_to_8_outs_0.inverter_dek_6.in VCO_decoder_cells_0.3bit_to_8_outs_0.c0_n a_3747_n1748# gd sg13_lv_nmos ad=0.1005p pd=1.34u as=0.1005p ps=1.34u w=0.15u l=0.13u
X696 VCO_decoder_cells_0.VCO3_selection_0.NAND_4in_dek_1.c VCO_decoder_cells_0.after_000011_n VP VP sg13_lv_pmos ad=0.1005p pd=1.34u as=0.1005p ps=1.34u w=0.15u l=0.13u
X697 VCO_decoder_cells_0.111 VCO_decoder_cells_0.3bit_to_8_outs_0.NAND_3in_dek_0.y VP VP sg13_lv_pmos ad=0.1005p pd=1.34u as=0.1005p ps=1.34u w=0.15u l=0.13u
X698 VP NOR_2in$1_0.A vco_core_3_0.nen11 VP sg13_lv_pmos ad=0.1005p pd=1.34u as=0.1005p ps=1.34u w=0.15u l=0.13u
X699 a_44739_n5565# a_44137_n5061# VP VP sg13_lv_pmos ad=0.2125p pd=1.93u as=0.11875p ps=1.005u w=0.625u l=0.13u
X700 gd PFD_passgate_4.B a_37194_1826# gd sg13_lv_nmos ad=0.136p pd=1.48u as=76f ps=0.78u w=0.4u l=1.4u
X701 vco_core_1_0.vco_delay_cell_1$1_3.out vco_core_1_0.vco_delay_cell_1$1_3.in a_41750_1826# gd sg13_lv_nmos ad=76f pd=0.78u as=0.136p ps=1.48u w=0.4u l=0.7u
X702 VP VCO_decoder_cells_0.row_section_decoding_0.NAND_2in_dek_0.b VCO_decoder_cells_0.after_000011 VP sg13_lv_pmos ad=0.1005p pd=1.34u as=0.1005p ps=1.34u w=0.15u l=0.13u
X703 a_10160_n428# VCO_decoder_cells_0.after_000111 a_9944_n428# gd sg13_lv_nmos ad=0.1005p pd=1.34u as=0.1005p ps=1.34u w=0.15u l=0.13u
X704 PFD_passgate_2.in_p VCO_MUX_0.VCO_sel gd gd sg13_lv_nmos ad=0.1005p pd=1.34u as=0.1005p ps=1.34u w=0.15u l=0.13u
X705 gd a_45132_n11460# a_45734_n11460# gd sg13_lv_nmos ad=0.2375p pd=1.63u as=0.2375p ps=1.63u w=1.25u l=0.13u
X706 gd VCO_decoder_cells_0.VCO4_selection_0.NAND_4in_dek_0.d a_3850_n4888# gd sg13_lv_nmos ad=0.1005p pd=1.34u as=0.1005p ps=1.34u w=0.15u l=0.13u
X707 gd PFD_passgate_4.B a_37194_2990# gd sg13_lv_nmos ad=0.136p pd=1.48u as=76f ps=0.78u w=0.4u l=1.4u
X708 gd PFD_passgate_1.B a_39218_n5509# gd sg13_lv_nmos ad=0.272p pd=2.28u as=0.272p ps=2.28u w=0.8u l=17u
X709 a_4269_n5362# VCO_decoder_cells_0.after_000111_n a_4053_n5362# gd sg13_lv_nmos ad=0.1005p pd=1.34u as=0.1005p ps=1.34u w=0.15u l=0.13u
X710 gd PFD_passgate_3.B a_42005_7152# gd sg13_lv_nmos ad=0.272p pd=2.28u as=0.272p ps=2.28u w=0.8u l=5u
X711 vco_passgate_3.OI vco_core_1_0.vco_delay_cell_1$1_0.pgt a_40664_3420# vco_passgate_3.OI sg13_lv_pmos ad=0.204p pd=1.88u as=0.114p ps=0.98u w=0.6u l=1.4u
X712 a_9777_n5894# VCO_decoder_cells_0.after_000111 gd gd sg13_lv_nmos ad=0.1005p pd=1.34u as=0.1005p ps=1.34u w=0.15u l=0.13u
X713 a_45884_n1282# a_45282_n1282# gd gd sg13_lv_nmos ad=0.2375p pd=1.63u as=0.2375p ps=1.63u w=1.25u l=0.13u
X714 gd PFD_passgate_4.B vco_core_1_0.vco_delay_cell_1$1_0.pgt gd sg13_lv_nmos ad=0.136p pd=1.48u as=76f ps=0.78u w=0.4u l=1.4u
X715 a_11526_1054# VCO_decoder_cells_0.VCO3_selection_0.NAND_4in_dek_0.b a_11310_1054# gd sg13_lv_nmos ad=0.1005p pd=1.34u as=0.1005p ps=1.34u w=0.15u l=0.13u
X716 VP a_45943_n5690# 0_buf_0.out VP sg13_lv_pmos ad=0.2375p pd=1.63u as=0.2375p ps=1.63u w=1.25u l=0.13u
X717 gd NOR_2in$1_0.B vco_core_3_0.nen5 gd sg13_lv_nmos ad=0.1005p pd=1.34u as=0.1005p ps=1.34u w=0.15u l=0.13u
X718 gd a_46598_6964# VCO_MUX_0.VCO3_in gd sg13_lv_nmos ad=0.2375p pd=1.63u as=0.2375p ps=1.63u w=1.25u l=0.13u
X719 VP VCO_MUX_0.VCO3_sel vco_passgate_4.OI gd sg13_lv_nmos ad=0.11875p pd=1.005u as=0.11875p ps=1.005u w=0.625u l=0.13u
X720 a_9993_n3464# VCO_decoder_cells_0.after_000111_n a_9777_n3464# gd sg13_lv_nmos ad=0.1005p pd=1.34u as=0.1005p ps=1.34u w=0.15u l=0.13u
X721 0_buf_1.out a_45734_n11460# VP VP sg13_lv_pmos ad=0.425p pd=3.18u as=0.2375p ps=1.63u w=1.25u l=0.13u
X722 vco_core_2_0.vco_delay_cell_2$6_9.out vco_core_2_0.vco_delay_cell_2$6_5.out a_40101_8614# vco_passgate_4.OI sg13_lv_pmos ad=0.408p pd=3.08u as=0.408p ps=3.08u w=1.2u l=2.5u
X723 vco_core_0_0.vco_delay_cell_0$1_0.pgt vco_core_0_0.vco_delay_cell_0$1_0.pgt vco_core_0_0.vp vco_core_0_0.vp sg13_lv_pmos ad=0.114p pd=0.98u as=0.204p ps=1.88u w=0.6u l=0.56u
X724 VP inverter_x1_2.IN vco_passgate_0.OI gd sg13_lv_nmos ad=0.11875p pd=1.005u as=0.11875p ps=1.005u w=0.625u l=0.13u
X725 VCO_decoder_cells_0.VCO3_selection_0.NAND_4in_dek_0.b VCO_decoder_cells_0.010 VP VP sg13_lv_pmos ad=0.1005p pd=1.34u as=0.1005p ps=1.34u w=0.15u l=0.13u
X726 a_45884_n1282# a_45282_n1282# gd gd sg13_lv_nmos ad=0.2375p pd=1.63u as=0.2375p ps=1.63u w=1.25u l=0.13u
X727 a_46168_2592# a_45566_2592# VP VP sg13_lv_pmos ad=0.2375p pd=1.63u as=0.2375p ps=1.63u w=1.25u l=0.13u
X728 VP VCO_decoder_cells_0.VCO2_selection_0.NAND_4in_dek_0.a VCO_decoder_cells_0.VCO2_5_sel VP sg13_lv_pmos ad=0.1005p pd=1.34u as=0.1005p ps=1.34u w=0.15u l=0.13u
X729 gd PFD_passgate_1.B a_23442_n6301# gd sg13_lv_nmos ad=0.272p pd=2.28u as=0.272p ps=2.28u w=0.8u l=17u
X730 vco_passgate_1.en_ vco_passgate_1.en gd gd sg13_lv_nmos ad=0.1005p pd=1.34u as=0.1005p ps=1.34u w=0.15u l=0.13u
X731 VP a_45943_n5690# 0_buf_0.out VP sg13_lv_pmos ad=0.2375p pd=1.63u as=0.2375p ps=1.63u w=1.25u l=0.13u
X732 a_36106_1826# PFD_passgate_4.B gd gd sg13_lv_nmos ad=76f pd=0.78u as=0.136p ps=1.48u w=0.4u l=1.4u
X733 VP inverter_x1_2.IN VCO_MUX_0.passgate_scaled_0.en_ VP sg13_lv_pmos ad=0.1005p pd=1.34u as=0.1005p ps=1.34u w=0.15u l=0.13u
X734 vco_core_0_0.vp PFD_passgate_2.in_p VP VP sg13_lv_pmos ad=0.2125p pd=1.93u as=0.11875p ps=1.005u w=0.625u l=0.13u
X735 a_5047_n6871# VCO_decoder_cells_0.after_001111 VCO_decoder_cells_0.VCO_selection_0.NAND_3in_dek_0.b gd sg13_lv_nmos ad=0.1005p pd=1.34u as=0.1005p ps=1.34u w=0.15u l=0.13u
X736 a_3747_n3074# c1 a_3531_n3074# gd sg13_lv_nmos ad=0.1005p pd=1.34u as=0.1005p ps=1.34u w=0.15u l=0.13u
X737 VP a_45566_2592# a_46168_2592# VP sg13_lv_pmos ad=0.2375p pd=1.63u as=0.425p ps=3.18u w=1.25u l=0.13u
X738 VCO_decoder_cells_0.VCO3_5_sel VCO_decoder_cells_0.VCO3_selection_0.NAND_4in_dek_1.b VP VP sg13_lv_pmos ad=0.1005p pd=1.34u as=0.1005p ps=1.34u w=0.15u l=0.13u
X739 gd a_45566_2592# a_46168_2592# gd sg13_lv_nmos ad=0.2375p pd=1.63u as=0.2375p ps=1.63u w=1.25u l=0.13u
X740 vco_core_0_0.out vco_core_0_0.vco_delay_cell_0$1_0.in a_42467_n486# vco_core_0_0.vp sg13_lv_pmos ad=0.114p pd=0.98u as=0.204p ps=1.88u w=0.6u l=0.28u
X741 a_10253_n1982# VCO_decoder_cells_0.after_001111 gd gd sg13_lv_nmos ad=0.1005p pd=1.34u as=0.1005p ps=1.34u w=0.15u l=0.13u
X742 a_10160_n902# VCO_decoder_cells_0.after_000111 a_9944_n902# gd sg13_lv_nmos ad=0.1005p pd=1.34u as=0.1005p ps=1.34u w=0.15u l=0.13u
X743 gd inverter_x1_2.OUT vco_passgate_0.OI gd sg13_lv_nmos ad=0.102p pd=1.28u as=0.102p ps=1.28u w=0.3u l=0.13u
X744 vco_core_4_0.vco_delay_cell_4_3.dn vco_core_4_0.vco_delay_cell_4_3.in vco_core_4_0.vco_delay_cell_4_2.in gd sg13_lv_nmos ad=0.272p pd=2.28u as=0.272p ps=2.28u w=0.8u l=15u
X745 a_41750_1826# PFD_passgate_4.B gd gd sg13_lv_nmos ad=76f pd=0.78u as=0.136p ps=1.48u w=0.4u l=1.4u
X746 VP 0_buf_1.in a_43326_n10831# VP sg13_lv_pmos ad=71.25f pd=0.755u as=71.25f ps=0.755u w=0.375u l=0.13u
X747 VP a_46598_6964# VCO_MUX_0.VCO3_in VP sg13_lv_pmos ad=0.2375p pd=1.63u as=0.2375p ps=1.63u w=1.25u l=0.13u
X748 VCO_decoder_cells_0.VCO2_selection_0.NAND_2in_dek_0.y f5 VP VP sg13_lv_pmos ad=0.1005p pd=1.34u as=0.1005p ps=1.34u w=0.15u l=0.13u
X749 gd PFD_passgate_1.B a_19702_n6301# gd sg13_lv_nmos ad=0.272p pd=2.28u as=0.272p ps=2.28u w=0.8u l=17u
X750 a_4246_154# f0 VCO_decoder_cells_0.row_section_decoding_0.NAND_3in_dek_0.c VP sg13_lv_pmos ad=0.1005p pd=1.34u as=0.1005p ps=1.34u w=0.15u l=0.13u
X751 gd a_45884_n1282# VCO_MUX_0.VCO_in gd sg13_lv_nmos ad=0.2375p pd=1.63u as=0.2375p ps=1.63u w=1.25u l=0.13u
X752 gd f4 VCO_decoder_cells_0.after_000111_n gd sg13_lv_nmos ad=0.1005p pd=1.34u as=0.1005p ps=1.34u w=0.15u l=0.13u
X753 VP a_46598_6964# VCO_MUX_0.VCO3_in VP sg13_lv_pmos ad=0.2375p pd=1.63u as=0.2375p ps=1.63u w=1.25u l=0.13u
X754 gd a_45566_2592# a_46168_2592# gd sg13_lv_nmos ad=0.2375p pd=1.63u as=0.2375p ps=1.63u w=1.25u l=0.13u
X755 a_37196_1356# vco_core_1_0.vco_delay_cell_1$1_0.out vco_core_1_0.vco_delay_cell_1$1_1.out vco_passgate_3.OI sg13_lv_pmos ad=0.204p pd=1.88u as=0.114p ps=0.98u w=0.6u l=0.7u
X756 gd VCO_decoder_cells_0.VCO2_11_sel vco_core_1_0.nen11 gd sg13_lv_nmos ad=0.1005p pd=1.34u as=0.1005p ps=1.34u w=0.15u l=0.13u
X757 VCO_MUX_0.VCO3_in a_46598_6964# VP VP sg13_lv_pmos ad=0.2375p pd=1.63u as=0.2375p ps=1.63u w=1.25u l=0.13u
X758 gd a_45884_n1282# VCO_MUX_0.VCO_in gd sg13_lv_nmos ad=0.2375p pd=1.63u as=0.2375p ps=1.63u w=1.25u l=0.13u
X759 VP 0_buf_1.in a_43326_n10831# VP sg13_lv_pmos ad=71.25f pd=0.755u as=0.1275p ps=1.43u w=0.375u l=0.13u
X760 a_3634_n4888# VCO_decoder_cells_0.VCO4_selection_0.NAND_4in_dek_0.b a_3418_n4888# gd sg13_lv_nmos ad=0.1005p pd=1.34u as=0.1005p ps=1.34u w=0.15u l=0.13u
X761 VCO_MUX_0.VCO3_sel NOR_2in$1_1.Out gd gd sg13_lv_nmos ad=0.1005p pd=1.34u as=0.1005p ps=1.34u w=0.15u l=0.13u
X762 a_31345_3300# VCO_decoder_cells_0.VCO2_11_sel VP VP sg13_lv_pmos ad=55.5f pd=0.74u as=0.1005p ps=1.34u w=0.15u l=0.13u
X763 a_11310_1528# VCO_decoder_cells_0.000000 gd gd sg13_lv_nmos ad=0.1005p pd=1.34u as=0.1005p ps=1.34u w=0.15u l=0.13u
X764 vco_core_1_0.vco_delay_cell_1$1_0.pgt vco_core_1_0.vco_delay_cell_1$1_0.pgt vco_passgate_3.OI vco_passgate_3.OI sg13_lv_pmos ad=0.114p pd=0.98u as=0.204p ps=1.88u w=0.6u l=1.4u
X765 gd VCO_decoder_cells_0.after_000011 VCO_decoder_cells_0.after_000011_n gd sg13_lv_nmos ad=0.1005p pd=1.34u as=0.1005p ps=1.34u w=0.15u l=0.13u
X766 vco_passgate_4.OI vco_core_2_0.vco_delay_cell_2$6_0.pgt a_40101_8614# vco_passgate_4.OI sg13_lv_pmos ad=0.408p pd=3.08u as=0.408p ps=3.08u w=1.2u l=5u
X767 VCO_decoder_cells_0.VCO3_selection_0.NAND_4in_dek_0.c VCO_decoder_cells_0.011 a_10840_1528# gd sg13_lv_nmos ad=0.1005p pd=1.34u as=0.1005p ps=1.34u w=0.15u l=0.13u
X768 a_9944_1054# VCO_decoder_cells_0.after_000111_n gd gd sg13_lv_nmos ad=0.1005p pd=1.34u as=0.1005p ps=1.34u w=0.15u l=0.13u
X769 a_45884_n1282# a_45282_n1282# VP VP sg13_lv_pmos ad=0.2375p pd=1.63u as=0.2375p ps=1.63u w=1.25u l=0.13u
X770 gd a_45884_n1282# VCO_MUX_0.VCO_in gd sg13_lv_nmos ad=0.2375p pd=1.63u as=0.2375p ps=1.63u w=1.25u l=0.13u
X771 VP a_45132_n11460# a_45734_n11460# VP sg13_lv_pmos ad=0.2375p pd=1.63u as=0.2375p ps=1.63u w=1.25u l=0.13u
X772 a_44190_7593# vco_core_2_0.out VP VP sg13_lv_pmos ad=71.25f pd=0.755u as=71.25f ps=0.755u w=0.375u l=0.13u
X773 vco_core_1_0.vco_delay_cell_1$1_5.in VCO_decoder_cells_0.VCO2_5_sel vco_core_1_0.vco_delay_cell_1$1_6.out gd sg13_lv_nmos ad=0.102p pd=1.28u as=0.102p ps=1.28u w=0.3u l=0.15u
X774 vco_passgate_1.OI vco_core_3_0.vco_delay_cell_3_0.pgt a_27182_n4047# vco_passgate_1.OI sg13_lv_pmos ad=0.408p pd=3.08u as=0.408p ps=3.08u w=1.2u l=17u
X775 vco_passgate_1.OI vco_passgate_1.en_ VP VP sg13_lv_pmos ad=0.11875p pd=1.005u as=0.11875p ps=1.005u w=0.625u l=0.13u
X776 vco_passgate_4.OI vco_core_2_0.vco_delay_cell_2$6_0.pgt a_36021_4818# vco_passgate_4.OI sg13_lv_pmos ad=0.408p pd=3.08u as=0.408p ps=3.08u w=1.2u l=5u
X777 VP a_45282_n1282# a_45884_n1282# VP sg13_lv_pmos ad=0.2375p pd=1.63u as=0.2375p ps=1.63u w=1.25u l=0.13u
X778 VP a_43326_n10831# a_43928_n10831# VP sg13_lv_pmos ad=0.114p pd=0.98u as=0.114p ps=0.98u w=0.6u l=0.13u
X779 gd a_46598_6964# VCO_MUX_0.VCO3_in gd sg13_lv_nmos ad=0.2375p pd=1.63u as=0.2375p ps=1.63u w=1.25u l=0.13u
X780 gd PFD_passgate_0.B vco_core_4_0.vco_delay_cell_4_9.dn gd sg13_lv_nmos ad=0.272p pd=2.28u as=0.272p ps=2.28u w=0.8u l=30u
X781 gd a_45943_n5690# 0_buf_0.out gd sg13_lv_nmos ad=0.2375p pd=1.63u as=0.2375p ps=1.63u w=1.25u l=0.13u
X782 vco_core_2_0.vco_delay_cell_2$6_2.in vco_core_2_0.vco_delay_cell_2$6_3.in a_37381_6360# gd sg13_lv_nmos ad=0.272p pd=2.28u as=0.272p ps=2.28u w=0.8u l=2.5u
X783 gd a_43928_n10831# a_44530_n11335# gd sg13_lv_nmos ad=0.11875p pd=1.005u as=0.2125p ps=1.93u w=0.625u l=0.13u
X784 VP a_45394_7089# a_45996_6964# VP sg13_lv_pmos ad=0.2375p pd=1.63u as=0.2375p ps=1.63u w=1.25u l=0.13u
X785 gd a_44792_7593# a_45394_7089# gd sg13_lv_nmos ad=0.11875p pd=1.005u as=0.2125p ps=1.93u w=0.625u l=0.13u
X786 VP VCO_decoder_cells_0.after_000011 VCO_decoder_cells_0.VCO3_selection_0.NAND_4in_dek_0.b VP sg13_lv_pmos ad=0.1005p pd=1.34u as=0.1005p ps=1.34u w=0.15u l=0.13u
X787 gd a_45734_n11460# 0_buf_1.out gd sg13_lv_nmos ad=0.2375p pd=1.63u as=0.2375p ps=1.63u w=1.25u l=0.13u
X788 vco_passgate_4.OI vco_core_2_0.vco_delay_cell_2$6_0.pgt a_41461_4818# vco_passgate_4.OI sg13_lv_pmos ad=0.408p pd=3.08u as=0.408p ps=3.08u w=1.2u l=5u
X789 VP VCO_decoder_cells_0.000000_n VCO_decoder_cells_0.000000 VP sg13_lv_pmos ad=0.1005p pd=1.34u as=0.1005p ps=1.34u w=0.15u l=0.13u
X790 VP VCO_decoder_cells_0.VCO3_selection_0.NAND_4in_dek_1.c VCO_decoder_cells_0.VCO3_5_sel VP sg13_lv_pmos ad=0.1005p pd=1.34u as=0.1005p ps=1.34u w=0.15u l=0.13u
X791 PFD_passgate_3.B PFD_passgate_3.in_p vco_in VP sg13_lv_pmos ad=0.102p pd=1.28u as=0.102p ps=1.28u w=0.3u l=0.15u
X792 gd a_46598_6964# VCO_MUX_0.VCO3_in gd sg13_lv_nmos ad=0.2375p pd=1.63u as=0.2375p ps=1.63u w=1.25u l=0.13u
X793 a_4211_n1748# c2 gd gd sg13_lv_nmos ad=0.1005p pd=1.34u as=0.1005p ps=1.34u w=0.15u l=0.13u
X794 a_44680_n1157# a_44078_n653# VP VP sg13_lv_pmos ad=0.11875p pd=1.005u as=0.11875p ps=1.005u w=0.625u l=0.13u
X795 vco_core_4_0.vco_delay_cell_4_9.out vco_core_4_0.vco_delay_cell_4_0.out vco_core_4_0.vco_delay_cell_4_9.dn gd sg13_lv_nmos ad=0.272p pd=2.28u as=0.272p ps=2.28u w=0.8u l=15u
X796 vco_passgate_1.en_ vco_passgate_1.en VP VP sg13_lv_pmos ad=0.1005p pd=1.34u as=0.1005p ps=1.34u w=0.15u l=0.13u
X797 VCO_MUX_0.VCO_in VCO_MUX_0.inverter_dek_0.out out VP sg13_lv_pmos ad=95f pd=0.88u as=95f ps=0.88u w=0.5u l=0.13u
X798 VCO_MUX_0.VCO3_in a_46598_6964# gd gd sg13_lv_nmos ad=0.2375p pd=1.63u as=0.2375p ps=1.63u w=1.25u l=0.13u
X799 VCO_decoder_cells_0.101 VCO_decoder_cells_0.3bit_to_8_outs_0.NAND_3in_dek_3.y VP VP sg13_lv_pmos ad=0.1005p pd=1.34u as=0.1005p ps=1.34u w=0.15u l=0.13u
X800 a_42501_n2486# vco_core_0_0.vco_delay_cell_0$1_0.pgt vco_core_0_0.vp vco_core_0_0.vp sg13_lv_pmos ad=0.114p pd=0.98u as=0.204p ps=1.88u w=0.6u l=0.56u
X801 gd vco_passgate_1.en_ PFD_passgate_1.B gd sg13_lv_nmos ad=0.102p pd=1.28u as=0.102p ps=1.28u w=0.3u l=0.13u
X802 VCO_decoder_cells_0.VCO3_selection_0.NAND_4in_dek_1.b VCO_decoder_cells_0.100 a_10160_1054# gd sg13_lv_nmos ad=0.1005p pd=1.34u as=0.1005p ps=1.34u w=0.15u l=0.13u
X803 VP PFD_passgate_2.in_p vco_core_0_0.vp VP sg13_lv_pmos ad=0.11875p pd=1.005u as=0.2125p ps=1.93u w=0.625u l=0.13u
X804 gd vco_core_0_0.in a_41821_n2018# gd sg13_lv_nmos ad=0.136p pd=1.48u as=76f ps=0.78u w=0.4u l=0.56u
X805 VCO_decoder_cells_0.VCO3_5_sel VCO_decoder_cells_0.VCO3_selection_0.NAND_4in_dek_1.d VP VP sg13_lv_pmos ad=0.1005p pd=1.34u as=0.1005p ps=1.34u w=0.15u l=0.13u
X806 out VCO_MUX_0.inverter_dek_0.out VCO_MUX_0.VCO_in VP sg13_lv_pmos ad=95f pd=0.88u as=0.17p ps=1.68u w=0.5u l=0.13u
X807 VCO_decoder_cells_0.VCO2_selection_0.NAND_3in_dek_2.y VCO_decoder_cells_0.after_000111_n VP VP sg13_lv_pmos ad=0.1005p pd=1.34u as=0.1005p ps=1.34u w=0.15u l=0.13u
X808 a_10954_n1982# VCO_decoder_cells_0.VCO2_selection_0.NAND_3in_dek_1.b a_10738_n1982# gd sg13_lv_nmos ad=0.1005p pd=1.34u as=0.1005p ps=1.34u w=0.15u l=0.13u
X809 gd a_45734_n11460# 0_buf_1.out gd sg13_lv_nmos ad=0.2375p pd=1.63u as=0.2375p ps=1.63u w=1.25u l=0.13u
X810 a_44792_7593# a_44190_7593# VP VP sg13_lv_pmos ad=0.114p pd=0.98u as=0.114p ps=0.98u w=0.6u l=0.13u
X811 gd PFD_passgate_3.B a_38741_7152# gd sg13_lv_nmos ad=0.272p pd=2.28u as=0.272p ps=2.28u w=0.8u l=5u
X812 a_10624_1528# VCO_decoder_cells_0.000000_n gd gd sg13_lv_nmos ad=0.1005p pd=1.34u as=0.1005p ps=1.34u w=0.15u l=0.13u
X813 VCO_decoder_cells_0.VCO2_selection_0.NAND_4in_dek_1.c VCO_decoder_cells_0.000000_n VP VP sg13_lv_pmos ad=0.1005p pd=1.34u as=0.1005p ps=1.34u w=0.15u l=0.13u
X814 vco_passgate_0.OI vco_core_4_0.pgt vco_core_4_0.vco_delay_cell_4_6.up vco_passgate_0.OI sg13_lv_pmos ad=0.408p pd=3.08u as=0.408p ps=3.08u w=1.2u l=30u
X815 vco_core_2_0.vco_delay_cell_2$6_0.pgt PFD_passgate_3.B gd gd sg13_lv_nmos ad=0.272p pd=2.28u as=0.272p ps=2.28u w=0.8u l=6u
X816 a_40664_3420# vco_core_1_0.vco_delay_cell_1$1_6.in vco_core_1_0.vco_delay_cell_1$1_6.out vco_passgate_3.OI sg13_lv_pmos ad=0.204p pd=1.88u as=0.114p ps=0.98u w=0.6u l=0.7u
X817 VCO_decoder_cells_0.VCO2_selection_0.inverter_dek_0.out VCO_decoder_cells_0.VCO2_selection_0.NAND_3in_dek_1.y VP VP sg13_lv_pmos ad=0.1005p pd=1.34u as=0.1005p ps=1.34u w=0.15u l=0.13u
X818 gd a_44739_n5565# a_45341_n5690# gd sg13_lv_nmos ad=0.2375p pd=1.63u as=0.2375p ps=1.63u w=1.25u l=0.13u
X819 a_11143_n3464# VCO_decoder_cells_0.VCO2_selection_0.NAND_4in_dek_1.c a_10927_n3464# gd sg13_lv_nmos ad=0.1005p pd=1.34u as=0.1005p ps=1.34u w=0.15u l=0.13u
X820 VP VCO_decoder_cells_0.111 VCO_decoder_cells_0.VCO_selection_0.NAND_3in_dek_0.a VP sg13_lv_pmos ad=0.1005p pd=1.34u as=0.1005p ps=1.34u w=0.15u l=0.13u
X821 vco_core_1_0.vco_delay_cell_1$1_1.out vco_core_1_0.vco_delay_cell_1$1_0.out a_37196_1356# vco_passgate_3.OI sg13_lv_pmos ad=0.114p pd=0.98u as=0.204p ps=1.88u w=0.6u l=0.7u
X822 out VCO_MUX_0.VCO3_sel VCO_MUX_0.VCO3_in gd sg13_lv_nmos ad=0.1005p pd=1.34u as=0.1005p ps=1.34u w=0.15u l=0.13u
X823 gd a_45734_n11460# 0_buf_1.out gd sg13_lv_nmos ad=0.2375p pd=1.63u as=0.2375p ps=1.63u w=1.25u l=0.13u
X824 vco_passgate_0.OI vco_core_4_0.pgt vco_core_4_0.vco_delay_cell_4_8.up vco_passgate_0.OI sg13_lv_pmos ad=0.408p pd=3.08u as=0.408p ps=3.08u w=1.2u l=30u
X825 VCO_MUX_0.VCO3_in a_46598_6964# VP VP sg13_lv_pmos ad=0.425p pd=3.18u as=0.2375p ps=1.63u w=1.25u l=0.13u
X826 gd a_45394_7089# a_45996_6964# gd sg13_lv_nmos ad=0.2375p pd=1.63u as=0.2375p ps=1.63u w=1.25u l=0.13u
X827 VCO_decoder_cells_0.after_001111_n f5 gd gd sg13_lv_nmos ad=0.1005p pd=1.34u as=0.1005p ps=1.34u w=0.15u l=0.13u
X828 VCO_decoder_cells_0.011 VCO_decoder_cells_0.3bit_to_8_outs_0.inverter_dek_10.in gd gd sg13_lv_nmos ad=0.1005p pd=1.34u as=0.1005p ps=1.34u w=0.15u l=0.13u
X829 vco_core_3_0.vco_delay_cell_3_5.out vco_core_3_0.vco_delay_cell_3_5.in a_19702_n7843# vco_passgate_1.OI sg13_lv_pmos ad=0.408p pd=3.08u as=0.408p ps=3.08u w=1.2u l=8.5u
X830 VP a_44362_3221# a_44964_2717# VP sg13_lv_pmos ad=0.11875p pd=1.005u as=0.11875p ps=1.005u w=0.625u l=0.13u
X831 VCO_decoder_cells_0.110 VCO_decoder_cells_0.3bit_to_8_outs_0.inverter_dek_1.in gd gd sg13_lv_nmos ad=0.1005p pd=1.34u as=0.1005p ps=1.34u w=0.15u l=0.13u
X832 gd PFD_passgate_1.B a_30922_n5509# gd sg13_lv_nmos ad=0.272p pd=2.28u as=0.272p ps=2.28u w=0.8u l=17u
X833 VCO_decoder_cells_0.3bit_to_8_outs_0.inverter_dek_8.in VCO_decoder_cells_0.3bit_to_8_outs_0.c2_n VP VP sg13_lv_pmos ad=0.1005p pd=1.34u as=0.1005p ps=1.34u w=0.15u l=0.13u
X834 VCO_MUX_0.VCO2_in a_46168_2592# VP VP sg13_lv_pmos ad=0.2375p pd=1.63u as=0.2375p ps=1.63u w=1.25u l=0.13u
X835 inverter_x1_12.IN VCO_decoder_cells_0.VCO2_5_sel gd gd sg13_lv_nmos ad=0.1005p pd=1.34u as=55.5f ps=0.74u w=0.15u l=0.13u
X836 a_11327_n902# VCO_decoder_cells_0.VCO3_selection_0.NAND_3in_dek_4.b a_11111_n902# gd sg13_lv_nmos ad=0.1005p pd=1.34u as=0.1005p ps=1.34u w=0.15u l=0.13u
X837 a_37194_2990# vco_core_1_0.out vco_core_1_0.vco_delay_cell_1$1_2.in gd sg13_lv_nmos ad=0.136p pd=1.48u as=76f ps=0.78u w=0.4u l=0.7u
X838 vco_core_1_0.vco_delay_cell_1$1_5.in vco_core_1_0.nen11 vco_core_1_0.vco_delay_cell_1$1_3.out vco_passgate_3.OI sg13_lv_pmos ad=0.102p pd=1.28u as=0.102p ps=1.28u w=0.3u l=0.15u
X839 VCO_decoder_cells_0.VCO2_selection_0.NAND_4in_dek_0.d VCO_decoder_cells_0.111 a_9993_n5420# gd sg13_lv_nmos ad=0.1005p pd=1.34u as=0.1005p ps=1.34u w=0.15u l=0.13u
X840 VCO_decoder_cells_0.VCO2_5_sel VCO_decoder_cells_0.VCO2_selection_0.NAND_4in_dek_0.a a_11428_n5894# gd sg13_lv_nmos ad=0.1005p pd=1.34u as=0.1005p ps=1.34u w=0.15u l=0.13u
X841 vco_core_2_0.out vco_core_2_0.vco_delay_cell_2$6_8.in a_42005_7152# gd sg13_lv_nmos ad=0.272p pd=2.28u as=0.272p ps=2.28u w=0.8u l=2.5u
X842 a_4722_154# f5 VCO_decoder_cells_0.row_section_decoding_0.NAND_3in_dek_0.b VP sg13_lv_pmos ad=0.1005p pd=1.34u as=0.1005p ps=1.34u w=0.15u l=0.13u
X843 vco_core_3_0.vco_delay_cell_3_7.out vco_core_3_0.vco_delay_cell_3_7.in a_34662_n5509# gd sg13_lv_nmos ad=0.272p pd=2.28u as=0.272p ps=2.28u w=0.8u l=8.5u
X844 vco_passgate_4.OI PFD_passgate_3.in_p VP VP sg13_lv_pmos ad=0.2125p pd=1.93u as=0.11875p ps=1.005u w=0.625u l=0.13u
X845 VP a_45943_n5690# 0_buf_0.out VP sg13_lv_pmos ad=0.2375p pd=1.63u as=0.2375p ps=1.63u w=1.25u l=0.13u
X846 a_43760_3221# vco_core_1_0.out VP VP sg13_lv_pmos ad=71.25f pd=0.755u as=71.25f ps=0.755u w=0.375u l=0.13u
X847 gd a_45734_n11460# 0_buf_1.out gd sg13_lv_nmos ad=0.2375p pd=1.63u as=0.2375p ps=1.63u w=1.25u l=0.13u
X848 vco_passgate_1.OI vco_core_3_0.vco_delay_cell_3_0.pgt a_27182_n7843# vco_passgate_1.OI sg13_lv_pmos ad=0.408p pd=3.08u as=0.408p ps=3.08u w=1.2u l=17u
X849 vco_core_2_0.vco_delay_cell_2$6_4.out vco_core_2_0.out a_36021_8614# vco_passgate_4.OI sg13_lv_pmos ad=0.408p pd=3.08u as=0.408p ps=3.08u w=1.2u l=2.5u
X850 vco_core_4_0.vco_delay_cell_4_7.out vco_core_4_0.vco_delay_cell_4_8.out vco_core_4_0.vco_delay_cell_4_7.dn gd sg13_lv_nmos ad=0.272p pd=2.28u as=0.272p ps=2.28u w=0.8u l=15u
X851 gd PFD_passgate_3.B a_40101_6360# gd sg13_lv_nmos ad=0.272p pd=2.28u as=0.272p ps=2.28u w=0.8u l=5u
X852 a_43535_n5061# vco_core_3_0.out VP VP sg13_lv_pmos ad=71.25f pd=0.755u as=71.25f ps=0.755u w=0.375u l=0.13u
X853 VP VCO_decoder_cells_0.3bit_to_8_outs_0.c1_n VCO_decoder_cells_0.3bit_to_8_outs_0.NAND_3in_dek_3.y VP sg13_lv_pmos ad=0.1005p pd=1.34u as=0.1005p ps=1.34u w=0.15u l=0.13u
X854 VP VCO_decoder_cells_0.010 VCO_decoder_cells_0.VCO2_selection_0.NAND_3in_dek_1.a VP sg13_lv_pmos ad=0.1005p pd=1.34u as=0.1005p ps=1.34u w=0.15u l=0.13u
X855 VCO_MUX_0.VCO2_in a_46168_2592# gd gd sg13_lv_nmos ad=0.2375p pd=1.63u as=0.2375p ps=1.63u w=1.25u l=0.13u
X856 a_45734_n11460# a_45132_n11460# VP VP sg13_lv_pmos ad=0.2375p pd=1.63u as=0.2375p ps=1.63u w=1.25u l=0.13u
X857 a_10463_n5894# f5 gd gd sg13_lv_nmos ad=0.1005p pd=1.34u as=0.1005p ps=1.34u w=0.15u l=0.13u
X858 VCO_MUX_0.VCO3_in a_46598_6964# gd gd sg13_lv_nmos ad=0.425p pd=3.18u as=0.2375p ps=1.63u w=1.25u l=0.13u
X859 VP a_44964_2717# a_45566_2592# VP sg13_lv_pmos ad=0.2375p pd=1.63u as=0.2375p ps=1.63u w=1.25u l=0.13u
X860 vco_core_3_0.vco_delay_cell_3_3.in vco_core_3_0.vco_delay_cell_3_4.in a_27182_n6301# gd sg13_lv_nmos ad=0.272p pd=2.28u as=0.272p ps=2.28u w=0.8u l=8.5u
X861 NOR_2in$1_0.B VCO_decoder_cells_0.VCO4_selection_0.NAND_3in_dek_1.y VP VP sg13_lv_pmos ad=0.1005p pd=1.34u as=0.1005p ps=1.34u w=0.15u l=0.13u
X862 gd a_46168_2592# VCO_MUX_0.VCO2_in gd sg13_lv_nmos ad=0.2375p pd=1.63u as=0.2375p ps=1.63u w=1.25u l=0.13u
X863 a_45943_n5690# a_45341_n5690# gd gd sg13_lv_nmos ad=0.425p pd=3.18u as=0.2375p ps=1.63u w=1.25u l=0.13u
X864 vco_passgate_3.OI VCO_MUX_0.VCO2_sel VP gd sg13_lv_nmos ad=0.2125p pd=1.93u as=0.11875p ps=1.005u w=0.625u l=0.13u
X865 a_10160_1054# VCO_decoder_cells_0.000000_n a_9944_1054# gd sg13_lv_nmos ad=0.1005p pd=1.34u as=0.1005p ps=1.34u w=0.15u l=0.13u
X866 a_42226_2990# vco_core_1_0.vco_delay_cell_1$1_5.in vco_core_1_0.out gd sg13_lv_nmos ad=0.136p pd=1.48u as=76f ps=0.78u w=0.4u l=0.7u
X867 VCO_MUX_0.VCO2_in a_46168_2592# gd gd sg13_lv_nmos ad=0.2375p pd=1.63u as=0.2375p ps=1.63u w=1.25u l=0.13u
X868 a_44078_n653# a_43476_n653# gd gd sg13_lv_nmos ad=0.114p pd=0.98u as=0.204p ps=1.88u w=0.6u l=0.13u
X869 VCO_decoder_cells_0.VCO4_selection_0.NAND_2in_dek_0.y VCO_decoder_cells_0.001 VP VP sg13_lv_pmos ad=0.1005p pd=1.34u as=0.1005p ps=1.34u w=0.15u l=0.13u
X870 gd PFD_passgate_1.B a_23442_n5509# gd sg13_lv_nmos ad=0.272p pd=2.28u as=0.272p ps=2.28u w=0.8u l=17u
X871 VP VCO_MUX_0.VCO2_sel vco_passgate_3.OI gd sg13_lv_nmos ad=0.11875p pd=1.005u as=0.2125p ps=1.93u w=0.625u l=0.13u
X872 VCO_decoder_cells_0.3bit_to_8_outs_0.inverter_dek_1.in VCO_decoder_cells_0.3bit_to_8_outs_0.c0_n VP VP sg13_lv_pmos ad=0.1005p pd=1.34u as=0.1005p ps=1.34u w=0.15u l=0.13u
X873 vco_core_4_0.vco_delay_cell_4_5.dn PFD_passgate_0.B gd gd sg13_lv_nmos ad=0.272p pd=2.28u as=0.272p ps=2.28u w=0.8u l=30u
X874 VP a_45884_n1282# VCO_MUX_0.VCO_in VP sg13_lv_pmos ad=0.2375p pd=1.63u as=0.2375p ps=1.63u w=1.25u l=0.13u
X875 a_45943_n5690# a_45341_n5690# gd gd sg13_lv_nmos ad=0.2375p pd=1.63u as=0.2375p ps=1.63u w=1.25u l=0.13u
X876 a_43535_n5061# vco_core_3_0.out gd gd sg13_lv_nmos ad=76f pd=0.78u as=0.136p ps=1.48u w=0.4u l=0.13u
X877 gd vco_core_0_0.in a_41855_n914# gd sg13_lv_nmos ad=0.136p pd=1.48u as=76f ps=0.78u w=0.4u l=0.56u
X878 VP VCO_decoder_cells_0.after_000111 VCO_decoder_cells_0.VCO3_selection_0.NAND_3in_dek_4.b VP sg13_lv_pmos ad=0.1005p pd=1.34u as=0.1005p ps=1.34u w=0.15u l=0.13u
X879 VCO_decoder_cells_0.VCO2_selection_0.NAND_3in_dek_0.y VCO_decoder_cells_0.f5_n VP VP sg13_lv_pmos ad=0.1005p pd=1.34u as=0.1005p ps=1.34u w=0.15u l=0.13u
X880 gd VCO_MUX_0.VCO3_sel VCO_MUX_0.passgate_scaled_3.en_ gd sg13_lv_nmos ad=0.1005p pd=1.34u as=0.1005p ps=1.34u w=0.15u l=0.13u
X881 VCO_MUX_0.VCO_in a_45884_n1282# VP VP sg13_lv_pmos ad=0.2375p pd=1.63u as=0.2375p ps=1.63u w=1.25u l=0.13u
X882 VCO_decoder_cells_0.3bit_to_8_outs_0.NAND_3in_dek_2.y c0 VP VP sg13_lv_pmos ad=0.1005p pd=1.34u as=0.1005p ps=1.34u w=0.15u l=0.13u
X883 a_11310_n428# VCO_decoder_cells_0.VCO3_selection_0.NAND_4in_dek_1.c a_11094_n428# gd sg13_lv_nmos ad=0.1005p pd=1.34u as=0.1005p ps=1.34u w=0.15u l=0.13u
X884 a_4427_n1430# c1 a_4211_n1430# gd sg13_lv_nmos ad=0.1005p pd=1.34u as=0.1005p ps=1.34u w=0.15u l=0.13u
X885 a_45734_n11460# a_45132_n11460# gd gd sg13_lv_nmos ad=0.2375p pd=1.63u as=0.2375p ps=1.63u w=1.25u l=0.13u
X886 a_44964_2717# a_44362_3221# gd gd sg13_lv_nmos ad=0.2125p pd=1.93u as=0.11875p ps=1.005u w=0.625u l=0.13u
X887 VP f2 a_3770_154# VP sg13_lv_pmos ad=0.1005p pd=1.34u as=0.1005p ps=1.34u w=0.15u l=0.13u
X888 VP a_44739_n5565# a_45341_n5690# VP sg13_lv_pmos ad=0.2375p pd=1.63u as=0.425p ps=3.18u w=1.25u l=0.13u
X889 VP VCO_decoder_cells_0.VCO3_selection_0.NAND_2in_dek_0.y VCO_decoder_cells_0.VCO3_selection_0.NAND_2in_dek_1.y VP sg13_lv_pmos ad=0.1005p pd=1.34u as=0.1005p ps=1.34u w=0.15u l=0.13u
X890 VP VCO_decoder_cells_0.101 VCO_decoder_cells_0.VCO3_selection_0.NAND_4in_dek_1.c VP sg13_lv_pmos ad=0.1005p pd=1.34u as=0.1005p ps=1.34u w=0.15u l=0.13u
X891 0_buf_1.in vco_core_4_0.vco_delay_cell_4_7.out vco_core_4_0.vco_delay_cell_4_6.dn gd sg13_lv_nmos ad=0.272p pd=2.28u as=0.272p ps=2.28u w=0.8u l=15u
X892 a_45566_2592# a_44964_2717# gd gd sg13_lv_nmos ad=0.2375p pd=1.63u as=0.2375p ps=1.63u w=1.25u l=0.13u
X893 a_43476_n653# vco_core_0_0.out VP VP sg13_lv_pmos ad=0.1275p pd=1.43u as=71.25f ps=0.755u w=0.375u l=0.13u
X894 VP a_45734_n11460# 0_buf_1.out VP sg13_lv_pmos ad=0.2375p pd=1.63u as=0.2375p ps=1.63u w=1.25u l=0.13u
X895 vco_core_3_0.vco_delay_cell_3_1.in vco_core_3_0.vco_delay_cell_3_2.in a_34662_n7843# vco_passgate_1.OI sg13_lv_pmos ad=0.408p pd=3.08u as=0.408p ps=3.08u w=1.2u l=8.5u
X896 gd PFD_passgate_1.B vco_core_3_0.vco_delay_cell_3_0.pgt gd sg13_lv_nmos ad=0.272p pd=2.28u as=0.272p ps=2.28u w=0.8u l=17u
X897 VP vco_core_0_0.out a_43476_n653# VP sg13_lv_pmos ad=71.25f pd=0.755u as=0.1275p ps=1.43u w=0.375u l=0.13u
X898 out VCO_MUX_0.VCO_sel VCO_MUX_0.VCO_in gd sg13_lv_nmos ad=95f pd=0.88u as=95f ps=0.88u w=0.5u l=0.13u
X899 VCO_decoder_cells_0.VCO4_selection_0.NAND_3in_dek_1.y VCO_decoder_cells_0.after_000011 VP VP sg13_lv_pmos ad=0.1005p pd=1.34u as=0.1005p ps=1.34u w=0.15u l=0.13u
X900 vco_passgate_4.OI vco_core_2_0.vco_delay_cell_2$6_0.pgt a_36021_8614# vco_passgate_4.OI sg13_lv_pmos ad=0.408p pd=3.08u as=0.408p ps=3.08u w=1.2u l=5u
X901 VCO_decoder_cells_0.3bit_to_8_outs_0.inverter_dek_6.in VCO_decoder_cells_0.3bit_to_8_outs_0.c0_n VP VP sg13_lv_pmos ad=0.1005p pd=1.34u as=0.1005p ps=1.34u w=0.15u l=0.13u
X902 vco_core_4_0.vco_delay_cell_4_8.out vco_core_4_0.vco_delay_cell_4_10.out vco_core_4_0.vco_delay_cell_4_8.up vco_passgate_0.OI sg13_lv_pmos ad=0.408p pd=3.08u as=0.408p ps=3.08u w=1.2u l=15u
X903 VP a_46168_2592# VCO_MUX_0.VCO2_in VP sg13_lv_pmos ad=0.2375p pd=1.63u as=0.2375p ps=1.63u w=1.25u l=0.13u
X904 VCO_decoder_cells_0.row_section_decoding_0.NAND_3in_dek_0.c f0 gd gd sg13_lv_nmos ad=0.1005p pd=1.34u as=0.1005p ps=1.34u w=0.15u l=0.13u
X905 vco_core_0_0.in VCO_MUX_0.VCO_sel vco_in gd sg13_lv_nmos ad=0.102p pd=1.28u as=0.102p ps=1.28u w=0.3u l=0.15u
X906 PFD_passgate_4.B VCO_MUX_0.VCO2_sel vco_in gd sg13_lv_nmos ad=0.102p pd=1.28u as=0.102p ps=1.28u w=0.3u l=0.15u
X907 a_39506_1826# vco_core_1_0.vco_delay_cell_1$1_7.in vco_core_1_0.vco_delay_cell_1$1_4.in gd sg13_lv_nmos ad=0.136p pd=1.48u as=76f ps=0.78u w=0.4u l=0.7u
X908 VCO_MUX_0.VCO2_in a_46168_2592# VP VP sg13_lv_pmos ad=0.2375p pd=1.63u as=0.2375p ps=1.63u w=1.25u l=0.13u
X909 0_buf_0.out a_45943_n5690# VP VP sg13_lv_pmos ad=0.425p pd=3.18u as=0.2375p ps=1.63u w=1.25u l=0.13u
X910 VP NOR_2in$1_0.B vco_core_3_0.nen5 VP sg13_lv_pmos ad=0.1005p pd=1.34u as=0.1005p ps=1.34u w=0.15u l=0.13u
X911 a_46598_6964# a_45996_6964# VP VP sg13_lv_pmos ad=0.425p pd=3.18u as=0.2375p ps=1.63u w=1.25u l=0.13u
X912 VCO_decoder_cells_0.3bit_to_8_outs_0.c0_n c0 VP VP sg13_lv_pmos ad=0.1005p pd=1.34u as=0.1005p ps=1.34u w=0.15u l=0.13u
X913 a_43928_n10831# a_43326_n10831# gd gd sg13_lv_nmos ad=0.114p pd=0.98u as=0.204p ps=1.88u w=0.6u l=0.13u
X914 VP vco_passgate_1.en vco_passgate_1.OI gd sg13_lv_nmos ad=0.11875p pd=1.005u as=0.11875p ps=1.005u w=0.625u l=0.13u
X915 VP a_43535_n5061# a_44137_n5061# VP sg13_lv_pmos ad=0.114p pd=0.98u as=0.114p ps=0.98u w=0.6u l=0.13u
X916 gd a_45943_n5690# 0_buf_0.out gd sg13_lv_nmos ad=0.2375p pd=1.63u as=0.2375p ps=1.63u w=1.25u l=0.13u
X917 VP a_45996_6964# a_46598_6964# VP sg13_lv_pmos ad=0.2375p pd=1.63u as=0.2375p ps=1.63u w=1.25u l=0.13u
X918 VP a_45734_n11460# 0_buf_1.out VP sg13_lv_pmos ad=0.2375p pd=1.63u as=0.2375p ps=1.63u w=1.25u l=0.13u
X919 0_buf_0.out a_45943_n5690# VP VP sg13_lv_pmos ad=0.2375p pd=1.63u as=0.2375p ps=1.63u w=1.25u l=0.13u
X920 vco_passgate_4.OI vco_core_2_0.vco_delay_cell_2$6_0.pgt a_37381_4818# vco_passgate_4.OI sg13_lv_pmos ad=0.408p pd=3.08u as=0.408p ps=3.08u w=1.2u l=5u
X921 gd a_45943_n5690# 0_buf_0.out gd sg13_lv_nmos ad=0.2375p pd=1.63u as=0.2375p ps=1.63u w=1.25u l=0.13u
X922 VCO_decoder_cells_0.VCO2_selection_0.NAND_3in_dek_1.y VCO_decoder_cells_0.VCO2_selection_0.NAND_3in_dek_0.y VP VP sg13_lv_pmos ad=0.1005p pd=1.34u as=0.1005p ps=1.34u w=0.15u l=0.13u
X923 a_36108_1356# vco_core_1_0.vco_delay_cell_1$1_0.pgt vco_passgate_3.OI vco_passgate_3.OI sg13_lv_pmos ad=0.114p pd=0.98u as=0.204p ps=1.88u w=0.6u l=1.4u
X924 VP a_44680_n1157# a_45282_n1282# VP sg13_lv_pmos ad=0.2375p pd=1.63u as=0.425p ps=3.18u w=1.25u l=0.13u
X925 VCO_decoder_cells_0.VCO2_selection_0.inverter_dek_0.out VCO_decoder_cells_0.VCO2_selection_0.NAND_3in_dek_1.y gd gd sg13_lv_nmos ad=0.1005p pd=1.34u as=0.1005p ps=1.34u w=0.15u l=0.13u
X926 VCO_decoder_cells_0.VCO2_selection_0.NAND_3in_dek_2.y VCO_decoder_cells_0.101 a_10673_n3938# gd sg13_lv_nmos ad=0.1005p pd=1.34u as=0.1005p ps=1.34u w=0.15u l=0.13u
X927 gd PFD_passgate_4.in_p vco_passgate_3.OI gd sg13_lv_nmos ad=0.102p pd=1.28u as=0.102p ps=1.28u w=0.3u l=0.13u
X928 VCO_decoder_cells_0.3bit_to_8_outs_0.NAND_3in_dek_0.y c0 a_3747_n1430# gd sg13_lv_nmos ad=0.1005p pd=1.34u as=0.1005p ps=1.34u w=0.15u l=0.13u
X929 VP VCO_decoder_cells_0.VCO4_selection_0.NAND_4in_dek_0.d NOR_2in$1_0.B VP sg13_lv_pmos ad=0.1005p pd=1.34u as=0.1005p ps=1.34u w=0.15u l=0.13u
X930 vco_core_2_0.vco_delay_cell_2$6_6.in vco_core_2_0.nen11 vco_core_2_0.vco_delay_cell_2$6_9.out vco_passgate_4.OI sg13_lv_pmos ad=0.102p pd=1.28u as=0.102p ps=1.28u w=0.3u l=0.15u
X931 vco_passgate_3.OI vco_core_1_0.vco_delay_cell_1$1_0.pgt a_39508_1356# vco_passgate_3.OI sg13_lv_pmos ad=0.204p pd=1.88u as=0.114p ps=0.98u w=0.6u l=1.4u
X932 vco_core_0_0.vp vco_core_0_0.vco_delay_cell_0$1_0.pgt a_41855_n486# vco_core_0_0.vp sg13_lv_pmos ad=0.204p pd=1.88u as=0.114p ps=0.98u w=0.6u l=0.56u
X933 a_3747_n1748# VCO_decoder_cells_0.3bit_to_8_outs_0.c1_n a_3531_n1748# gd sg13_lv_nmos ad=0.1005p pd=1.34u as=0.1005p ps=1.34u w=0.15u l=0.13u
X934 vco_core_3_0.vco_delay_cell_3_7.in vco_core_3_0.vco_delay_cell_3_8.in a_30922_n4047# vco_passgate_1.OI sg13_lv_pmos ad=0.408p pd=3.08u as=0.408p ps=3.08u w=1.2u l=8.5u
X935 VP VCO_decoder_cells_0.VCO3_5_sel vco_core_2_0.nen5 VP sg13_lv_pmos ad=0.1005p pd=1.34u as=0.1005p ps=1.34u w=0.15u l=0.13u
X936 VCO_MUX_0.VCO2_in a_46168_2592# gd gd sg13_lv_nmos ad=0.2375p pd=1.63u as=0.2375p ps=1.63u w=1.25u l=0.13u
X937 gd a_43476_n653# a_44078_n653# gd sg13_lv_nmos ad=0.204p pd=1.88u as=0.114p ps=0.98u w=0.6u l=0.13u
X938 gd a_44137_n5061# a_44739_n5565# gd sg13_lv_nmos ad=0.11875p pd=1.005u as=0.2125p ps=1.93u w=0.625u l=0.13u
X939 a_41209_n2486# vco_core_0_0.vco_delay_cell_0$1_2.in vco_core_0_0.vco_delay_cell_0$1_1.in vco_core_0_0.vp sg13_lv_pmos ad=0.204p pd=1.88u as=0.114p ps=0.98u w=0.6u l=0.28u
X940 VP a_44792_7593# a_45394_7089# VP sg13_lv_pmos ad=0.11875p pd=1.005u as=0.2125p ps=1.93u w=0.625u l=0.13u
X941 vco_core_2_0.vco_delay_cell_2$6_6.out vco_core_2_0.vco_delay_cell_2$6_6.in a_34661_6360# gd sg13_lv_nmos ad=0.272p pd=2.28u as=0.272p ps=2.28u w=0.8u l=2.5u
X942 gd a_46168_2592# VCO_MUX_0.VCO2_in gd sg13_lv_nmos ad=0.2375p pd=1.63u as=0.2375p ps=1.63u w=1.25u l=0.13u
X943 vco_passgate_3.OI vco_core_1_0.vco_delay_cell_1$1_0.pgt a_39508_3420# vco_passgate_3.OI sg13_lv_pmos ad=0.204p pd=1.88u as=0.114p ps=0.98u w=0.6u l=1.4u
X944 VCO_MUX_0.VCO3_in a_46598_6964# VP VP sg13_lv_pmos ad=0.2375p pd=1.63u as=0.2375p ps=1.63u w=1.25u l=0.13u
X945 vco_core_2_0.vco_delay_cell_2$6_0.out vco_core_2_0.vco_delay_cell_2$6_0.in a_41461_4818# vco_passgate_4.OI sg13_lv_pmos ad=0.408p pd=3.08u as=0.408p ps=3.08u w=1.2u l=2.5u
X946 a_46598_6964# a_45996_6964# gd gd sg13_lv_nmos ad=0.425p pd=3.18u as=0.2375p ps=1.63u w=1.25u l=0.13u
X947 gd a_45341_n5690# a_45943_n5690# gd sg13_lv_nmos ad=0.2375p pd=1.63u as=0.425p ps=3.18u w=1.25u l=0.13u
X948 VP a_46598_6964# VCO_MUX_0.VCO3_in VP sg13_lv_pmos ad=0.2375p pd=1.63u as=0.425p ps=3.18u w=1.25u l=0.13u
X949 a_11094_n428# VCO_decoder_cells_0.VCO3_selection_0.NAND_4in_dek_1.d gd gd sg13_lv_nmos ad=0.1005p pd=1.34u as=0.1005p ps=1.34u w=0.15u l=0.13u
X950 gd PFD_passgate_1.B a_27182_n6301# gd sg13_lv_nmos ad=0.272p pd=2.28u as=0.272p ps=2.28u w=0.8u l=17u
X951 a_45341_n5690# a_44739_n5565# VP VP sg13_lv_pmos ad=0.2375p pd=1.63u as=0.2375p ps=1.63u w=1.25u l=0.13u
X952 gd a_45996_6964# a_46598_6964# gd sg13_lv_nmos ad=0.2375p pd=1.63u as=0.2375p ps=1.63u w=1.25u l=0.13u
X953 a_9777_n3464# VCO_decoder_cells_0.000000_n gd gd sg13_lv_nmos ad=0.1005p pd=1.34u as=0.1005p ps=1.34u w=0.15u l=0.13u
X954 VCO_MUX_0.VCO_in a_45884_n1282# VP VP sg13_lv_pmos ad=0.2375p pd=1.63u as=0.2375p ps=1.63u w=1.25u l=0.13u
X955 VCO_MUX_0.VCO_in a_45884_n1282# gd gd sg13_lv_nmos ad=0.425p pd=3.18u as=0.2375p ps=1.63u w=1.25u l=0.13u
X956 VCO_decoder_cells_0.VCO2_selection_0.NAND_4in_dek_1.d VCO_decoder_cells_0.after_000011_n VP VP sg13_lv_pmos ad=0.1005p pd=1.34u as=0.1005p ps=1.34u w=0.15u l=0.13u
X957 VCO_MUX_0.VCO3_sel NOR_2in$1_1.Out VP VP sg13_lv_pmos ad=0.1005p pd=1.34u as=0.1005p ps=1.34u w=0.15u l=0.13u
X958 a_4506_2110# f4 VCO_decoder_cells_0.after_000111_n VP sg13_lv_pmos ad=0.1005p pd=1.34u as=0.1005p ps=1.34u w=0.15u l=0.13u
X959 VP a_45282_n1282# a_45884_n1282# VP sg13_lv_pmos ad=0.2375p pd=1.63u as=0.425p ps=3.18u w=1.25u l=0.13u
X960 VP c1 VCO_decoder_cells_0.3bit_to_8_outs_0.NAND_3in_dek_0.y VP sg13_lv_pmos ad=0.1005p pd=1.34u as=0.1005p ps=1.34u w=0.15u l=0.13u
X961 VP a_43928_n10831# a_44530_n11335# VP sg13_lv_pmos ad=0.11875p pd=1.005u as=0.2125p ps=1.93u w=0.625u l=0.13u
X962 VCO_decoder_cells_0.VCO2_5_sel VCO_decoder_cells_0.VCO2_selection_0.NAND_4in_dek_0.b VP VP sg13_lv_pmos ad=0.1005p pd=1.34u as=0.1005p ps=1.34u w=0.15u l=0.13u
X963 gd VCO_decoder_cells_0.VCO2_5_sel vco_core_1_0.nen5 gd sg13_lv_nmos ad=0.1005p pd=1.34u as=0.1005p ps=1.34u w=0.15u l=0.13u
X964 VCO_MUX_0.VCO_in a_45884_n1282# gd gd sg13_lv_nmos ad=0.2375p pd=1.63u as=0.2375p ps=1.63u w=1.25u l=0.13u
X965 VP VCO_decoder_cells_0.VCO_selection_0.NAND_3in_dek_0.a VCO_MUX_0.VCO_sel VP sg13_lv_pmos ad=0.1005p pd=1.34u as=0.1005p ps=1.34u w=0.15u l=0.13u
X966 VCO_decoder_cells_0.VCO3_selection_0.NAND_4in_dek_0.d VCO_decoder_cells_0.000000 VP VP sg13_lv_pmos ad=0.1005p pd=1.34u as=0.1005p ps=1.34u w=0.15u l=0.13u
X967 VCO_decoder_cells_0.VCO2_selection_0.NAND_3in_dek_1.a VCO_decoder_cells_0.010 a_9777_n1982# gd sg13_lv_nmos ad=0.1005p pd=1.34u as=0.1005p ps=1.34u w=0.15u l=0.13u
X968 vco_core_3_0.vco_delay_cell_3_9.in vco_core_3_0.out a_23442_n4047# vco_passgate_1.OI sg13_lv_pmos ad=0.408p pd=3.08u as=0.408p ps=3.08u w=1.2u l=8.5u
X969 vco_core_1_0.vco_delay_cell_1$1_4.in vco_core_1_0.vco_delay_cell_1$1_7.in a_39506_1826# gd sg13_lv_nmos ad=76f pd=0.78u as=0.136p ps=1.48u w=0.4u l=0.7u
X970 a_41209_n2018# vco_core_0_0.vco_delay_cell_0$1_2.in vco_core_0_0.vco_delay_cell_0$1_1.in gd sg13_lv_nmos ad=0.136p pd=1.48u as=76f ps=0.78u w=0.4u l=0.28u
X971 vco_core_1_0.vco_delay_cell_1$1_6.out vco_core_1_0.vco_delay_cell_1$1_6.in a_40662_2990# gd sg13_lv_nmos ad=76f pd=0.78u as=0.136p ps=1.48u w=0.4u l=0.7u
X972 gd vco_core_0_0.in vco_core_0_0.vco_delay_cell_0$1_0.pgt gd sg13_lv_nmos ad=0.136p pd=1.48u as=76f ps=0.78u w=0.4u l=0.56u
X973 out VCO_MUX_0.passgate_scaled_3.en_ VCO_MUX_0.VCO3_in VP sg13_lv_pmos ad=0.1005p pd=1.34u as=0.1005p ps=1.34u w=0.15u l=0.13u
X974 a_10253_n7436# VCO_decoder_cells_0.000000 gd gd sg13_lv_nmos ad=0.1005p pd=1.34u as=0.1005p ps=1.34u w=0.15u l=0.13u
X975 VP VCO_decoder_cells_0.VCO4_selection_0.NAND_2in_dek_0.y NOR_2in$1_0.A VP sg13_lv_pmos ad=0.1005p pd=1.34u as=0.1005p ps=1.34u w=0.15u l=0.13u
X976 a_44137_n5061# a_43535_n5061# VP VP sg13_lv_pmos ad=0.204p pd=1.88u as=0.114p ps=0.98u w=0.6u l=0.13u
X977 VCO_decoder_cells_0.VCO3_selection_0.NAND_4in_dek_0.c VCO_decoder_cells_0.011 VP VP sg13_lv_pmos ad=0.1005p pd=1.34u as=0.1005p ps=1.34u w=0.15u l=0.13u
X978 a_5000_n4888# VCO_decoder_cells_0.after_000011_n a_4784_n4888# gd sg13_lv_nmos ad=0.1005p pd=1.34u as=0.1005p ps=1.34u w=0.15u l=0.13u
X979 VP a_43760_3221# a_44362_3221# VP sg13_lv_pmos ad=0.114p pd=0.98u as=0.204p ps=1.88u w=0.6u l=0.13u
X980 0_buf_1.out a_45734_n11460# VP VP sg13_lv_pmos ad=0.2375p pd=1.63u as=0.2375p ps=1.63u w=1.25u l=0.13u
X981 VP a_44530_n11335# a_45132_n11460# VP sg13_lv_pmos ad=0.2375p pd=1.63u as=0.2375p ps=1.63u w=1.25u l=0.13u
X982 VCO_MUX_0.VCO3_in a_46598_6964# gd gd sg13_lv_nmos ad=0.2375p pd=1.63u as=0.2375p ps=1.63u w=1.25u l=0.13u
X983 vco_passgate_4.OI VCO_MUX_0.VCO3_sel VP gd sg13_lv_nmos ad=0.2125p pd=1.93u as=0.11875p ps=1.005u w=0.625u l=0.13u
X984 vco_core_1_0.vco_delay_cell_1$1_2.out vco_core_1_0.vco_delay_cell_1$1_2.in a_38352_3420# vco_passgate_3.OI sg13_lv_pmos ad=0.114p pd=0.98u as=0.204p ps=1.88u w=0.6u l=0.7u
X985 a_10692_n5420# VCO_decoder_cells_0.after_000111 a_10476_n5420# gd sg13_lv_nmos ad=0.1005p pd=1.34u as=0.1005p ps=1.34u w=0.15u l=0.13u
X986 gd PFD_passgate_3.B a_36021_6360# gd sg13_lv_nmos ad=0.272p pd=2.28u as=0.272p ps=2.28u w=0.8u l=5u
X987 inverter_x1_2.IN VCO_decoder_cells_0.VCO5_selection_0.NAND_2in_dek_0.a a_10729_n7436# gd sg13_lv_nmos ad=0.1005p pd=1.34u as=0.1005p ps=1.34u w=0.15u l=0.13u
X988 gd a_46598_6964# VCO_MUX_0.VCO3_in gd sg13_lv_nmos ad=0.2375p pd=1.63u as=0.425p ps=3.18u w=1.25u l=0.13u
X989 a_46168_2592# a_45566_2592# VP VP sg13_lv_pmos ad=0.425p pd=3.18u as=0.2375p ps=1.63u w=1.25u l=0.13u
X990 VP f1 a_4246_154# VP sg13_lv_pmos ad=0.1005p pd=1.34u as=0.1005p ps=1.34u w=0.15u l=0.13u
X991 0_buf_0.out a_45943_n5690# gd gd sg13_lv_nmos ad=0.2375p pd=1.63u as=0.2375p ps=1.63u w=1.25u l=0.13u
X992 VP a_45566_2592# a_46168_2592# VP sg13_lv_pmos ad=0.2375p pd=1.63u as=0.2375p ps=1.63u w=1.25u l=0.13u
X993 gd a_45132_n11460# a_45734_n11460# gd sg13_lv_nmos ad=0.2375p pd=1.63u as=0.425p ps=3.18u w=1.25u l=0.13u
X994 NOR_2in$1_0.Out NOR_2in$1_0.B a_14717_n4830# VP sg13_lv_pmos ad=0.1005p pd=1.34u as=55.5f ps=0.74u w=0.15u l=0.13u
X995 VP VCO_decoder_cells_0.VCO4_selection_0.NAND_4in_dek_0.b NOR_2in$1_0.B VP sg13_lv_pmos ad=0.1005p pd=1.34u as=0.1005p ps=1.34u w=0.15u l=0.13u
X996 a_46168_2592# a_45566_2592# VP VP sg13_lv_pmos ad=0.2375p pd=1.63u as=0.2375p ps=1.63u w=1.25u l=0.13u
X997 vco_core_0_0.vp VCO_MUX_0.VCO_sel VP gd sg13_lv_nmos ad=0.11875p pd=1.005u as=0.11875p ps=1.005u w=0.625u l=0.13u
X998 vco_core_1_0.vco_delay_cell_1$1_5.in vco_core_1_0.nen5 vco_core_1_0.vco_delay_cell_1$1_6.out vco_passgate_3.OI sg13_lv_pmos ad=0.102p pd=1.28u as=0.102p ps=1.28u w=0.3u l=0.15u
X999 gd VCO_decoder_cells_0.row_section_decoding_0.NAND_2in_dek_0.b a_4246_1132# gd sg13_lv_nmos ad=0.1005p pd=1.34u as=0.1005p ps=1.34u w=0.15u l=0.13u
X1000 0_buf_0.out a_45943_n5690# gd gd sg13_lv_nmos ad=0.2375p pd=1.63u as=0.2375p ps=1.63u w=1.25u l=0.13u
X1001 gd PFD_passgate_3.B a_41461_6360# gd sg13_lv_nmos ad=0.272p pd=2.28u as=0.272p ps=2.28u w=0.8u l=5u
X1002 gd f4 VCO_decoder_cells_0.row_section_decoding_0.NAND_3in_dek_0.b gd sg13_lv_nmos ad=0.1005p pd=1.34u as=0.1005p ps=1.34u w=0.15u l=0.13u
X1003 a_45282_n1282# a_44680_n1157# gd gd sg13_lv_nmos ad=0.2375p pd=1.63u as=0.2375p ps=1.63u w=1.25u l=0.13u
X1004 VCO_decoder_cells_0.3bit_to_8_outs_0.NAND_3in_dek_3.y c2 VP VP sg13_lv_pmos ad=0.1005p pd=1.34u as=0.1005p ps=1.34u w=0.15u l=0.13u
X1005 VP a_44530_n11335# a_45132_n11460# VP sg13_lv_pmos ad=0.2375p pd=1.63u as=0.425p ps=3.18u w=1.25u l=0.13u
X1006 gd PFD_passgate_4.B a_39506_1826# gd sg13_lv_nmos ad=0.136p pd=1.48u as=76f ps=0.78u w=0.4u l=1.4u
X1007 a_42467_n914# vco_core_0_0.vco_delay_cell_0$1_0.in vco_core_0_0.out gd sg13_lv_nmos ad=0.136p pd=1.48u as=76f ps=0.78u w=0.4u l=0.28u
X1008 a_3531_n3392# VCO_decoder_cells_0.3bit_to_8_outs_0.c2_n gd gd sg13_lv_nmos ad=0.1005p pd=1.34u as=0.1005p ps=1.34u w=0.15u l=0.13u
X1009 VP a_45341_n5690# a_45943_n5690# VP sg13_lv_pmos ad=0.2375p pd=1.63u as=0.2375p ps=1.63u w=1.25u l=0.13u
X1010 a_41750_1826# vco_core_1_0.vco_delay_cell_1$1_3.in vco_core_1_0.vco_delay_cell_1$1_3.out gd sg13_lv_nmos ad=0.136p pd=1.48u as=76f ps=0.78u w=0.4u l=0.7u
X1011 0_buf_1.out a_45734_n11460# VP VP sg13_lv_pmos ad=0.2375p pd=1.63u as=0.2375p ps=1.63u w=1.25u l=0.13u
X1012 gd PFD_passgate_4.B a_39506_2990# gd sg13_lv_nmos ad=0.136p pd=1.48u as=76f ps=0.78u w=0.4u l=1.4u
X1013 a_42501_n2018# vco_core_0_0.in gd gd sg13_lv_nmos ad=76f pd=0.78u as=0.136p ps=1.48u w=0.4u l=0.56u
X1014 VP VCO_decoder_cells_0.VCO2_selection_0.inverter_dek_0.out VCO_decoder_cells_0.VCO2_11_sel VP sg13_lv_pmos ad=0.1005p pd=1.34u as=0.1005p ps=1.34u w=0.15u l=0.13u
X1015 0_buf_1.out a_45734_n11460# gd gd sg13_lv_nmos ad=0.2375p pd=1.63u as=0.2375p ps=1.63u w=1.25u l=0.13u
X1016 gd VCO_decoder_cells_0.000000_n VCO_decoder_cells_0.000000 gd sg13_lv_nmos ad=0.1005p pd=1.34u as=0.1005p ps=1.34u w=0.15u l=0.13u
X1017 VP a_45341_n5690# a_45943_n5690# VP sg13_lv_pmos ad=0.2375p pd=1.63u as=0.2375p ps=1.63u w=1.25u l=0.13u
X1018 VCO_decoder_cells_0.VCO3_selection_0.NAND_4in_dek_0.c VCO_decoder_cells_0.000000_n VP VP sg13_lv_pmos ad=0.1005p pd=1.34u as=0.1005p ps=1.34u w=0.15u l=0.13u
X1019 gd a_43928_n10831# a_44530_n11335# gd sg13_lv_nmos ad=0.11875p pd=1.005u as=0.11875p ps=1.005u w=0.625u l=0.13u
X1020 VCO_decoder_cells_0.VCO2_selection_0.NAND_4in_dek_0.d VCO_decoder_cells_0.111 VP VP sg13_lv_pmos ad=0.1005p pd=1.34u as=0.1005p ps=1.34u w=0.15u l=0.13u
X1021 VCO_decoder_cells_0.VCO2_selection_0.NAND_4in_dek_0.a VCO_decoder_cells_0.110 VP VP sg13_lv_pmos ad=0.1005p pd=1.34u as=0.1005p ps=1.34u w=0.15u l=0.13u
X1022 VCO_MUX_0.VCO3_in a_46598_6964# VP VP sg13_lv_pmos ad=0.2375p pd=1.63u as=0.2375p ps=1.63u w=1.25u l=0.13u
X1023 gd vco_core_1_0.out a_43760_3221# gd sg13_lv_nmos ad=0.136p pd=1.48u as=76f ps=0.78u w=0.4u l=0.13u
X1024 vco_core_4_0.vco_delay_cell_4_3.up vco_core_4_0.pgt vco_passgate_0.OI vco_passgate_0.OI sg13_lv_pmos ad=0.408p pd=3.08u as=0.408p ps=3.08u w=1.2u l=30u
X1025 a_46168_2592# a_45566_2592# gd gd sg13_lv_nmos ad=0.2375p pd=1.63u as=0.2375p ps=1.63u w=1.25u l=0.13u
X1026 a_38350_1826# vco_core_1_0.vco_delay_cell_1$1_1.out vco_core_1_0.vco_delay_cell_1$1_7.in gd sg13_lv_nmos ad=0.136p pd=1.48u as=76f ps=0.78u w=0.4u l=0.7u
X1027 0_buf_1.out a_45734_n11460# VP VP sg13_lv_pmos ad=0.2375p pd=1.63u as=0.2375p ps=1.63u w=1.25u l=0.13u
X1028 vco_passgate_1.en NOR_2in$1_0.Out gd gd sg13_lv_nmos ad=0.1005p pd=1.34u as=0.1005p ps=1.34u w=0.15u l=0.13u
X1029 vco_core_0_0.vco_delay_cell_0$1_1.in vco_core_0_0.vco_delay_cell_0$1_2.in a_41209_n2486# vco_core_0_0.vp sg13_lv_pmos ad=0.114p pd=0.98u as=0.204p ps=1.88u w=0.6u l=0.28u
X1030 vco_core_4_0.vco_delay_cell_4_2.up vco_core_4_0.vco_delay_cell_4_2.in vco_core_4_0.vco_delay_cell_4_1.in vco_passgate_0.OI sg13_lv_pmos ad=0.408p pd=3.08u as=0.408p ps=3.08u w=1.2u l=15u
X1031 VP a_46598_6964# VCO_MUX_0.VCO3_in VP sg13_lv_pmos ad=0.2375p pd=1.63u as=0.2375p ps=1.63u w=1.25u l=0.13u
X1032 gd PFD_passgate_3.in_p vco_passgate_4.OI gd sg13_lv_nmos ad=0.102p pd=1.28u as=0.102p ps=1.28u w=0.3u l=0.13u
X1033 gd a_45566_2592# a_46168_2592# gd sg13_lv_nmos ad=0.2375p pd=1.63u as=0.425p ps=3.18u w=1.25u l=0.13u
X1034 VP f2 a_4722_628# VP sg13_lv_pmos ad=0.1005p pd=1.34u as=0.1005p ps=1.34u w=0.15u l=0.13u
X1035 VP a_43476_n653# a_44078_n653# VP sg13_lv_pmos ad=0.114p pd=0.98u as=0.114p ps=0.98u w=0.6u l=0.13u
X1036 VCO_decoder_cells_0.3bit_to_8_outs_0.NAND_3in_dek_0.y c2 VP VP sg13_lv_pmos ad=0.1005p pd=1.34u as=0.1005p ps=1.34u w=0.15u l=0.13u
X1037 a_4211_n1430# c2 gd gd sg13_lv_nmos ad=0.1005p pd=1.34u as=0.1005p ps=1.34u w=0.15u l=0.13u
X1038 VCO_decoder_cells_0.100 VCO_decoder_cells_0.3bit_to_8_outs_0.inverter_dek_6.in gd gd sg13_lv_nmos ad=0.1005p pd=1.34u as=0.1005p ps=1.34u w=0.15u l=0.13u
X1039 VCO_decoder_cells_0.VCO2_11_sel VCO_decoder_cells_0.VCO2_selection_0.NAND_4in_dek_1.d VP VP sg13_lv_pmos ad=0.1005p pd=1.34u as=0.1005p ps=1.34u w=0.15u l=0.13u
X1040 VP VCO_MUX_0.VCO3_sel VCO_MUX_0.passgate_scaled_3.en_ VP sg13_lv_pmos ad=0.1005p pd=1.34u as=0.1005p ps=1.34u w=0.15u l=0.13u
X1041 0_buf_1.out a_45734_n11460# gd gd sg13_lv_nmos ad=0.2375p pd=1.63u as=0.2375p ps=1.63u w=1.25u l=0.13u
X1042 VP VCO_decoder_cells_0.VCO2_5_sel vco_core_1_0.nen5 VP sg13_lv_pmos ad=0.1005p pd=1.34u as=0.1005p ps=1.34u w=0.15u l=0.13u
X1043 a_3510_2110# f5 VCO_decoder_cells_0.after_001111_n VP sg13_lv_pmos ad=0.1005p pd=1.34u as=0.1005p ps=1.34u w=0.15u l=0.13u
X1044 a_44362_3221# a_43760_3221# gd gd sg13_lv_nmos ad=0.114p pd=0.98u as=0.204p ps=1.88u w=0.6u l=0.13u
X1045 VP VCO_decoder_cells_0.after_000111_n VCO_decoder_cells_0.after_000111 VP sg13_lv_pmos ad=0.1005p pd=1.34u as=0.1005p ps=1.34u w=0.15u l=0.13u
X1046 VCO_decoder_cells_0.VCO3_selection_0.NAND_2in_dek_1.y VCO_decoder_cells_0.VCO3_selection_0.NAND_2in_dek_0.y a_11106_3010# gd sg13_lv_nmos ad=0.1005p pd=1.34u as=0.1005p ps=1.34u w=0.15u l=0.13u
X1047 VP a_45282_n1282# a_45884_n1282# VP sg13_lv_pmos ad=0.2375p pd=1.63u as=0.2375p ps=1.63u w=1.25u l=0.13u
X1048 vco_core_2_0.out vco_core_2_0.vco_delay_cell_2$6_8.in a_42005_8614# vco_passgate_4.OI sg13_lv_pmos ad=0.408p pd=3.08u as=0.408p ps=3.08u w=1.2u l=2.5u
X1049 VP vco_core_2_0.out a_44190_7593# VP sg13_lv_pmos ad=71.25f pd=0.755u as=71.25f ps=0.755u w=0.375u l=0.13u
X1050 a_45884_n1282# a_45282_n1282# VP VP sg13_lv_pmos ad=0.2375p pd=1.63u as=0.2375p ps=1.63u w=1.25u l=0.13u
X1051 a_3583_n5362# VCO_decoder_cells_0.001 VCO_decoder_cells_0.VCO4_selection_0.NAND_2in_dek_0.y gd sg13_lv_nmos ad=0.1005p pd=1.34u as=0.1005p ps=1.34u w=0.15u l=0.13u
X1052 a_10738_n1982# VCO_decoder_cells_0.VCO2_selection_0.NAND_3in_dek_0.y gd gd sg13_lv_nmos ad=0.1005p pd=1.34u as=0.1005p ps=1.34u w=0.15u l=0.13u
X1053 a_42501_n2486# vco_core_0_0.out vco_core_0_0.vco_delay_cell_0$1_3.in vco_core_0_0.vp sg13_lv_pmos ad=0.204p pd=1.88u as=0.114p ps=0.98u w=0.6u l=0.28u
X1054 vco_passgate_4.OI vco_core_2_0.vco_delay_cell_2$6_0.pgt a_37381_8614# vco_passgate_4.OI sg13_lv_pmos ad=0.408p pd=3.08u as=0.408p ps=3.08u w=1.2u l=5u
X1055 VP VCO_decoder_cells_0.001 VCO_decoder_cells_0.VCO4_selection_0.NAND_4in_dek_0.b VP sg13_lv_pmos ad=0.1005p pd=1.34u as=0.1005p ps=1.34u w=0.15u l=0.13u
X1056 gd a_45282_n1282# a_45884_n1282# gd sg13_lv_nmos ad=0.2375p pd=1.63u as=0.2375p ps=1.63u w=1.25u l=0.13u
X1057 gd VCO_decoder_cells_0.000000 a_4314_n4888# gd sg13_lv_nmos ad=0.1005p pd=1.34u as=0.1005p ps=1.34u w=0.15u l=0.13u
X1058 0_buf_0.out a_45943_n5690# VP VP sg13_lv_pmos ad=0.2375p pd=1.63u as=0.2375p ps=1.63u w=1.25u l=0.13u
X1059 a_11310_1054# VCO_decoder_cells_0.VCO3_selection_0.NAND_4in_dek_0.c a_11094_1054# gd sg13_lv_nmos ad=0.1005p pd=1.34u as=0.1005p ps=1.34u w=0.15u l=0.13u
X1060 VCO_decoder_cells_0.3bit_to_8_outs_0.NAND_3in_dek_2.y c0 a_4427_n3392# gd sg13_lv_nmos ad=0.1005p pd=1.34u as=0.1005p ps=1.34u w=0.15u l=0.13u
X1061 vco_core_3_0.vco_delay_cell_3_0.in NOR_2in$1_0.B vco_core_3_0.vco_delay_cell_3_7.out gd sg13_lv_nmos ad=0.102p pd=1.28u as=0.102p ps=1.28u w=0.3u l=0.15u
X1062 a_45394_7089# a_44792_7593# gd gd sg13_lv_nmos ad=0.11875p pd=1.005u as=0.11875p ps=1.005u w=0.625u l=0.13u
X1063 a_42228_3420# vco_core_1_0.vco_delay_cell_1$1_5.in vco_core_1_0.out vco_passgate_3.OI sg13_lv_pmos ad=0.204p pd=1.88u as=0.114p ps=0.98u w=0.6u l=0.7u
X1064 gd VCO_decoder_cells_0.VCO3_11_sel vco_core_2_0.nen11 gd sg13_lv_nmos ad=0.1005p pd=1.34u as=0.1005p ps=1.34u w=0.15u l=0.13u
X1065 out VCO_MUX_0.VCO2_sel VCO_MUX_0.VCO2_in gd sg13_lv_nmos ad=0.1005p pd=1.34u as=0.1005p ps=1.34u w=0.15u l=0.13u
X1066 VCO_MUX_0.VCO3_in a_46598_6964# gd gd sg13_lv_nmos ad=0.2375p pd=1.63u as=0.2375p ps=1.63u w=1.25u l=0.13u
X1067 a_39508_1356# vco_core_1_0.vco_delay_cell_1$1_7.in vco_core_1_0.vco_delay_cell_1$1_4.in vco_passgate_3.OI sg13_lv_pmos ad=0.204p pd=1.88u as=0.114p ps=0.98u w=0.6u l=0.7u
X1068 gd a_45282_n1282# a_45884_n1282# gd sg13_lv_nmos ad=0.2375p pd=1.63u as=0.2375p ps=1.63u w=1.25u l=0.13u
X1069 a_38352_1356# vco_core_1_0.vco_delay_cell_1$1_0.pgt vco_passgate_3.OI vco_passgate_3.OI sg13_lv_pmos ad=0.114p pd=0.98u as=0.204p ps=1.88u w=0.6u l=1.4u
X1070 VP a_44078_n653# a_44680_n1157# VP sg13_lv_pmos ad=0.11875p pd=1.005u as=0.11875p ps=1.005u w=0.625u l=0.13u
X1071 vco_core_0_0.vco_delay_cell_0$1_1.in vco_core_0_0.vco_delay_cell_0$1_2.in a_41209_n2018# gd sg13_lv_nmos ad=76f pd=0.78u as=0.136p ps=1.48u w=0.4u l=0.28u
X1072 0_buf_0.out a_45943_n5690# VP VP sg13_lv_pmos ad=0.2375p pd=1.63u as=0.2375p ps=1.63u w=1.25u l=0.13u
X1073 gd a_46598_6964# VCO_MUX_0.VCO3_in gd sg13_lv_nmos ad=0.2375p pd=1.63u as=0.2375p ps=1.63u w=1.25u l=0.13u
X1074 out VCO_MUX_0.inverter_dek_0.out VCO_MUX_0.VCO_in VP sg13_lv_pmos ad=0.17p pd=1.68u as=95f ps=0.88u w=0.5u l=0.13u
X1075 VCO_decoder_cells_0.001 VCO_decoder_cells_0.3bit_to_8_outs_0.NAND_3in_dek_2.y VP VP sg13_lv_pmos ad=0.1005p pd=1.34u as=0.1005p ps=1.34u w=0.15u l=0.13u
X1076 vco_core_4_0.vco_delay_cell_4_4.up vco_core_4_0.pgt vco_passgate_0.OI vco_passgate_0.OI sg13_lv_pmos ad=0.408p pd=3.08u as=0.408p ps=3.08u w=1.2u l=30u
X1077 a_4361_n6871# VCO_decoder_cells_0.VCO_selection_0.NAND_3in_dek_0.a VCO_MUX_0.VCO_sel gd sg13_lv_nmos ad=0.1005p pd=1.34u as=0.1005p ps=1.34u w=0.15u l=0.13u
X1078 vco_passgate_4.OI vco_core_2_0.vco_delay_cell_2$6_0.pgt a_38741_4818# vco_passgate_4.OI sg13_lv_pmos ad=0.408p pd=3.08u as=0.408p ps=3.08u w=1.2u l=5u
X1079 VCO_MUX_0.VCO_in VCO_MUX_0.inverter_dek_0.out out VP sg13_lv_pmos ad=95f pd=0.88u as=95f ps=0.88u w=0.5u l=0.13u
X1080 gd f5 a_5047_n7189# gd sg13_lv_nmos ad=0.1005p pd=1.34u as=0.1005p ps=1.34u w=0.15u l=0.13u
X1081 vco_core_2_0.vco_delay_cell_2$6_5.in vco_core_2_0.vco_delay_cell_2$6_4.out a_37381_7152# gd sg13_lv_nmos ad=0.272p pd=2.28u as=0.272p ps=2.28u w=0.8u l=2.5u
X1082 VP inverter_x1_2.IN vco_passgate_0.OI gd sg13_lv_nmos ad=0.11875p pd=1.005u as=0.2125p ps=1.93u w=0.625u l=0.13u
X1083 a_5000_n5362# VCO_decoder_cells_0.after_000011 a_4784_n5362# gd sg13_lv_nmos ad=0.1005p pd=1.34u as=0.1005p ps=1.34u w=0.15u l=0.13u
X1084 gd VCO_decoder_cells_0.VCO3_5_sel vco_core_2_0.nen5 gd sg13_lv_nmos ad=0.1005p pd=1.34u as=0.1005p ps=1.34u w=0.15u l=0.13u
X1085 a_38352_3420# vco_core_1_0.vco_delay_cell_1$1_0.pgt vco_passgate_3.OI vco_passgate_3.OI sg13_lv_pmos ad=0.114p pd=0.98u as=0.204p ps=1.88u w=0.6u l=1.4u
X1086 VCO_decoder_cells_0.VCO3_11_sel VCO_decoder_cells_0.VCO3_selection_0.NAND_4in_dek_0.b VP VP sg13_lv_pmos ad=0.1005p pd=1.34u as=0.1005p ps=1.34u w=0.15u l=0.13u
X1087 vco_core_0_0.vp vco_core_0_0.vco_delay_cell_0$1_0.pgt vco_core_0_0.vco_delay_cell_0$1_0.pgt vco_core_0_0.vp sg13_lv_pmos ad=0.204p pd=1.88u as=0.114p ps=0.98u w=0.6u l=0.56u
X1088 vco_passgate_4.OI vco_core_2_0.vco_delay_cell_2$6_0.pgt a_34661_4818# vco_passgate_4.OI sg13_lv_pmos ad=0.408p pd=3.08u as=0.408p ps=3.08u w=1.2u l=5u
X1089 vco_passgate_3.OI PFD_passgate_4.in_p VP VP sg13_lv_pmos ad=0.11875p pd=1.005u as=0.11875p ps=1.005u w=0.625u l=0.13u
X1090 gd 0_buf_1.in a_43326_n10831# gd sg13_lv_nmos ad=0.136p pd=1.48u as=76f ps=0.78u w=0.4u l=0.13u
X1091 vco_core_4_0.vco_delay_cell_4_2.up vco_core_4_0.pgt vco_passgate_0.OI vco_passgate_0.OI sg13_lv_pmos ad=0.408p pd=3.08u as=0.408p ps=3.08u w=1.2u l=30u
X1092 a_11428_n5894# VCO_decoder_cells_0.VCO2_selection_0.NAND_4in_dek_0.b a_11212_n5894# gd sg13_lv_nmos ad=0.1005p pd=1.34u as=0.1005p ps=1.34u w=0.15u l=0.13u
X1093 vco_core_2_0.vco_delay_cell_2$6_2.in vco_core_2_0.vco_delay_cell_2$6_3.in a_37381_4818# vco_passgate_4.OI sg13_lv_pmos ad=0.408p pd=3.08u as=0.408p ps=3.08u w=1.2u l=2.5u
X1094 gd VCO_decoder_cells_0.VCO3_11_sel NOR_2in$1_1.Out gd sg13_lv_nmos ad=55.5f pd=0.74u as=0.1005p ps=1.34u w=0.15u l=0.13u
X1095 a_42501_n2018# vco_core_0_0.out vco_core_0_0.vco_delay_cell_0$1_3.in gd sg13_lv_nmos ad=0.136p pd=1.48u as=76f ps=0.78u w=0.4u l=0.28u
X1096 a_41821_n2486# vco_core_0_0.vco_delay_cell_0$1_0.pgt vco_core_0_0.vp vco_core_0_0.vp sg13_lv_pmos ad=0.114p pd=0.98u as=0.204p ps=1.88u w=0.6u l=0.56u
X1097 VCO_decoder_cells_0.3bit_to_8_outs_0.c0_n c0 gd gd sg13_lv_nmos ad=0.1005p pd=1.34u as=0.1005p ps=1.34u w=0.15u l=0.13u
X1098 a_43928_n10831# a_43326_n10831# VP VP sg13_lv_pmos ad=0.114p pd=0.98u as=0.114p ps=0.98u w=0.6u l=0.13u
X1099 vco_core_1_0.vco_delay_cell_1$1_7.in vco_core_1_0.vco_delay_cell_1$1_1.out a_38350_1826# gd sg13_lv_nmos ad=76f pd=0.78u as=0.136p ps=1.48u w=0.4u l=0.7u
X1100 vco_passgate_4.OI vco_core_2_0.vco_delay_cell_2$6_0.pgt a_42005_8614# vco_passgate_4.OI sg13_lv_pmos ad=0.408p pd=3.08u as=0.408p ps=3.08u w=1.2u l=5u
X1101 gd PFD_passgate_2.in_p vco_core_0_0.in gd sg13_lv_nmos ad=0.102p pd=1.28u as=0.102p ps=1.28u w=0.3u l=0.13u
X1102 VCO_decoder_cells_0.3bit_to_8_outs_0.inverter_dek_10.in VCO_decoder_cells_0.3bit_to_8_outs_0.c2_n VP VP sg13_lv_pmos ad=0.1005p pd=1.34u as=0.1005p ps=1.34u w=0.15u l=0.13u
X1103 VCO_decoder_cells_0.VCO2_selection_0.NAND_3in_dek_0.y VCO_decoder_cells_0.100 a_9993_n3938# gd sg13_lv_nmos ad=0.1005p pd=1.34u as=0.1005p ps=1.34u w=0.15u l=0.13u
X1104 vco_passgate_1.en NOR_2in$1_0.Out VP VP sg13_lv_pmos ad=0.1005p pd=1.34u as=0.1005p ps=1.34u w=0.15u l=0.13u
X1105 a_44964_2717# a_44362_3221# VP VP sg13_lv_pmos ad=0.2125p pd=1.93u as=0.11875p ps=1.005u w=0.625u l=0.13u
X1106 VCO_decoder_cells_0.VCO3_selection_0.inverter_dek_1.in VCO_decoder_cells_0.VCO3_selection_0.NAND_3in_dek_4.a VP VP sg13_lv_pmos ad=0.1005p pd=1.34u as=0.1005p ps=1.34u w=0.15u l=0.13u
X1107 VCO_decoder_cells_0.VCO2_selection_0.NAND_3in_dek_1.a f5 VP VP sg13_lv_pmos ad=0.1005p pd=1.34u as=0.1005p ps=1.34u w=0.15u l=0.13u
X1108 a_45132_n11460# a_44530_n11335# gd gd sg13_lv_nmos ad=0.425p pd=3.18u as=0.2375p ps=1.63u w=1.25u l=0.13u
X1109 NOR_2in$1_1.Out VCO_decoder_cells_0.VCO3_5_sel a_29701_7737# VP sg13_lv_pmos ad=0.1005p pd=1.34u as=55.5f ps=0.74u w=0.15u l=0.13u
X1110 gd PFD_passgate_4.B a_41750_1826# gd sg13_lv_nmos ad=0.136p pd=1.48u as=76f ps=0.78u w=0.4u l=1.4u
X1111 VCO_MUX_0.VCO_in a_45884_n1282# gd gd sg13_lv_nmos ad=0.2375p pd=1.63u as=0.2375p ps=1.63u w=1.25u l=0.13u
X1112 VP a_46168_2592# VCO_MUX_0.VCO2_in VP sg13_lv_pmos ad=0.2375p pd=1.63u as=0.2375p ps=1.63u w=1.25u l=0.13u
X1113 VCO_decoder_cells_0.VCO3_selection_0.inverter_dek_0.out VCO_decoder_cells_0.VCO3_selection_0.NAND_2in_dek_1.y VP VP sg13_lv_pmos ad=0.1005p pd=1.34u as=0.1005p ps=1.34u w=0.15u l=0.13u
X1114 gd PFD_passgate_1.B a_27182_n5509# gd sg13_lv_nmos ad=0.272p pd=2.28u as=0.272p ps=2.28u w=0.8u l=17u
X1115 vco_passgate_1.OI vco_core_3_0.vco_delay_cell_3_0.pgt a_34662_n4047# vco_passgate_1.OI sg13_lv_pmos ad=0.408p pd=3.08u as=0.408p ps=3.08u w=1.2u l=17u
X1116 VP a_45996_6964# a_46598_6964# VP sg13_lv_pmos ad=0.2375p pd=1.63u as=0.2375p ps=1.63u w=1.25u l=0.13u
X1117 a_10463_n3464# VCO_decoder_cells_0.after_000011_n gd gd sg13_lv_nmos ad=0.1005p pd=1.34u as=0.1005p ps=1.34u w=0.15u l=0.13u
X1118 VP a_45132_n11460# a_45734_n11460# VP sg13_lv_pmos ad=0.2375p pd=1.63u as=0.2375p ps=1.63u w=1.25u l=0.13u
X1119 VP VCO_decoder_cells_0.VCO2_selection_0.NAND_2in_dek_0.y VCO_decoder_cells_0.VCO2_5_sel VP sg13_lv_pmos ad=0.1005p pd=1.34u as=0.1005p ps=1.34u w=0.15u l=0.13u
X1120 VCO_MUX_0.VCO_in a_45884_n1282# gd gd sg13_lv_nmos ad=0.2375p pd=1.63u as=0.2375p ps=1.63u w=1.25u l=0.13u
X1121 VP vco_passgate_1.en_ vco_passgate_1.OI VP sg13_lv_pmos ad=0.11875p pd=1.005u as=0.11875p ps=1.005u w=0.625u l=0.13u
X1122 a_42467_n486# vco_core_0_0.vco_delay_cell_0$1_0.in vco_core_0_0.out vco_core_0_0.vp sg13_lv_pmos ad=0.204p pd=1.88u as=0.114p ps=0.98u w=0.6u l=0.28u
X1123 gd VCO_MUX_0.VCO2_sel VCO_MUX_0.passgate_scaled_1.en_ gd sg13_lv_nmos ad=0.1005p pd=1.34u as=0.1005p ps=1.34u w=0.15u l=0.13u
X1124 a_45132_n11460# a_44530_n11335# gd gd sg13_lv_nmos ad=0.2375p pd=1.63u as=0.2375p ps=1.63u w=1.25u l=0.13u
X1125 gd PFD_passgate_0.B vco_core_4_0.pgt gd sg13_lv_nmos ad=0.272p pd=2.28u as=0.272p ps=2.28u w=0.8u l=30u
X1126 gd a_45734_n11460# 0_buf_1.out gd sg13_lv_nmos ad=0.2375p pd=1.63u as=0.425p ps=3.18u w=1.25u l=0.13u
X1127 gd f2 VCO_decoder_cells_0.row_section_decoding_0.NAND_3in_dek_0.a gd sg13_lv_nmos ad=0.1005p pd=1.34u as=0.1005p ps=1.34u w=0.15u l=0.13u
X1128 gd PFD_passgate_4.B a_38350_1826# gd sg13_lv_nmos ad=0.136p pd=1.48u as=76f ps=0.78u w=0.4u l=1.4u
X1129 a_11094_1054# VCO_decoder_cells_0.VCO3_selection_0.NAND_4in_dek_0.d gd gd sg13_lv_nmos ad=0.1005p pd=1.34u as=0.1005p ps=1.34u w=0.15u l=0.13u
X1130 VP a_46168_2592# VCO_MUX_0.VCO2_in VP sg13_lv_pmos ad=0.2375p pd=1.63u as=0.2375p ps=1.63u w=1.25u l=0.13u
X1131 gd PFD_passgate_4.B a_38350_2990# gd sg13_lv_nmos ad=0.136p pd=1.48u as=76f ps=0.78u w=0.4u l=1.4u
X1132 VP VCO_decoder_cells_0.3bit_to_8_outs_0.c1_n VCO_decoder_cells_0.3bit_to_8_outs_0.NAND_3in_dek_2.y VP sg13_lv_pmos ad=0.1005p pd=1.34u as=0.1005p ps=1.34u w=0.15u l=0.13u
X1133 VP a_45132_n11460# a_45734_n11460# VP sg13_lv_pmos ad=0.2375p pd=1.63u as=0.2375p ps=1.63u w=1.25u l=0.13u
X1134 vco_core_3_0.vco_delay_cell_3_5.out vco_core_3_0.vco_delay_cell_3_5.in a_19702_n6301# gd sg13_lv_nmos ad=0.272p pd=2.28u as=0.272p ps=2.28u w=0.8u l=8.5u
X1135 0_buf_0.out a_45943_n5690# gd gd sg13_lv_nmos ad=0.2375p pd=1.63u as=0.2375p ps=1.63u w=1.25u l=0.13u
X1136 vco_core_3_0.vco_delay_cell_3_1.out vco_core_3_0.vco_delay_cell_3_1.in a_38402_n7843# vco_passgate_1.OI sg13_lv_pmos ad=0.408p pd=3.08u as=0.408p ps=3.08u w=1.2u l=8.5u
X1137 vco_passgate_3.OI vco_core_1_0.vco_delay_cell_1$1_0.pgt vco_core_1_0.vco_delay_cell_1$1_0.pgt vco_passgate_3.OI sg13_lv_pmos ad=0.204p pd=1.88u as=0.114p ps=0.98u w=0.6u l=1.4u
X1138 vco_core_1_0.vco_delay_cell_1$1_4.in vco_core_1_0.vco_delay_cell_1$1_7.in a_39508_1356# vco_passgate_3.OI sg13_lv_pmos ad=0.114p pd=0.98u as=0.204p ps=1.88u w=0.6u l=0.7u
X1139 VP inverter_x1_2.OUT vco_passgate_0.OI VP sg13_lv_pmos ad=0.11875p pd=1.005u as=0.11875p ps=1.005u w=0.625u l=0.13u
X1140 a_38350_1826# PFD_passgate_4.B gd gd sg13_lv_nmos ad=76f pd=0.78u as=0.136p ps=1.48u w=0.4u l=1.4u
X1141 VP PFD_passgate_3.in_p vco_passgate_4.OI VP sg13_lv_pmos ad=0.11875p pd=1.005u as=0.2125p ps=1.93u w=0.625u l=0.13u
X1142 gd PFD_passgate_3.B a_37381_6360# gd sg13_lv_nmos ad=0.272p pd=2.28u as=0.272p ps=2.28u w=0.8u l=5u
X1143 VCO_MUX_0.VCO2_in a_46168_2592# gd gd sg13_lv_nmos ad=0.2375p pd=1.63u as=0.2375p ps=1.63u w=1.25u l=0.13u
X1144 NOR_2in$1_0.Out NOR_2in$1_0.B gd gd sg13_lv_nmos ad=0.1005p pd=1.34u as=55.5f ps=0.74u w=0.15u l=0.13u
X1145 a_38350_2990# PFD_passgate_4.B gd gd sg13_lv_nmos ad=76f pd=0.78u as=0.136p ps=1.48u w=0.4u l=1.4u
X1146 vco_core_1_0.vco_delay_cell_1$1_3.out vco_core_1_0.vco_delay_cell_1$1_3.in a_41752_1356# vco_passgate_3.OI sg13_lv_pmos ad=0.114p pd=0.98u as=0.204p ps=1.88u w=0.6u l=0.7u
X1147 VP a_45943_n5690# 0_buf_0.out VP sg13_lv_pmos ad=0.2375p pd=1.63u as=0.425p ps=3.18u w=1.25u l=0.13u
C0 VCO_MUX_0.VCO3_in inverter_x1_2.IN 0.01911f
C1 a_45341_n5690# a_45943_n5690# 0.92278f
C2 0_buf_1.in VP 0.35914f
C3 vco_core_4_0.vco_delay_cell_4_10.out vco_core_4_0.vco_delay_cell_4_8.dn 0.0652f
C4 VCO_decoder_cells_0.000000 a_4314_n4888# 0.02888f
C5 PFD_passgate_3.B VP 0.27438f
C6 VCO_decoder_cells_0.VCO3_selection_0.NAND_3in_dek_3.y VCO_decoder_cells_0.VCO3_selection_0.NAND_4in_dek_1.d 0.10038f
C7 a_41855_n486# vco_core_0_0.vco_delay_cell_0$1_1.in 0.07831f
C8 vco_passgate_1.OI a_27182_n4047# 0.40656f
C9 VCO_decoder_cells_0.3bit_to_8_outs_0.inverter_dek_1.in c1 0.34305f
C10 a_19702_n7843# vco_core_3_0.vco_delay_cell_3_0.pgt 0.27075f
C11 VCO_MUX_0.VCO_sel VCO_MUX_0.VCO_in 0.80006f
C12 a_40101_8614# vco_passgate_4.OI 0.24074f
C13 vco_core_3_0.vco_delay_cell_3_1.out vco_core_3_0.vco_delay_cell_3_0.in 0.25683f
C14 VCO_decoder_cells_0.000000_n VCO_decoder_cells_0.VCO2_selection_0.NAND_4in_dek_1.c 0.29452f
C15 VCO_MUX_0.passgate_scaled_2.en_ 0_buf_0.out 0.24262f
C16 a_38350_2990# vco_core_1_0.vco_delay_cell_1$1_2.in 0.0826f
C17 out VP 0.79432f
C18 vco_core_0_0.vco_delay_cell_0$1_3.in a_41821_n2486# 0.08084f
C19 NOR_2in$1_0.Out vco_passgate_1.en 0.09254f
C20 PFD_passgate_0.B VP 0.35444f
C21 vco_core_3_0.nen11 vco_core_3_0.vco_delay_cell_3_0.in 0.09274f
C22 a_42226_2990# VCO_decoder_cells_0.VCO2_5_sel 0.03417f
C23 VCO_decoder_cells_0.VCO2_selection_0.NAND_3in_dek_1.a VCO_decoder_cells_0.VCO2_selection_0.NAND_3in_dek_1.b 0.7624f
C24 a_38352_3420# vco_core_1_0.out 0.06802f
C25 VCO_decoder_cells_0.VCO5_selection_0.NAND_2in_dek_0.b VCO_decoder_cells_0.100 0.01301f
C26 m2_4850_n3731# VCO_decoder_cells_0.001 0.0959f
C27 vco_passgate_1.en PFD_passgate_1.B 0.03027f
C28 VCO_decoder_cells_0.VCO5_selection_0.NAND_2in_dek_0.b VCO_decoder_cells_0.000000 0.23373f
C29 VCO_decoder_cells_0.VCO2_selection_0.NAND_4in_dek_0.d VCO_decoder_cells_0.VCO2_selection_0.NAND_4in_dek_0.a 0.13034f
C30 VCO_decoder_cells_0.VCO3_11_sel VP 1.31412f
C31 vco_core_4_0.vco_delay_cell_4_9.out vco_core_4_0.vco_delay_cell_4_10.out 0.11087f
C32 VCO_decoder_cells_0.111 VCO_decoder_cells_0.VCO2_selection_0.inverter_dek_0.out 0.01173f
C33 a_34662_n7843# vco_core_3_0.vco_delay_cell_3_0.pgt 0.25993f
C34 m2_4965_n6706# m2_4965_n6788# 0.20492f
C35 NOR_2in$1_0.A VP 0.85949f
C36 VCO_decoder_cells_0.VCO3_selection_0.NAND_4in_dek_0.b VCO_decoder_cells_0.VCO3_selection_0.NAND_4in_dek_1.c 0.1105f
C37 c0 VCO_decoder_cells_0.3bit_to_8_outs_0.inverter_dek_8.in 0.25886f
C38 m2_9698_n7271# VCO_decoder_cells_0.VCO5_selection_0.NAND_2in_dek_0.a 0.15127f
C39 VCO_decoder_cells_0.after_001111 a_10253_n1982# 0.02888f
C40 VCO_decoder_cells_0.after_001111_n f2 0.05386f
C41 VP VCO_decoder_cells_0.3bit_to_8_outs_0.inverter_dek_8.in 0.38992f
C42 VCO_decoder_cells_0.VCO3_selection_0.NAND_4in_dek_1.a VCO_decoder_cells_0.VCO3_5_sel 0.46568f
C43 VP vco_core_1_0.vco_delay_cell_1$1_6.in 0.04588f
C44 VCO_decoder_cells_0.after_001111_n VCO_decoder_cells_0.100 0.11241f
C45 VCO_decoder_cells_0.010 f0 0.05123f
C46 vco_core_4_0.vco_delay_cell_4_1.dn vco_passgate_0.OI 0.05308f
C47 VCO_decoder_cells_0.after_001111_n VCO_decoder_cells_0.000000 1.96324f
C48 a_11327_n902# VCO_decoder_cells_0.VCO3_selection_0.inverter_dek_1.in 0.04015f
C49 VCO_decoder_cells_0.VCO3_selection_0.NAND_4in_dek_0.c VP 0.38023f
C50 a_9777_n3938# a_9993_n3938# 0.01537f
C51 vco_passgate_3.OI PFD_passgate_4.in_p 0.22316f
C52 VCO_decoder_cells_0.VCO3_selection_0.NAND_4in_dek_1.d a_10630_n428# 0.04377f
C53 vco_passgate_4.OI vco_core_2_0.vco_delay_cell_2$6_1.in 1.18411f
C54 VCO_MUX_0.VCO2_sel 0_buf_1.out 0.12361f
C55 VCO_MUX_0.VCO3_sel 0_buf_0.out 0.02227f
C56 vco_passgate_3.OI vco_core_1_0.vco_delay_cell_1$1_3.in 0.62677f
C57 m2_4640_957# f3 0.05661f
C58 VCO_decoder_cells_0.VCO3_5_sel VCO_decoder_cells_0.VCO3_selection_0.NAND_4in_dek_1.b 0.49857f
C59 a_45566_2592# a_46168_2592# 0.92278f
C60 VCO_decoder_cells_0.after_001111_n VCO_decoder_cells_0.after_001111 0.59321f
C61 vco_core_1_0.vco_delay_cell_1$1_0.in VCO_decoder_cells_0.VCO2_5_sel 0.08194f
C62 vco_passgate_1.en_ PFD_passgate_1.B 0.19593f
C63 a_23442_n5509# vco_core_3_0.vco_delay_cell_3_0.pgt 0.0144f
C64 c0 VCO_decoder_cells_0.after_000011_n 0.02738f
C65 vco_in PFD_passgate_4.in_p 0.04193f
C66 a_45996_6964# VP 1.42163f
C67 vco_core_0_0.vco_delay_cell_0$1_0.pgt vco_core_0_0.vco_delay_cell_0$1_0.in 0.07413f
C68 vco_core_2_0.vco_delay_cell_2$6_0.pgt a_37381_4818# 0.12687f
C69 VCO_MUX_0.VCO_in 0_buf_1.out 0.01636f
C70 VP VCO_decoder_cells_0.after_000011_n 0.8546f
C71 VCO_decoder_cells_0.3bit_to_8_outs_0.c0_n VCO_decoder_cells_0.3bit_to_8_outs_0.NAND_3in_dek_0.y 0.26046f
C72 VCO_decoder_cells_0.VCO3_5_sel vco_core_2_0.vco_delay_cell_2$6_5.out 0.06772f
C73 vco_passgate_1.OI VP 1.54011f
C74 VCO_decoder_cells_0.111 f4 0.06119f
C75 vco_passgate_3.OI VCO_MUX_0.VCO3_sel 4.03599f
C76 VCO_decoder_cells_0.f5_n NOR_2in$1_0.B 0.09794f
C77 a_10954_n1982# VCO_decoder_cells_0.VCO2_selection_0.NAND_3in_dek_1.y 0.04007f
C78 VCO_decoder_cells_0.3bit_to_8_outs_0.c1_n VCO_decoder_cells_0.3bit_to_8_outs_0.inverter_dek_10.in 0.05988f
C79 PFD_passgate_2.in_p vco_in 0.06614f
C80 VCO_decoder_cells_0.after_001111_n VCO_decoder_cells_0.after_000111_n 10.6408f
C81 VCO_MUX_0.VCO3_in VP 2.4846f
C82 VCO_decoder_cells_0.row_section_decoding_0.NAND_2in_dek_0.b VCO_decoder_cells_0.after_000011_n 0.13035f
C83 VCO_decoder_cells_0.f5_n VCO_decoder_cells_0.101 0.22696f
C84 VCO_decoder_cells_0.VCO2_11_sel VCO_decoder_cells_0.VCO2_selection_0.NAND_3in_dek_0.y 0.18322f
C85 vco_core_2_0.out vco_core_2_0.vco_delay_cell_2$6_8.in 0.42628f
C86 a_43476_n653# a_44078_n653# 0.37543f
C87 VCO_decoder_cells_0.111 m2_4279_n6788# 0.01819f
C88 a_4211_n3074# VCO_decoder_cells_0.3bit_to_8_outs_0.c2_n 0.01054f
C89 vco_core_4_0.vco_delay_cell_4_6.dn vco_core_4_0.vco_delay_cell_4_6.up 0.03587f
C90 vco_passgate_3.OI a_36108_1356# 0.16236f
C91 a_4211_n3392# a_4427_n3392# 0.01537f
C92 VCO_MUX_0.VCO_sel f1 0.05386f
C93 vco_in VCO_MUX_0.VCO3_sel 0.13963f
C94 VCO_decoder_cells_0.101 VCO_decoder_cells_0.VCO_selection_0.NAND_3in_dek_0.c 0.20395f
C95 f4 VCO_decoder_cells_0.after_000111 0.04026f
C96 vco_core_1_0.vco_delay_cell_1$1_5.in VCO_decoder_cells_0.VCO2_11_sel 0.11799f
C97 PFD_passgate_4.B vco_core_1_0.vco_delay_cell_1$1_6.out 0.01889f
C98 NOR_2in$1_0.A f5 0.09195f
C99 VCO_decoder_cells_0.VCO4_selection_0.NAND_4in_dek_0.b VCO_decoder_cells_0.001 0.34576f
C100 m2_5122_n2745# VCO_decoder_cells_0.3bit_to_8_outs_0.inverter_dek_10.in 0.09561f
C101 VCO_decoder_cells_0.after_001111 a_10630_3010# 0.02888f
C102 NOR_2in$1_0.A vco_core_3_0.vco_delay_cell_3_0.pgt 0.55534f
C103 VCO_decoder_cells_0.VCO3_selection_0.NAND_3in_dek_4.b VCO_decoder_cells_0.VCO3_selection_0.NAND_3in_dek_4.a 0.78655f
C104 VCO_decoder_cells_0.110 VCO_decoder_cells_0.after_001111_n 1.73369f
C105 vco_passgate_3.OI PFD_passgate_4.B 0.73872f
C106 VCO_decoder_cells_0.VCO3_selection_0.NAND_4in_dek_0.b VCO_decoder_cells_0.010 0.23649f
C107 NOR_2in$1_0.A f3 0.05357f
C108 vco_core_2_0.nen11 vco_core_2_0.vco_delay_cell_2$6_0.in 0.19513f
C109 VCO_decoder_cells_0.after_000011 VCO_decoder_cells_0.000000_n 0.24769f
C110 vco_core_4_0.vco_delay_cell_4_0.in vco_core_4_0.pgt 0.95872f
C111 a_3510_2110# f4 0.0306f
C112 vco_core_1_0.vco_delay_cell_1$1_0.in vco_core_1_0.vco_delay_cell_1$1_6.in 0.17071f
C113 vco_core_4_0.vco_delay_cell_4_4.dn vco_core_4_0.vco_delay_cell_4_4.in 0.0652f
C114 f1 VCO_decoder_cells_0.000 0.04865f
C115 vco_core_3_0.vco_delay_cell_3_0.pgt a_23442_n6301# 0.02106f
C116 VP VCO_decoder_cells_0.VCO2_selection_0.NAND_4in_dek_1.c 0.36323f
C117 vco_in PFD_passgate_4.B 0.33335f
C118 VCO_MUX_0.VCO3_sel inverter_x1_12.IN 0.02007f
C119 a_39506_1826# vco_core_1_0.vco_delay_cell_1$1_4.in 0.08216f
C120 vco_core_0_0.vp vco_passgate_1.OI 0.24645f
C121 vco_core_2_0.vco_delay_cell_2$6_5.in vco_passgate_4.OI 1.16063f
C122 VCO_decoder_cells_0.000000_n VCO_decoder_cells_0.row_section_decoding_0.NAND_3in_dek_0.a 0.32487f
C123 VCO_decoder_cells_0.VCO5_selection_0.NAND_2in_dek_0.a VCO_decoder_cells_0.VCO5_selection_0.NAND_2in_dek_0.b 0.68305f
C124 VCO_MUX_0.VCO_sel m2_50108_n531# 0.09498f
C125 vco_core_4_0.vco_delay_cell_4_7.out vco_core_4_0.pgt 0.95869f
C126 f5 VCO_decoder_cells_0.after_000011_n 0.12619f
C127 vco_passgate_0.OI vco_core_4_0.vco_delay_cell_4_7.up 0.61027f
C128 VP a_39508_3420# 0.01129f
C129 VCO_MUX_0.passgate_scaled_1.en_ VCO_MUX_0.passgate_scaled_3.en_ 0.01013f
C130 m2_4279_n6788# VCO_decoder_cells_0.VCO_selection_0.NAND_3in_dek_0.b 0.01316f
C131 f3 VCO_decoder_cells_0.after_000011_n 0.06997f
C132 vco_passgate_1.OI vco_core_3_0.vco_delay_cell_3_0.pgt 91.932f
C133 VCO_decoder_cells_0.after_000011 VCO_decoder_cells_0.001 0.16548f
C134 vco_passgate_4.OI a_36021_4818# 0.24291f
C135 VCO_decoder_cells_0.row_section_decoding_0.NAND_3in_dek_0.b f4 0.08532f
C136 m2_11231_1693# VCO_decoder_cells_0.100 0.01109f
C137 a_4211_n1748# a_4427_n1748# 0.01537f
C138 m2_11231_1693# VCO_decoder_cells_0.000000 0.0622f
C139 vco_core_4_0.vco_delay_cell_4_5.up vco_passgate_0.OI 0.59265f
C140 vco_core_3_0.vco_delay_cell_3_0.pgt vco_core_3_0.vco_delay_cell_3_4.in 0.54549f
C141 a_5000_n5362# VCO_decoder_cells_0.after_001111_n 0.01052f
C142 VCO_decoder_cells_0.111 VCO_decoder_cells_0.after_000111 2.13548f
C143 vco_core_2_0.vco_delay_cell_2$6_3.in a_37381_4818# 0.06478f
C144 VCO_decoder_cells_0.VCO3_selection_0.NAND_3in_dek_3.y VCO_decoder_cells_0.001 0.06545f
C145 VP VCO_decoder_cells_0.VCO4_selection_0.NAND_4in_dek_0.b 0.42634f
C146 vco_core_1_0.vco_delay_cell_1$1_5.in a_42228_3420# 0.1136f
C147 a_4427_n1430# VCO_decoder_cells_0.3bit_to_8_outs_0.NAND_3in_dek_0.y 0.01202f
C148 a_38352_1356# vco_core_1_0.vco_delay_cell_1$1_0.pgt 0.19792f
C149 vco_core_2_0.vco_delay_cell_2$6_8.in vco_core_2_0.vco_delay_cell_2$6_0.pgt 0.09505f
C150 vco_core_2_0.nen11 vco_core_2_0.vco_delay_cell_2$6_5.out 0.02183f
C151 vco_core_3_0.vco_delay_cell_3_1.in a_38402_n7843# 0.06489f
C152 PFD_passgate_0.B vco_core_4_0.vco_delay_cell_4_1.in 0.64278f
C153 VCO_MUX_0.VCO2_sel VCO_decoder_cells_0.VCO2_11_sel 0.0701f
C154 f0 NOR_2in$1_0.B 0.05567f
C155 f0 VCO_decoder_cells_0.101 0.05184f
C156 PFD_passgate_4.B a_37194_1826# 0.19114f
C157 vco_core_0_0.vco_delay_cell_0$1_0.pgt PFD_passgate_2.in_p 0.0109f
C158 inverter_x1_2.IN VCO_decoder_cells_0.VCO2_selection_0.NAND_4in_dek_0.a 0.02185f
C159 VCO_decoder_cells_0.VCO3_11_sel VCO_decoder_cells_0.VCO2_5_sel 0.07536f
C160 VCO_MUX_0.VCO3_sel a_45566_2592# 0.02031f
C161 a_42467_n914# vco_core_0_0.vco_delay_cell_0$1_0.in 0.06929f
C162 vco_core_2_0.vco_delay_cell_2$6_6.in a_38741_7152# 0.06287f
C163 vco_passgate_1.OI a_19702_n7843# 0.40591f
C164 a_40101_8614# vco_core_2_0.vco_delay_cell_2$6_9.out 0.0131f
C165 VCO_decoder_cells_0.010 VCO_decoder_cells_0.3bit_to_8_outs_0.inverter_dek_10.in 0.36782f
C166 VCO_decoder_cells_0.3bit_to_8_outs_0.c0_n VCO_decoder_cells_0.3bit_to_8_outs_0.inverter_dek_8.in 0.32342f
C167 NOR_2in$1_0.A VCO_decoder_cells_0.VCO2_5_sel 0.05089f
C168 vco_core_3_0.vco_delay_cell_3_7.in vco_core_3_0.vco_delay_cell_3_7.out 0.16437f
C169 vco_passgate_0.OI vco_core_4_0.pgt 0.13783p
C170 0_buf_1.in PFD_passgate_0.B 0.79258f
C171 VCO_decoder_cells_0.after_000011 c0 0.01968f
C172 NOR_2in$1_0.B VCO_decoder_cells_0.VCO4_selection_0.NAND_3in_dek_1.y 0.39867f
C173 VCO_decoder_cells_0.010 VCO_decoder_cells_0.VCO5_selection_0.NAND_2in_dek_0.b 0.28546f
C174 VCO_decoder_cells_0.VCO2_5_sel vco_core_1_0.vco_delay_cell_1$1_6.in 0.05713f
C175 vco_core_0_0.in vco_core_0_0.vco_delay_cell_0$1_3.in 0.08487f
C176 vco_core_1_0.vco_delay_cell_1$1_0.pgt a_38352_3420# 0.18326f
C177 VCO_decoder_cells_0.after_000011 VP 1.25051f
C178 vco_passgate_1.OI a_34662_n7843# 0.40785f
C179 VCO_decoder_cells_0.VCO3_11_sel PFD_passgate_3.B 1.08883f
C180 a_43535_n5061# vco_core_3_0.out 0.30916f
C181 VP VCO_decoder_cells_0.VCO2_selection_0.NAND_3in_dek_0.y 0.47286f
C182 a_38741_8614# vco_core_2_0.out 0.06879f
C183 vco_core_1_0.vco_delay_cell_1$1_5.in VP 0.05049f
C184 VCO_decoder_cells_0.row_section_decoding_0.NAND_2in_dek_0.b VCO_decoder_cells_0.after_000011 0.67984f
C185 VCO_decoder_cells_0.after_001111_n VCO_decoder_cells_0.010 0.1082f
C186 vco_core_1_0.vco_delay_cell_1$1_1.out VCO_decoder_cells_0.VCO2_11_sel 0.02221f
C187 VP VCO_decoder_cells_0.row_section_decoding_0.NAND_3in_dek_0.a 0.39283f
C188 VCO_decoder_cells_0.after_000111 VCO_decoder_cells_0.VCO3_selection_0.NAND_4in_dek_1.b 0.05521f
C189 vco_core_0_0.vp vco_core_0_0.vco_delay_cell_0$1_3.in 0.4994f
C190 vco_core_1_0.vco_delay_cell_1$1_0.out a_36108_1356# 0.09177f
C191 VCO_decoder_cells_0.VCO3_selection_0.NAND_3in_dek_3.y VP 0.35073f
C192 VCO_decoder_cells_0.f5_n a_9777_n3938# 0.01076f
C193 VCO_decoder_cells_0.VCO5_selection_0.NAND_2in_dek_0.a a_9777_n7436# 0.04346f
C194 VCO_MUX_0.VCO2_sel inverter_x1_2.IN 0.23849f
C195 a_4211_n3074# a_4427_n3074# 0.01537f
C196 NOR_2in$1_0.B vco_core_3_0.vco_delay_cell_3_5.in 0.09885f
C197 VCO_decoder_cells_0.VCO_selection_0.NAND_3in_dek_0.a VCO_decoder_cells_0.VCO_selection_0.NAND_3in_dek_0.c 0.18858f
C198 VCO_decoder_cells_0.VCO2_selection_0.NAND_3in_dek_1.b VCO_decoder_cells_0.VCO2_selection_0.NAND_3in_dek_1.y 0.40481f
C199 vco_core_4_0.vco_delay_cell_4_2.in vco_passgate_0.OI 4.50637f
C200 a_23442_n5509# vco_passgate_1.OI 0.03719f
C201 PFD_passgate_4.B vco_core_1_0.vco_delay_cell_1$1_0.out 0.12564f
C202 VCO_MUX_0.VCO_sel vco_passgate_3.OI 0.03062f
C203 vco_core_0_0.vco_delay_cell_0$1_1.in vco_core_0_0.vco_delay_cell_0$1_2.in 0.28038f
C204 vco_core_3_0.vco_delay_cell_3_2.in a_34662_n6301# 0.05096f
C205 a_39218_n5509# a_39218_n4047# 0.01952f
C206 a_11310_1054# a_11526_1054# 0.01537f
C207 VCO_decoder_cells_0.VCO3_11_sel VCO_decoder_cells_0.VCO3_selection_0.NAND_4in_dek_0.c 0.44436f
C208 VCO_MUX_0.inverter_dek_0.out VP 0.46307f
C209 vco_passgate_3.OI vco_core_1_0.nen5 0.43004f
C210 inverter_x1_2.OUT inverter_x1_2.IN 0.12221f
C211 vco_core_3_0.vco_delay_cell_3_8.in vco_core_3_0.vco_delay_cell_3_5.in 0.35098f
C212 a_42226_2990# vco_core_1_0.vco_delay_cell_1$1_5.in 0.16205f
C213 VCO_decoder_cells_0.VCO3_selection_0.NAND_4in_dek_1.a VCO_decoder_cells_0.VCO3_selection_0.NAND_4in_dek_1.b 0.58311f
C214 VCO_decoder_cells_0.3bit_to_8_outs_0.c2_n VCO_decoder_cells_0.3bit_to_8_outs_0.inverter_dek_10.in 1.10392f
C215 a_39218_n4047# vco_core_3_0.nen5 0.1022f
C216 VCO_MUX_0.VCO_sel vco_in 0.82597f
C217 VCO_decoder_cells_0.VCO3_selection_0.inverter_dek_1.in VCO_decoder_cells_0.VCO3_selection_0.NAND_4in_dek_1.d 0.01061f
C218 VCO_decoder_cells_0.f5_n VCO_decoder_cells_0.011 2.72034f
C219 c2 VCO_decoder_cells_0.3bit_to_8_outs_0.inverter_dek_6.in 1.10383f
C220 VP VCO_decoder_cells_0.VCO2_selection_0.NAND_4in_dek_0.a 0.52715f
C221 f5 VCO_decoder_cells_0.after_000011 0.58829f
C222 VCO_decoder_cells_0.VCO3_5_sel a_42005_7152# 0.05117f
C223 PFD_passgate_3.B vco_core_2_0.vco_delay_cell_2$6_6.out 0.21239f
C224 VCO_decoder_cells_0.VCO3_selection_0.NAND_3in_dek_4.b VCO_decoder_cells_0.010 0.24346f
C225 vco_core_4_0.vco_delay_cell_4_0.dn vco_core_4_0.vco_delay_cell_4_0.in 0.06512f
C226 PFD_passgate_4.B vco_core_1_0.vco_delay_cell_1$1_2.in 0.03774f
C227 f4 f2 0.11107f
C228 0_buf_1.out 0_buf_0.out 0.43143f
C229 a_10463_n3464# VCO_decoder_cells_0.VCO2_selection_0.NAND_4in_dek_1.d 0.04377f
C230 VCO_MUX_0.VCO3_in out 0.32931f
C231 NOR_2in$1_0.A VCO_decoder_cells_0.after_000011_n 0.07437f
C232 a_31345_3300# inverter_x1_12.IN 0.03063f
C233 f4 VCO_decoder_cells_0.100 0.03007f
C234 VCO_decoder_cells_0.after_000011 f3 0.11829f
C235 NOR_2in$1_0.A vco_passgate_1.OI 0.89443f
C236 f4 VCO_decoder_cells_0.000000 0.04358f
C237 vco_core_1_0.vco_delay_cell_1$1_7.in a_39508_1356# 0.11019f
C238 vco_core_4_0.pgt vco_core_4_0.vco_delay_cell_4_9.up 0.21552f
C239 NOR_2in$1_0.Out NOR_2in$1_0.B 0.2371f
C240 VCO_decoder_cells_0.VCO3_11_sel vco_core_2_0.vco_delay_cell_2$6_6.out 0.04016f
C241 NOR_2in$1_0.B PFD_passgate_1.B 1.7833f
C242 VCO_decoder_cells_0.VCO4_selection_0.NAND_2in_dek_0.y a_3583_n5362# 0.04014f
C243 a_39506_2990# vco_core_1_0.vco_delay_cell_1$1_0.in 0.06455f
C244 VCO_MUX_0.VCO2_in a_46168_2592# 1.50476f
C245 VCO_decoder_cells_0.VCO3_selection_0.NAND_3in_dek_3.y f5 0.07475f
C246 a_38350_2990# vco_core_1_0.vco_delay_cell_1$1_0.pgt 0.02221f
C247 NOR_2in$1_0.A vco_core_3_0.vco_delay_cell_3_4.in 0.03609f
C248 vco_core_1_0.vco_delay_cell_1$1_5.in vco_core_1_0.vco_delay_cell_1$1_0.in 0.01051f
C249 f4 VCO_decoder_cells_0.after_001111 0.04796f
C250 vco_passgate_1.OI a_23442_n6301# 0.0372f
C251 f3 VCO_decoder_cells_0.row_section_decoding_0.NAND_3in_dek_0.a 0.33004f
C252 f1 VCO_decoder_cells_0.000000_n 0.05244f
C253 VP VCO_decoder_cells_0.3bit_to_8_outs_0.NAND_3in_dek_6.y 0.40042f
C254 a_38741_8614# vco_core_2_0.vco_delay_cell_2$6_0.pgt 0.12044f
C255 VCO_decoder_cells_0.VCO3_selection_0.NAND_4in_dek_0.d a_11526_1054# 0.01736f
C256 VCO_decoder_cells_0.VCO3_5_sel VCO_decoder_cells_0.VCO3_selection_0.NAND_4in_dek_1.c 0.59661f
C257 vco_core_4_0.vco_delay_cell_4_2.up vco_core_4_0.pgt 0.19866f
C258 VCO_decoder_cells_0.VCO4_selection_0.NAND_2in_dek_0.y VCO_decoder_cells_0.001 0.28902f
C259 vco_core_3_0.vco_delay_cell_3_8.in PFD_passgate_1.B 0.33702f
C260 VCO_decoder_cells_0.VCO3_5_sel NOR_2in$1_1.Out 0.2911f
C261 m2_11509_2917# VCO_decoder_cells_0.VCO3_selection_0.NAND_2in_dek_1.y 0.01039f
C262 VCO_MUX_0.VCO2_sel VP 0.98528f
C263 VCO_decoder_cells_0.row_section_decoding_0.NAND_3in_dek_0.c VCO_decoder_cells_0.000000_n 0.28634f
C264 VCO_decoder_cells_0.after_000111_n f4 0.4985f
C265 vco_core_2_0.vco_delay_cell_2$6_4.out vco_core_2_0.vco_delay_cell_2$6_6.in 0.14434f
C266 VCO_decoder_cells_0.after_000111_n a_4506_2110# 0.0397f
C267 VCO_MUX_0.VCO_in VP 2.48406f
C268 f5 VCO_decoder_cells_0.VCO2_selection_0.NAND_4in_dek_0.a 0.41713f
C269 inverter_x1_2.OUT VP 1.51294f
C270 a_39218_n5509# PFD_passgate_1.B 0.22004f
C271 vco_passgate_1.OI vco_core_3_0.vco_delay_cell_3_4.in 2.75724f
C272 f1 VCO_decoder_cells_0.001 0.05941f
C273 m2_50398_n2585# vco_passgate_1.en 0.08844f
C274 a_41855_n486# vco_core_0_0.vp 0.18491f
C275 vco_passgate_4.OI a_38741_7152# 0.01208f
C276 VCO_decoder_cells_0.110 f4 0.06229f
C277 vco_core_3_0.vco_delay_cell_3_2.in PFD_passgate_1.B 0.57024f
C278 vco_passgate_4.OI VCO_MUX_0.VCO3_sel 1.92311f
C279 VCO_decoder_cells_0.111 f2 0.07945f
C280 vco_passgate_4.OI a_38741_6360# 0.01208f
C281 m2_4702_n5455# VCO_decoder_cells_0.VCO4_selection_0.NAND_3in_dek_1.y 0.07333f
C282 vco_core_3_0.nen5 PFD_passgate_1.B 0.02529f
C283 vco_core_4_0.vco_delay_cell_4_2.in vco_core_4_0.vco_delay_cell_4_2.up 0.08248f
C284 vco_passgate_0.OI inverter_x1_2.IN 9.2644f
C285 vco_core_3_0.nen11 vco_core_3_0.vco_delay_cell_3_5.in 0.0394f
C286 a_39508_3420# vco_core_1_0.vco_delay_cell_1$1_6.in 0.08272f
C287 VCO_decoder_cells_0.111 VCO_decoder_cells_0.100 0.13053f
C288 VCO_decoder_cells_0.111 VCO_decoder_cells_0.000000 0.38631f
C289 vco_in vco_core_4_0.pgt 0.01452f
C290 vco_core_2_0.vco_delay_cell_2$6_8.in VP 0.01391f
C291 VCO_decoder_cells_0.VCO3_selection_0.inverter_dek_0.out VCO_decoder_cells_0.VCO3_selection_0.NAND_4in_dek_0.b 0.57875f
C292 c0 VCO_decoder_cells_0.3bit_to_8_outs_0.NAND_3in_dek_3.y 0.36282f
C293 a_4269_n5362# VCO_decoder_cells_0.VCO4_selection_0.NAND_3in_dek_1.y 0.01865f
C294 a_38350_1826# vco_core_1_0.vco_delay_cell_1$1_0.pgt 0.02882f
C295 a_43535_n5061# VP 0.76355f
C296 VP VCO_decoder_cells_0.3bit_to_8_outs_0.NAND_3in_dek_3.y 0.40042f
C297 m2_3889_957# VCO_decoder_cells_0.row_section_decoding_0.NAND_2in_dek_0.b 0.08647f
C298 VCO_decoder_cells_0.VCO4_selection_0.NAND_4in_dek_0.d a_3634_n4888# 0.01154f
C299 VCO_MUX_0.VCO_sel VCO_decoder_cells_0.f5_n 0.05391f
C300 vco_core_0_0.vp VCO_MUX_0.VCO2_sel 0.0264f
C301 f2 VCO_decoder_cells_0.after_000111 0.03933f
C302 VCO_decoder_cells_0.after_000011_n VCO_decoder_cells_0.VCO2_selection_0.NAND_4in_dek_1.c 0.41774f
C303 vco_core_3_0.out vco_core_3_0.vco_delay_cell_3_0.in 0.32844f
C304 VCO_decoder_cells_0.after_001111_n NOR_2in$1_0.B 0.05713f
C305 vco_core_0_0.vco_delay_cell_0$1_2.in a_41821_n2486# 0.12324f
C306 VCO_decoder_cells_0.111 VCO_decoder_cells_0.after_001111 0.1471f
C307 PFD_passgate_4.B vco_core_1_0.out 0.04129f
C308 a_44739_n5565# a_45341_n5690# 0.55039f
C309 a_41821_n2018# a_42501_n2018# 0.01446f
C310 vco_core_4_0.vco_delay_cell_4_0.dn vco_passgate_0.OI 0.05179f
C311 VCO_decoder_cells_0.after_000111 VCO_decoder_cells_0.100 3.4793f
C312 m2_51016_n2749# VCO_MUX_0.passgate_scaled_3.en_ 0.08956f
C313 VCO_decoder_cells_0.after_000111 VCO_decoder_cells_0.000000 11.5273f
C314 VCO_decoder_cells_0.after_001111_n VCO_decoder_cells_0.101 0.10371f
C315 vco_core_1_0.vco_delay_cell_1$1_3.in vco_core_1_0.nen11 0.09952f
C316 f0 VCO_decoder_cells_0.011 0.06683f
C317 VCO_MUX_0.VCO_sel VCO_decoder_cells_0.VCO_selection_0.NAND_3in_dek_0.c 0.30859f
C318 VCO_decoder_cells_0.VCO4_selection_0.NAND_2in_dek_0.y VP 0.25885f
C319 NOR_2in$1_0.A VCO_decoder_cells_0.VCO4_selection_0.NAND_4in_dek_0.b 0.08265f
C320 VCO_MUX_0.VCO_sel a_43476_n653# 0.01906f
C321 vco_passgate_3.OI vco_core_2_0.vco_delay_cell_2$6_0.pgt 0.22202f
C322 m2_3617_957# VCO_decoder_cells_0.after_001111_n 0.09653f
C323 a_37381_8614# vco_passgate_4.OI 0.24133f
C324 vco_core_2_0.nen11 a_41461_6360# 0.01233f
C325 vco_core_4_0.vco_delay_cell_4_5.dn vco_core_4_0.vco_delay_cell_4_5.up 0.03587f
C326 a_37194_2990# PFD_passgate_4.B 0.18219f
C327 a_43326_n10831# VP 0.75057f
C328 VP vco_core_1_0.vco_delay_cell_1$1_2.out 0.03924f
C329 VCO_decoder_cells_0.after_000111 VCO_decoder_cells_0.after_001111 11.3153f
C330 VCO_decoder_cells_0.f5_n VCO_decoder_cells_0.000 0.39354f
C331 VCO_decoder_cells_0.3bit_to_8_outs_0.c0_n VCO_decoder_cells_0.row_section_decoding_0.NAND_3in_dek_0.a 0.01058f
C332 VCO_decoder_cells_0.111 VCO_decoder_cells_0.after_000111_n 0.17943f
C333 PFD_passgate_1.B a_38402_n6301# 0.22858f
C334 vco_core_1_0.vco_delay_cell_1$1_5.in VCO_decoder_cells_0.VCO2_5_sel 0.62526f
C335 a_45943_n5690# inverter_x1_2.IN 0.01822f
C336 VCO_decoder_cells_0.VCO3_selection_0.NAND_4in_dek_1.a m2_11724_n995# 0.05585f
C337 VCO_decoder_cells_0.011 VCO_decoder_cells_0.VCO4_selection_0.NAND_3in_dek_1.y 0.0207f
C338 a_27182_n7843# vco_core_3_0.vco_delay_cell_3_0.pgt 0.25575f
C339 vco_core_3_0.vco_delay_cell_3_1.out PFD_passgate_1.B 0.01363f
C340 vco_passgate_4.OI vco_core_2_0.vco_delay_cell_2$6_2.in 1.18427f
C341 vco_passgate_3.OI vco_core_1_0.vco_delay_cell_1$1_4.in 0.64569f
C342 a_4053_n5362# a_4269_n5362# 0.01537f
C343 vco_core_4_0.vco_delay_cell_4_8.out vco_core_4_0.vco_delay_cell_4_7.up 0.08248f
C344 vco_core_3_0.nen11 PFD_passgate_1.B 0.14321f
C345 f1 VP 0.42073f
C346 a_9944_n428# a_10160_n428# 0.01537f
C347 VCO_decoder_cells_0.f5_n VCO_decoder_cells_0.VCO3_selection_0.NAND_3in_dek_0.y 0.29702f
C348 VCO_decoder_cells_0.after_000111_n VCO_decoder_cells_0.after_000111 3.34598f
C349 a_3986_2110# VP 0.06937f
C350 a_11111_n902# a_11327_n902# 0.01537f
C351 a_4427_n3074# VCO_decoder_cells_0.3bit_to_8_outs_0.inverter_dek_10.in 0.01202f
C352 VCO_decoder_cells_0.111 VCO_decoder_cells_0.110 11.4647f
C353 VCO_decoder_cells_0.VCO2_selection_0.NAND_4in_dek_0.b VCO_decoder_cells_0.after_000111 0.53204f
C354 vco_core_0_0.vco_delay_cell_0$1_0.pgt vco_core_0_0.vco_delay_cell_0$1_1.in 0.86305f
C355 VCO_decoder_cells_0.VCO4_selection_0.NAND_4in_dek_0.b VCO_decoder_cells_0.after_000011_n 0.3887f
C356 vco_core_2_0.out vco_core_2_0.vco_delay_cell_2$6_6.in 0.11189f
C357 a_36106_1826# vco_core_1_0.vco_delay_cell_1$1_0.out 0.08217f
C358 VCO_decoder_cells_0.row_section_decoding_0.NAND_3in_dek_0.b f2 0.19974f
C359 VCO_decoder_cells_0.VCO3_5_sel vco_core_2_0.vco_delay_cell_2$6_5.in 0.06164f
C360 VCO_decoder_cells_0.100 VCO_decoder_cells_0.VCO3_selection_0.NAND_4in_dek_1.b 0.2327f
C361 VCO_decoder_cells_0.row_section_decoding_0.NAND_3in_dek_0.c VP 0.23003f
C362 VCO_decoder_cells_0.after_001111 VCO_decoder_cells_0.VCO_selection_0.NAND_3in_dek_0.b 0.19953f
C363 VCO_decoder_cells_0.000000 VCO_decoder_cells_0.VCO3_selection_0.NAND_4in_dek_1.b 0.02964f
C364 NOR_2in$1_0.A VCO_decoder_cells_0.after_000011 0.09951f
C365 PFD_passgate_4.B vco_core_1_0.nen11 0.11364f
C366 vco_core_1_0.vco_delay_cell_1$1_6.out VCO_decoder_cells_0.VCO2_11_sel 0.02214f
C367 a_44964_2717# a_45566_2592# 0.55039f
C368 a_41209_n2018# vco_core_0_0.vco_delay_cell_0$1_2.in 0.06929f
C369 VCO_decoder_cells_0.row_section_decoding_0.NAND_2in_dek_0.b a_3986_2110# 0.0454f
C370 vco_passgate_0.OI VP 1.54466f
C371 VCO_MUX_0.VCO3_sel VCO_MUX_0.VCO2_in 0.17965f
C372 a_42467_n486# vco_core_0_0.out 0.12317f
C373 vco_passgate_3.OI VCO_decoder_cells_0.VCO2_11_sel 0.47698f
C374 VCO_MUX_0.VCO_sel VCO_decoder_cells_0.VCO2_selection_0.NAND_2in_dek_0.y 0.0144f
C375 vco_core_2_0.vco_delay_cell_2$6_0.pgt a_34661_4818# 0.12142f
C376 VCO_decoder_cells_0.110 VCO_decoder_cells_0.after_000111 0.23697f
C377 VCO_decoder_cells_0.VCO2_selection_0.NAND_4in_dek_0.d VCO_decoder_cells_0.f5_n 0.29151f
C378 VCO_decoder_cells_0.VCO3_selection_0.NAND_4in_dek_0.b VCO_decoder_cells_0.011 0.21921f
C379 VCO_MUX_0.VCO3_sel PFD_passgate_3.in_p 0.11493f
C380 a_41461_6360# vco_core_2_0.vco_delay_cell_2$6_0.in 0.04737f
C381 vco_core_4_0.vco_delay_cell_4_9.dn vco_core_4_0.pgt 0.02009f
C382 VCO_decoder_cells_0.VCO2_5_sel VCO_decoder_cells_0.VCO2_selection_0.NAND_4in_dek_0.a 0.28599f
C383 VCO_decoder_cells_0.100 VCO_decoder_cells_0.3bit_to_8_outs_0.inverter_dek_6.in 0.24089f
C384 a_39506_2990# vco_core_1_0.vco_delay_cell_1$1_6.in 0.07362f
C385 VCO_decoder_cells_0.011 VCO_decoder_cells_0.VCO2_selection_0.NAND_3in_dek_1.b 0.22042f
C386 a_10630_n902# f5 0.02901f
C387 a_10738_n1982# a_10954_n1982# 0.01537f
C388 vco_in VCO_decoder_cells_0.VCO2_11_sel 0.25962f
C389 VCO_decoder_cells_0.3bit_to_8_outs_0.NAND_3in_dek_0.y m2_5122_n1101# 0.09561f
C390 c2 VCO_decoder_cells_0.3bit_to_8_outs_0.c1_n 0.66038f
C391 vco_core_2_0.vco_delay_cell_2$6_4.out a_37381_7152# 0.04642f
C392 a_3531_n3074# VCO_decoder_cells_0.3bit_to_8_outs_0.c2_n 0.01057f
C393 VCO_MUX_0.inverter_dek_0.out out 0.16943f
C394 vco_core_2_0.nen11 vco_core_2_0.vco_delay_cell_2$6_1.in 0.02206f
C395 VCO_decoder_cells_0.after_000011 VCO_decoder_cells_0.after_000011_n 0.38326f
C396 VCO_decoder_cells_0.after_000111_n VCO_decoder_cells_0.VCO3_selection_0.NAND_4in_dek_1.b 0.43019f
C397 vco_passgate_0.OI vco_core_4_0.vco_delay_cell_4_8.up 0.61057f
C398 vco_core_1_0.vco_delay_cell_1$1_0.in vco_core_1_0.vco_delay_cell_1$1_2.out 0.17f
C399 VCO_decoder_cells_0.after_000011_n VCO_decoder_cells_0.VCO2_selection_0.NAND_3in_dek_0.y 0.02252f
C400 VCO_decoder_cells_0.110 VCO_decoder_cells_0.VCO3_selection_0.NAND_4in_dek_1.a 0.01103f
C401 inverter_x1_2.IN 0_buf_0.out 0.08752f
C402 VCO_decoder_cells_0.row_section_decoding_0.NAND_3in_dek_0.b VCO_decoder_cells_0.row_section_decoding_0.NAND_2in_dek_0.a 0.01463f
C403 VCO_decoder_cells_0.110 VCO_decoder_cells_0.VCO_selection_0.NAND_3in_dek_0.b 0.17451f
C404 c1 VCO_decoder_cells_0.000000_n 0.01608f
C405 VCO_decoder_cells_0.010 f4 0.04838f
C406 VCO_decoder_cells_0.3bit_to_8_outs_0.c0_n VCO_decoder_cells_0.3bit_to_8_outs_0.NAND_3in_dek_6.y 0.36287f
C407 f5 f1 0.1714f
C408 VP VCO_MUX_0.passgate_scaled_3.en_ 0.23961f
C409 a_4211_n1430# c2 0.01052f
C410 a_45943_n5690# VP 2.75203f
C411 a_39506_1826# vco_core_1_0.vco_delay_cell_1$1_7.in 0.08419f
C412 vco_core_2_0.vco_delay_cell_2$6_4.out vco_passgate_4.OI 1.13395f
C413 vco_passgate_3.OI a_41752_1356# 0.16462f
C414 VCO_MUX_0.VCO_sel f0 0.05502f
C415 vco_core_4_0.vco_delay_cell_4_1.dn vco_core_4_0.vco_delay_cell_4_1.up 0.03587f
C416 vco_core_4_0.vco_delay_cell_4_8.out vco_core_4_0.pgt 0.96495f
C417 f3 f1 0.43525f
C418 VCO_decoder_cells_0.110 VCO_decoder_cells_0.VCO3_selection_0.NAND_4in_dek_1.b 0.17688f
C419 inverter_x1_12.IN VCO_decoder_cells_0.VCO2_11_sel 0.15632f
C420 VCO_MUX_0.VCO2_sel VCO_decoder_cells_0.VCO2_5_sel 0.02678f
C421 vco_core_4_0.vco_delay_cell_4_4.up vco_passgate_0.OI 0.61239f
C422 NOR_2in$1_0.A VCO_decoder_cells_0.VCO2_selection_0.NAND_4in_dek_0.a 0.01425f
C423 a_29701_7737# VP 0.0467f
C424 VCO_decoder_cells_0.row_section_decoding_0.NAND_3in_dek_0.c f3 0.17838f
C425 VCO_decoder_cells_0.VCO3_selection_0.inverter_dek_1.in VP 0.40142f
C426 a_36021_8614# vco_core_2_0.vco_delay_cell_2$6_4.out 0.01038f
C427 vco_core_4_0.vco_delay_cell_4_6.dn vco_core_4_0.pgt 0.02009f
C428 vco_core_4_0.vco_delay_cell_4_0.in vco_core_4_0.vco_delay_cell_4_1.in 0.11087f
C429 vco_passgate_0.OI vco_core_3_0.vco_delay_cell_3_0.pgt 0.14314f
C430 f0 VCO_decoder_cells_0.000 0.05278f
C431 VP a_37196_3420# 0.01008f
C432 VCO_decoder_cells_0.VCO2_selection_0.NAND_4in_dek_0.d VCO_decoder_cells_0.VCO2_selection_0.NAND_2in_dek_0.y 0.60062f
C433 vco_in inverter_x1_2.IN 1.57339f
C434 vco_core_3_0.vco_delay_cell_3_0.pgt vco_core_3_0.vco_delay_cell_3_5.out 0.64618f
C435 a_45884_n1282# VCO_MUX_0.VCO3_sel 0.01948f
C436 VCO_decoder_cells_0.3bit_to_8_outs_0.c1_n VCO_decoder_cells_0.3bit_to_8_outs_0.inverter_dek_6.in 0.41671f
C437 vco_core_1_0.vco_delay_cell_1$1_3.in vco_core_1_0.vco_delay_cell_1$1_0.pgt 0.22046f
C438 vco_core_2_0.vco_delay_cell_2$6_6.in vco_core_2_0.vco_delay_cell_2$6_0.pgt 0.52104f
C439 VCO_decoder_cells_0.VCO3_selection_0.NAND_4in_dek_1.d m2_10551_n263# 0.14304f
C440 vco_passgate_3.OI a_42228_3420# 0.15577f
C441 VCO_decoder_cells_0.VCO3_selection_0.NAND_4in_dek_0.b a_11310_1054# 0.02222f
C442 m2_10650_n7353# VCO_decoder_cells_0.VCO5_selection_0.NAND_2in_dek_0.b 0.01482f
C443 m2_4702_n5455# VCO_decoder_cells_0.after_001111_n 0.34397f
C444 a_4722_154# f4 0.0323f
C445 vco_core_2_0.vco_delay_cell_2$6_1.in vco_core_2_0.vco_delay_cell_2$6_0.in 0.27102f
C446 VCO_decoder_cells_0.VCO3_selection_0.NAND_4in_dek_1.a VCO_decoder_cells_0.VCO3_selection_0.NAND_4in_dek_1.c 0.08011f
C447 out VCO_MUX_0.VCO2_sel 0.47993f
C448 VCO_decoder_cells_0.VCO2_selection_0.NAND_3in_dek_1.b VCO_decoder_cells_0.VCO2_selection_0.NAND_4in_dek_1.d 0.01086f
C449 VCO_decoder_cells_0.VCO2_selection_0.NAND_3in_dek_0.y VCO_decoder_cells_0.VCO2_selection_0.NAND_4in_dek_1.c 0.03075f
C450 VCO_decoder_cells_0.VCO4_selection_0.NAND_3in_dek_1.y VCO_decoder_cells_0.VCO4_selection_0.NAND_3in_dek_0.y 0.06934f
C451 VCO_decoder_cells_0.VCO4_selection_0.NAND_3in_dek_1.y VCO_decoder_cells_0.000 0.23713f
C452 a_10630_3010# VCO_decoder_cells_0.VCO3_selection_0.NAND_2in_dek_0.y 0.04346f
C453 a_10673_n3938# VCO_decoder_cells_0.VCO2_selection_0.NAND_3in_dek_0.y 0.01159f
C454 vco_core_1_0.nen5 vco_core_1_0.out 0.35082f
C455 VCO_MUX_0.VCO3_sel vco_core_1_0.vco_delay_cell_1$1_0.pgt 0.03422f
C456 VCO_decoder_cells_0.VCO2_selection_0.NAND_3in_dek_2.y VCO_decoder_cells_0.VCO2_selection_0.inverter_dek_0.out 0.61572f
C457 vco_core_1_0.vco_delay_cell_1$1_3.out vco_core_1_0.vco_delay_cell_1$1_3.in 0.31196f
C458 VCO_MUX_0.VCO_in out 0.62055f
C459 VCO_decoder_cells_0.VCO3_selection_0.NAND_4in_dek_1.b VCO_decoder_cells_0.VCO3_selection_0.NAND_4in_dek_1.c 0.48993f
C460 VCO_decoder_cells_0.011 VCO_decoder_cells_0.3bit_to_8_outs_0.inverter_dek_10.in 0.24091f
C461 vco_core_0_0.vco_delay_cell_0$1_0.pgt a_41821_n2486# 0.1168f
C462 PFD_passgate_0.B vco_core_4_0.vco_delay_cell_4_0.in 0.63923f
C463 inverter_x1_2.OUT PFD_passgate_0.B 0.17073f
C464 vco_core_0_0.vco_delay_cell_0$1_2.in a_41209_n2486# 0.08176f
C465 VCO_decoder_cells_0.111 VCO_decoder_cells_0.010 0.1169f
C466 NOR_2in$1_0.B vco_core_3_0.vco_delay_cell_3_7.out 0.07149f
C467 vco_core_4_0.vco_delay_cell_4_7.out 0_buf_1.in 0.14665f
C468 a_36108_1356# vco_core_1_0.vco_delay_cell_1$1_0.pgt 0.1812f
C469 a_3747_n1430# VCO_decoder_cells_0.3bit_to_8_outs_0.NAND_3in_dek_0.y 0.0504f
C470 VP 0_buf_0.out 2.43223f
C471 VCO_decoder_cells_0.VCO3_selection_0.NAND_4in_dek_0.d a_11310_1528# 0.04352f
C472 vco_core_2_0.vco_delay_cell_2$6_8.in PFD_passgate_3.B 0.23135f
C473 vco_core_1_0.vco_delay_cell_1$1_1.out vco_core_1_0.vco_delay_cell_1$1_7.in 0.32016f
C474 a_40101_8614# vco_core_2_0.vco_delay_cell_2$6_5.out 0.06326f
C475 vco_core_4_0.vco_delay_cell_4_7.out PFD_passgate_0.B 0.63923f
C476 VCO_decoder_cells_0.VCO2_selection_0.NAND_3in_dek_1.y VCO_decoder_cells_0.VCO2_selection_0.inverter_dek_0.out 0.31424f
C477 vco_core_1_0.vco_delay_cell_1$1_6.out VP 0.02568f
C478 PFD_passgate_4.B vco_core_1_0.vco_delay_cell_1$1_0.pgt 1.80246f
C479 VCO_decoder_cells_0.010 VCO_decoder_cells_0.after_000111 3.09449f
C480 VCO_decoder_cells_0.VCO2_5_sel vco_core_1_0.vco_delay_cell_1$1_2.out 0.04901f
C481 vco_core_0_0.in vco_core_0_0.vco_delay_cell_0$1_2.in 0.08169f
C482 a_10463_n5894# VCO_decoder_cells_0.VCO2_selection_0.NAND_2in_dek_0.y 0.04346f
C483 VCO_decoder_cells_0.after_000011 VCO_decoder_cells_0.VCO4_selection_0.NAND_4in_dek_0.b 0.29206f
C484 f2 VCO_decoder_cells_0.100 0.03045f
C485 VCO_decoder_cells_0.after_001111_n VCO_decoder_cells_0.011 0.33429f
C486 VCO_decoder_cells_0.000000 VCO_decoder_cells_0.VCO4_selection_0.NAND_4in_dek_0.d 0.23618f
C487 f2 VCO_decoder_cells_0.000000 0.04399f
C488 a_4577_n6871# VCO_decoder_cells_0.VCO_selection_0.NAND_3in_dek_0.c 0.0137f
C489 vco_core_2_0.vco_delay_cell_2$6_8.in VCO_decoder_cells_0.VCO3_11_sel 0.10808f
C490 vco_passgate_3.OI VP 2.50129f
C491 c1 c0 6.31364f
C492 vco_core_2_0.vco_delay_cell_2$6_6.in a_36021_7152# 0.06016f
C493 VCO_decoder_cells_0.VCO3_selection_0.NAND_4in_dek_0.b VCO_decoder_cells_0.VCO3_selection_0.NAND_4in_dek_0.d 0.20836f
C494 VCO_decoder_cells_0.000000 VCO_decoder_cells_0.100 2.98086f
C495 m2_50398_n1771# 0_buf_1.out 0.04414f
C496 vco_core_2_0.out vco_passgate_4.OI 2.0294f
C497 c1 VP 0.42681f
C498 m2_9698_n7271# VCO_decoder_cells_0.000 0.01117f
C499 0_buf_1.in a_43326_n10831# 0.30831f
C500 f2 VCO_decoder_cells_0.after_001111 0.04677f
C501 a_41855_n914# vco_core_0_0.vco_delay_cell_0$1_0.pgt 0.01152f
C502 a_38402_n7843# a_38402_n6301# 0.01952f
C503 VCO_MUX_0.VCO3_in VCO_MUX_0.VCO2_sel 0.51726f
C504 vco_core_1_0.vco_delay_cell_1$1_0.out VCO_decoder_cells_0.VCO2_11_sel 0.02534f
C505 m2_4164_957# VCO_decoder_cells_0.row_section_decoding_0.NAND_2in_dek_0.a 0.01263f
C506 vco_core_1_0.nen5 vco_core_1_0.nen11 0.02256f
C507 vco_core_0_0.vp vco_core_0_0.vco_delay_cell_0$1_2.in 0.48295f
C508 VCO_decoder_cells_0.f5_n VCO_decoder_cells_0.000000_n 0.29109f
C509 VCO_decoder_cells_0.VCO3_selection_0.NAND_3in_dek_4.b a_11327_n902# 0.02503f
C510 vco_in VP 3.0026f
C511 VCO_decoder_cells_0.100 VCO_decoder_cells_0.after_001111 0.85368f
C512 m2_11351_n2075# VCO_decoder_cells_0.VCO2_selection_0.NAND_3in_dek_1.y 0.01049f
C513 VCO_decoder_cells_0.VCO3_selection_0.NAND_4in_dek_0.b VCO_decoder_cells_0.VCO3_selection_0.NAND_3in_dek_0.y 0.02392f
C514 VCO_decoder_cells_0.000000 VCO_decoder_cells_0.after_001111 0.2645f
C515 vco_passgate_1.OI a_27182_n7843# 0.40668f
C516 vco_core_3_0.vco_delay_cell_3_0.pgt vco_core_3_0.vco_delay_cell_3_0.in 0.40277f
C517 VCO_MUX_0.VCO2_in VCO_MUX_0.passgate_scaled_1.en_ 0.27663f
C518 vco_core_2_0.vco_delay_cell_2$6_1.in a_38741_4818# 0.01238f
C519 m2_4640_n185# f0 0.20541f
C520 a_36021_8614# vco_core_2_0.out 0.06837f
C521 a_38402_n7843# vco_core_3_0.nen11 0.09025f
C522 VCO_MUX_0.VCO_in VCO_MUX_0.VCO3_in 0.02119f
C523 NOR_2in$1_0.A VCO_decoder_cells_0.VCO4_selection_0.NAND_2in_dek_0.y 0.30977f
C524 a_30922_n4047# vco_core_3_0.vco_delay_cell_3_8.in 0.0657f
C525 a_27182_n7843# vco_core_3_0.vco_delay_cell_3_4.in 0.06619f
C526 vco_core_4_0.vco_delay_cell_4_1.in vco_passgate_0.OI 4.53299f
C527 VCO_decoder_cells_0.after_000111_n f2 0.05623f
C528 m2_3889_957# VCO_decoder_cells_0.after_000011_n 0.09624f
C529 f2 VCO_decoder_cells_0.row_section_decoding_0.NAND_2in_dek_0.a 0.10016f
C530 VCO_decoder_cells_0.after_000111_n VCO_decoder_cells_0.100 0.27586f
C531 a_4246_154# VP 0.06931f
C532 VCO_decoder_cells_0.after_000111_n VCO_decoder_cells_0.000000 0.37996f
C533 VCO_MUX_0.VCO_sel VCO_MUX_0.VCO2_in 0.02451f
C534 VCO_decoder_cells_0.after_000011 VCO_decoder_cells_0.VCO2_selection_0.NAND_3in_dek_0.y 0.02634f
C535 vco_core_3_0.vco_delay_cell_3_9.in vco_core_3_0.vco_delay_cell_3_5.in 0.35098f
C536 vco_core_1_0.vco_delay_cell_1$1_2.out vco_core_1_0.vco_delay_cell_1$1_6.in 0.32016f
C537 inverter_x1_12.IN VP 0.38178f
C538 f4 NOR_2in$1_0.B 0.06147f
C539 vco_core_0_0.in vco_in 0.30423f
C540 VCO_decoder_cells_0.f5_n VCO_decoder_cells_0.001 0.25222f
C541 VCO_decoder_cells_0.row_section_decoding_0.NAND_2in_dek_0.b a_4246_1132# 0.02754f
C542 a_10476_n5420# VCO_decoder_cells_0.f5_n 0.03034f
C543 0_buf_1.in vco_passgate_0.OI 3.79383f
C544 vco_passgate_3.OI vco_core_0_0.vp 0.16313f
C545 f4 VCO_decoder_cells_0.101 0.04831f
C546 NOR_2in$1_0.A f1 0.05357f
C547 a_34662_n5509# a_34662_n4047# 0.01952f
C548 a_10729_n7436# inverter_x1_2.IN 0.04322f
C549 VCO_decoder_cells_0.110 f2 0.07252f
C550 VCO_decoder_cells_0.after_000111_n VCO_decoder_cells_0.after_001111 0.42684f
C551 a_11094_1054# a_11310_1054# 0.01537f
C552 a_3531_n3392# VCO_decoder_cells_0.3bit_to_8_outs_0.inverter_dek_8.in 0.01962f
C553 VCO_decoder_cells_0.110 VCO_decoder_cells_0.100 0.28786f
C554 a_41821_n2486# a_42501_n2486# 0.01578f
C555 VCO_decoder_cells_0.110 VCO_decoder_cells_0.000000 0.48842f
C556 VCO_decoder_cells_0.VCO4_selection_0.NAND_2in_dek_0.y VCO_decoder_cells_0.after_000011_n 0.24644f
C557 vco_core_1_0.vco_delay_cell_1$1_6.out vco_core_1_0.vco_delay_cell_1$1_0.in 0.43098f
C558 m2_11231_1611# VCO_decoder_cells_0.VCO3_selection_0.NAND_4in_dek_0.b 0.01078f
C559 PFD_passgate_0.B vco_passgate_0.OI 2.65594f
C560 a_40101_7152# PFD_passgate_3.B 0.09157f
C561 VCO_decoder_cells_0.after_000111 a_9993_n5894# 0.01847f
C562 VCO_decoder_cells_0.000000 a_9944_1528# 0.01015f
C563 c2 VCO_decoder_cells_0.3bit_to_8_outs_0.c2_n 0.47084f
C564 vco_passgate_3.OI vco_core_1_0.vco_delay_cell_1$1_0.in 0.67176f
C565 vco_core_4_0.vco_delay_cell_4_1.up vco_core_4_0.pgt 0.19866f
C566 VCO_decoder_cells_0.f5_n a_10692_n5420# 0.01185f
C567 PFD_passgate_3.B a_40101_6360# 0.09552f
C568 VCO_decoder_cells_0.VCO3_5_sel VCO_MUX_0.VCO3_sel 0.02635f
C569 VCO_decoder_cells_0.110 VCO_decoder_cells_0.after_001111 1.51055f
C570 VCO_decoder_cells_0.after_000111_n VCO_decoder_cells_0.row_section_decoding_0.NAND_2in_dek_0.a 0.02228f
C571 NOR_2in$1_0.A vco_core_3_0.vco_delay_cell_3_5.out 0.03301f
C572 vco_core_3_0.nen11 vco_core_3_0.vco_delay_cell_3_7.out 0.0761f
C573 VCO_decoder_cells_0.row_section_decoding_0.NAND_3in_dek_0.b a_4722_154# 0.04544f
C574 a_30922_n5509# vco_core_3_0.vco_delay_cell_3_5.in 0.10114f
C575 f1 VCO_decoder_cells_0.after_000011_n 0.039f
C576 vco_passgate_4.OI vco_core_2_0.vco_delay_cell_2$6_0.pgt 33.7419f
C577 VCO_decoder_cells_0.3bit_to_8_outs_0.NAND_3in_dek_0.y c1 0.41902f
C578 vco_core_2_0.vco_delay_cell_2$6_5.in vco_core_2_0.vco_delay_cell_2$6_5.out 0.27103f
C579 a_42005_8614# vco_core_2_0.vco_delay_cell_2$6_8.in 0.07064f
C580 VCO_MUX_0.VCO_sel VCO_decoder_cells_0.after_001111_n 0.0656f
C581 vco_core_3_0.vco_delay_cell_3_9.in PFD_passgate_1.B 0.34847f
C582 VCO_MUX_0.VCO2_in 0_buf_1.out 0.19299f
C583 VCO_decoder_cells_0.100 VCO_decoder_cells_0.VCO2_selection_0.NAND_3in_dek_1.a 0.05691f
C584 a_23442_n6301# vco_core_3_0.vco_delay_cell_3_5.out 0.05096f
C585 VCO_decoder_cells_0.110 VCO_decoder_cells_0.after_000111_n 3.49911f
C586 a_39218_n4047# vco_core_3_0.out 0.04816f
C587 VCO_decoder_cells_0.VCO5_selection_0.NAND_2in_dek_0.a VCO_decoder_cells_0.000000 0.41651f
C588 VCO_decoder_cells_0.VCO3_selection_0.NAND_3in_dek_4.a VCO_decoder_cells_0.VCO2_selection_0.NAND_3in_dek_1.a 0.01654f
C589 out VCO_MUX_0.passgate_scaled_3.en_ 0.58222f
C590 a_36021_8614# vco_core_2_0.vco_delay_cell_2$6_0.pgt 0.17078f
C591 VCO_decoder_cells_0.VCO3_selection_0.NAND_4in_dek_0.d a_11094_1054# 0.0306f
C592 VCO_decoder_cells_0.after_000111_n a_9944_1528# 0.01259f
C593 a_9777_n3464# a_9993_n3464# 0.01537f
C594 a_45884_n1282# VCO_MUX_0.VCO_sel 0.04219f
C595 c0 VCO_decoder_cells_0.f5_n 0.01792f
C596 VCO_decoder_cells_0.after_001111 VCO_decoder_cells_0.VCO2_selection_0.NAND_3in_dek_1.a 0.58886f
C597 VCO_decoder_cells_0.111 NOR_2in$1_0.B 0.08785f
C598 VCO_decoder_cells_0.f5_n VP 1.92966f
C599 vco_passgate_1.OI vco_passgate_0.OI 0.72933f
C600 VCO_MUX_0.passgate_scaled_0.en_ VCO_MUX_0.passgate_scaled_2.en_ 0.011f
C601 VCO_decoder_cells_0.after_001111_n VCO_decoder_cells_0.000 0.12681f
C602 a_45566_2592# VP 1.44533f
C603 vco_core_4_0.vco_delay_cell_4_9.out vco_core_4_0.vco_delay_cell_4_10.dn 0.0652f
C604 vco_passgate_1.OI vco_core_3_0.vco_delay_cell_3_5.out 2.75826f
C605 VCO_decoder_cells_0.111 VCO_decoder_cells_0.101 0.62371f
C606 VCO_decoder_cells_0.3bit_to_8_outs_0.c2_n VCO_decoder_cells_0.3bit_to_8_outs_0.inverter_dek_6.in 0.05723f
C607 f0 VCO_decoder_cells_0.000000_n 0.06197f
C608 m2_11351_n2321# VCO_decoder_cells_0.VCO2_selection_0.inverter_dek_0.out 0.09661f
C609 NOR_2in$1_0.A m2_3226_n5537# 0.09786f
C610 VP VCO_decoder_cells_0.VCO_selection_0.NAND_3in_dek_0.c 0.38587f
C611 vco_core_0_0.vco_delay_cell_0$1_0.pgt VP 0.0128f
C612 a_44190_7593# a_44792_7593# 0.37543f
C613 a_43476_n653# VP 0.75057f
C614 VCO_decoder_cells_0.3bit_to_8_outs_0.NAND_3in_dek_2.y VCO_decoder_cells_0.VCO4_selection_0.NAND_4in_dek_0.d 0.01262f
C615 vco_core_3_0.vco_delay_cell_3_5.out vco_core_3_0.vco_delay_cell_3_4.in 0.16384f
C616 vco_core_3_0.out vco_core_3_0.vco_delay_cell_3_5.in 0.26031f
C617 VCO_decoder_cells_0.after_000111 NOR_2in$1_0.B 0.08845f
C618 vco_core_1_0.out VCO_decoder_cells_0.VCO2_11_sel 0.01334f
C619 vco_core_0_0.vco_delay_cell_0$1_0.pgt a_41209_n2486# 0.12423f
C620 a_39508_3420# vco_core_1_0.vco_delay_cell_1$1_2.out 0.10901f
C621 f5 a_9777_n5894# 0.01244f
C622 a_30922_n5509# PFD_passgate_1.B 0.22557f
C623 a_41855_n914# a_42467_n914# 0.01752f
C624 VCO_decoder_cells_0.after_000111 VCO_decoder_cells_0.101 0.73993f
C625 a_9944_n428# VCO_decoder_cells_0.after_001111_n 0.01052f
C626 vco_core_1_0.vco_delay_cell_1$1_3.in a_40664_1356# 0.09177f
C627 vco_core_1_0.nen5 vco_core_1_0.vco_delay_cell_1$1_0.pgt 0.38607f
C628 vco_passgate_4.OI a_36021_7152# 0.01267f
C629 VCO_decoder_cells_0.VCO5_selection_0.NAND_2in_dek_0.b a_10253_n7436# 0.04346f
C630 VCO_decoder_cells_0.after_000111_n VCO_decoder_cells_0.VCO3_selection_0.NAND_4in_dek_1.c 0.17688f
C631 vco_passgate_4.OI a_36021_6360# 0.01227f
C632 vco_passgate_1.en_ vco_passgate_1.en 0.11981f
C633 VCO_decoder_cells_0.after_000111_n a_10457_n3938# 0.03036f
C634 f0 VCO_decoder_cells_0.001 0.06267f
C635 vco_core_0_0.in vco_core_0_0.vco_delay_cell_0$1_0.pgt 0.14293f
C636 vco_core_1_0.vco_delay_cell_1$1_6.out VCO_decoder_cells_0.VCO2_5_sel 0.04211f
C637 vco_core_4_0.vco_delay_cell_4_0.out vco_core_4_0.vco_delay_cell_4_9.out 0.11087f
C638 vco_core_1_0.vco_delay_cell_1$1_4.in vco_core_1_0.nen11 0.02053f
C639 VCO_decoder_cells_0.VCO4_selection_0.NAND_2in_dek_0.y VCO_decoder_cells_0.VCO4_selection_0.NAND_4in_dek_0.b 0.31899f
C640 a_4361_n6871# VCO_decoder_cells_0.VCO_selection_0.NAND_3in_dek_0.a 0.01515f
C641 a_36106_1826# vco_core_1_0.vco_delay_cell_1$1_0.pgt 0.01095f
C642 NOR_2in$1_0.A vco_core_3_0.vco_delay_cell_3_0.in 0.17203f
C643 VCO_MUX_0.VCO3_in VCO_MUX_0.passgate_scaled_3.en_ 0.27664f
C644 VCO_decoder_cells_0.3bit_to_8_outs_0.c0_n c1 1.10897f
C645 vco_passgate_3.OI VCO_decoder_cells_0.VCO2_5_sel 0.35043f
C646 VCO_decoder_cells_0.3bit_to_8_outs_0.inverter_dek_8.in a_4427_n3392# 0.01202f
C647 a_37381_6360# vco_core_2_0.vco_delay_cell_2$6_3.in 0.04737f
C648 VP vco_core_1_0.vco_delay_cell_1$1_2.in 0.03436f
C649 a_41209_n2018# a_41821_n2018# 0.01752f
C650 m2_3889_957# VCO_decoder_cells_0.after_000011 0.01141f
C651 VCO_decoder_cells_0.010 f2 0.04836f
C652 VCO_decoder_cells_0.VCO4_selection_0.NAND_3in_dek_1.y VCO_decoder_cells_0.001 0.24287f
C653 out 0_buf_0.out 0.08737f
C654 f5 VCO_decoder_cells_0.f5_n 7.27826f
C655 vco_core_0_0.vco_delay_cell_0$1_0.pgt vco_core_0_0.vp 6.4847f
C656 VCO_decoder_cells_0.010 VCO_decoder_cells_0.100 0.2592f
C657 VCO_decoder_cells_0.010 VCO_decoder_cells_0.000000 0.58355f
C658 vco_core_2_0.out vco_core_2_0.vco_delay_cell_2$6_9.out 0.06648f
C659 vco_in VCO_decoder_cells_0.VCO2_5_sel 0.04036f
C660 VP VCO_decoder_cells_0.VCO2_selection_0.NAND_2in_dek_0.y 0.26171f
C661 vco_core_4_0.vco_delay_cell_4_7.dn vco_core_4_0.vco_delay_cell_4_7.up 0.03587f
C662 a_44680_n1157# a_44078_n653# 0.48912f
C663 m2_50398_n1771# inverter_x1_2.IN 0.08844f
C664 vco_passgate_4.OI vco_core_2_0.vco_delay_cell_2$6_3.in 1.18427f
C665 vco_core_3_0.out PFD_passgate_1.B 0.34674f
C666 vco_core_2_0.nen11 VCO_MUX_0.VCO3_sel 0.01378f
C667 VCO_decoder_cells_0.VCO3_selection_0.NAND_4in_dek_0.b VCO_decoder_cells_0.000000_n 0.12387f
C668 vco_passgate_3.OI vco_core_1_0.vco_delay_cell_1$1_7.in 0.64707f
C669 VCO_decoder_cells_0.VCO3_selection_0.NAND_4in_dek_1.b VCO_decoder_cells_0.101 0.27786f
C670 f5 VCO_decoder_cells_0.VCO_selection_0.NAND_3in_dek_0.c 0.16632f
C671 f3 VCO_decoder_cells_0.f5_n 0.03148f
C672 vco_core_1_0.nen11 VCO_decoder_cells_0.VCO2_11_sel 0.37553f
C673 a_45132_n11460# a_45734_n11460# 0.92278f
C674 PFD_passgate_1.B a_30922_n6301# 0.23521f
C675 vco_core_0_0.vco_delay_cell_0$1_0.pgt vco_core_3_0.vco_delay_cell_3_0.pgt 0.02594f
C676 VCO_decoder_cells_0.010 VCO_decoder_cells_0.after_001111 0.3095f
C677 VCO_decoder_cells_0.3bit_to_8_outs_0.NAND_3in_dek_2.y VCO_decoder_cells_0.3bit_to_8_outs_0.c1_n 0.34305f
C678 VCO_MUX_0.VCO_in VCO_MUX_0.inverter_dek_0.out 0.41538f
C679 VCO_decoder_cells_0.3bit_to_8_outs_0.inverter_dek_1.in c2 0.28637f
C680 vco_passgate_1.OI vco_core_3_0.vco_delay_cell_3_0.in 3.04961f
C681 VCO_decoder_cells_0.VCO3_5_sel vco_core_2_0.vco_delay_cell_2$6_4.out 0.06906f
C682 vco_in PFD_passgate_3.B 0.33553f
C683 VCO_decoder_cells_0.101 VCO_decoder_cells_0.3bit_to_8_outs_0.inverter_dek_6.in 0.3678f
C684 vco_core_1_0.vco_delay_cell_1$1_6.out vco_core_1_0.vco_delay_cell_1$1_6.in 0.31541f
C685 a_42228_3420# vco_core_1_0.out 0.14888f
C686 inverter_x1_12.IN VCO_decoder_cells_0.VCO2_5_sel 0.26863f
C687 f2 a_4722_628# 0.0323f
C688 m2_4279_n6788# VCO_decoder_cells_0.VCO_selection_0.NAND_3in_dek_0.a 0.04467f
C689 vco_core_1_0.vco_delay_cell_1$1_0.in vco_core_1_0.vco_delay_cell_1$1_0.out 0.35866f
C690 PFD_passgate_0.B vco_in 0.30931f
C691 a_3747_n3074# VCO_decoder_cells_0.3bit_to_8_outs_0.inverter_dek_10.in 0.0504f
C692 a_42467_n486# vco_core_0_0.vco_delay_cell_0$1_0.in 0.08176f
C693 vco_passgate_3.OI vco_core_1_0.vco_delay_cell_1$1_6.in 0.61502f
C694 VCO_decoder_cells_0.after_000111_n VCO_decoder_cells_0.010 0.15146f
C695 VCO_decoder_cells_0.VCO3_11_sel vco_in 0.03237f
C696 a_39506_2990# vco_core_1_0.vco_delay_cell_1$1_2.out 0.0826f
C697 VCO_decoder_cells_0.001 VCO_decoder_cells_0.VCO2_selection_0.NAND_3in_dek_1.b 0.0104f
C698 vco_passgate_0.OI vco_core_4_0.vco_delay_cell_4_10.up 0.61027f
C699 f0 VP 3.65668f
C700 NOR_2in$1_0.A vco_in 0.03822f
C701 m2_11231_1693# VCO_decoder_cells_0.VCO3_selection_0.NAND_4in_dek_0.d 0.14185f
C702 VCO_decoder_cells_0.3bit_to_8_outs_0.inverter_dek_6.in a_4427_n1748# 0.01202f
C703 VCO_decoder_cells_0.after_000011 f1 0.0411f
C704 a_41752_1356# vco_core_1_0.nen11 0.04147f
C705 VCO_decoder_cells_0.VCO3_selection_0.NAND_2in_dek_0.y a_11106_3010# 0.01079f
C706 VCO_MUX_0.VCO3_sel a_43760_3221# 0.01517f
C707 VCO_decoder_cells_0.VCO3_selection_0.NAND_3in_dek_4.b VCO_decoder_cells_0.VCO3_selection_0.NAND_4in_dek_1.d 0.01728f
C708 f4 VCO_decoder_cells_0.011 0.06202f
C709 VCO_decoder_cells_0.VCO3_11_sel a_11526_1054# 0.04361f
C710 VCO_decoder_cells_0.VCO3_selection_0.NAND_4in_dek_1.d a_11526_n428# 0.01149f
C711 VCO_MUX_0.VCO3_in 0_buf_0.out 0.33893f
C712 c0 VCO_decoder_cells_0.VCO4_selection_0.NAND_3in_dek_1.y 0.03762f
C713 VCO_decoder_cells_0.110 VCO_decoder_cells_0.010 0.20952f
C714 m2_51016_n1607# VCO_MUX_0.VCO2_in 0.04414f
C715 VCO_decoder_cells_0.row_section_decoding_0.NAND_3in_dek_0.c VCO_decoder_cells_0.after_000011 0.01297f
C716 VP VCO_decoder_cells_0.VCO4_selection_0.NAND_3in_dek_1.y 0.53565f
C717 f5 VCO_decoder_cells_0.VCO2_selection_0.NAND_2in_dek_0.y 0.22366f
C718 vco_core_1_0.vco_delay_cell_1$1_0.in vco_core_1_0.vco_delay_cell_1$1_2.in 0.17f
C719 PFD_passgate_1.B vco_core_3_0.vco_delay_cell_3_3.in 0.57024f
C720 vco_core_4_0.vco_delay_cell_4_3.up vco_passgate_0.OI 0.61131f
C721 a_44792_7593# VP 0.75482f
C722 vco_core_2_0.vco_delay_cell_2$6_0.pgt a_41461_4818# 0.11436f
C723 vco_core_4_0.vco_delay_cell_4_7.dn vco_core_4_0.pgt 0.02009f
C724 VCO_MUX_0.VCO_in VCO_MUX_0.VCO2_sel 0.02678f
C725 VCO_decoder_cells_0.row_section_decoding_0.NAND_2in_dek_0.a a_4722_628# 0.04506f
C726 vco_core_0_0.vco_delay_cell_0$1_0.in vco_core_0_0.out 0.29321f
C727 VCO_decoder_cells_0.after_000111_n a_9944_1054# 0.01259f
C728 VCO_decoder_cells_0.VCO2_selection_0.inverter_dek_0.out VCO_decoder_cells_0.VCO2_selection_0.NAND_4in_dek_1.d 0.02273f
C729 vco_core_4_0.vco_delay_cell_4_10.out vco_core_4_0.pgt 0.96495f
C730 VCO_decoder_cells_0.row_section_decoding_0.NAND_3in_dek_0.c VCO_decoder_cells_0.row_section_decoding_0.NAND_3in_dek_0.a 0.25364f
C731 VP vco_core_1_0.out 0.70347f
C732 vco_in vco_passgate_1.OI 0.06025f
C733 vco_core_2_0.vco_delay_cell_2$6_0.pgt vco_core_1_0.vco_delay_cell_1$1_0.pgt 0.10919f
C734 vco_core_0_0.vp a_42501_n2486# 0.15984f
C735 VCO_decoder_cells_0.111 VCO_decoder_cells_0.VCO_selection_0.NAND_3in_dek_0.a 0.22094f
C736 vco_passgate_4.OI VP 2.01656f
C737 vco_core_2_0.vco_delay_cell_2$6_9.out vco_core_2_0.vco_delay_cell_2$6_0.pgt 0.01072f
C738 a_3531_n1430# c2 0.01052f
C739 VCO_decoder_cells_0.VCO3_selection_0.NAND_4in_dek_1.a m2_11724_n1241# 0.09593f
C740 a_44739_n5565# VP 0.81077f
C741 VCO_decoder_cells_0.VCO3_selection_0.NAND_4in_dek_1.a VCO_decoder_cells_0.VCO3_selection_0.inverter_dek_0.out 0.02439f
C742 vco_passgate_3.OI a_39508_1356# 0.17137f
C743 VCO_decoder_cells_0.010 VCO_decoder_cells_0.VCO2_selection_0.NAND_3in_dek_1.a 0.20016f
C744 VCO_MUX_0.VCO2_in inverter_x1_2.IN 0.10596f
C745 vco_core_4_0.vco_delay_cell_4_3.dn vco_core_4_0.vco_delay_cell_4_3.in 0.0652f
C746 VCO_decoder_cells_0.3bit_to_8_outs_0.NAND_3in_dek_3.y VCO_decoder_cells_0.3bit_to_8_outs_0.NAND_3in_dek_6.y 0.07903f
C747 VCO_decoder_cells_0.010 VCO_decoder_cells_0.VCO5_selection_0.NAND_2in_dek_0.a 0.14137f
C748 0_buf_1.in vco_core_4_0.vco_delay_cell_4_5.dn 0.07967f
C749 vco_core_0_0.in a_42467_n914# 0.12562f
C750 VCO_decoder_cells_0.VCO3_selection_0.NAND_4in_dek_0.b VP 0.37881f
C751 f5 f0 0.13327f
C752 vco_core_1_0.vco_delay_cell_1$1_4.in vco_core_1_0.vco_delay_cell_1$1_0.pgt 0.30616f
C753 VCO_decoder_cells_0.after_000111 VCO_decoder_cells_0.VCO_selection_0.NAND_3in_dek_0.a 0.35065f
C754 VP VCO_decoder_cells_0.VCO2_selection_0.NAND_3in_dek_1.b 0.2956f
C755 VCO_decoder_cells_0.VCO3_5_sel vco_core_2_0.out 0.31113f
C756 m2_11231_1693# m2_11231_1611# 0.20492f
C757 VCO_MUX_0.VCO_sel a_4361_n6871# 0.04016f
C758 a_42226_2990# vco_core_1_0.out 0.08535f
C759 f3 f0 0.06144f
C760 PFD_passgate_0.B vco_core_4_0.vco_delay_cell_4_5.dn 0.10573f
C761 vco_core_4_0.vco_delay_cell_4_9.dn PFD_passgate_0.B 0.12651f
C762 VCO_decoder_cells_0.111 VCO_decoder_cells_0.011 0.20851f
C763 vco_core_0_0.in a_41821_n2018# 0.12786f
C764 a_3531_n1748# a_3747_n1748# 0.01537f
C765 VCO_decoder_cells_0.after_001111_n VCO_decoder_cells_0.000000_n 0.17813f
C766 a_10463_n3464# VCO_decoder_cells_0.after_000011_n 0.02888f
C767 VCO_decoder_cells_0.3bit_to_8_outs_0.c2_n VCO_decoder_cells_0.3bit_to_8_outs_0.c1_n 2.71674f
C768 a_27182_n5509# vco_core_3_0.vco_delay_cell_3_9.in 0.04645f
C769 vco_core_2_0.vco_delay_cell_2$6_6.in PFD_passgate_3.B 1.73882f
C770 vco_passgate_3.OI a_39508_3420# 0.17137f
C771 VCO_decoder_cells_0.VCO5_selection_0.NAND_2in_dek_0.b inverter_x1_2.IN 0.2283f
C772 VCO_MUX_0.inverter_dek_0.out m2_50108_n531# 0.0567f
C773 vco_core_2_0.vco_delay_cell_2$6_6.out a_34661_4818# 0.01238f
C774 PFD_passgate_4.B a_40662_2990# 0.18203f
C775 vco_core_3_0.vco_delay_cell_3_0.pgt a_39218_n4047# 0.26291f
C776 NOR_2in$1_0.B VCO_decoder_cells_0.VCO4_selection_0.NAND_4in_dek_0.d 0.14703f
C777 vco_core_0_0.vco_delay_cell_0$1_2.in vco_core_0_0.vco_delay_cell_0$1_3.in 0.27785f
C778 VP vco_core_1_0.nen11 0.1136f
C779 f2 NOR_2in$1_0.B 0.05451f
C780 NOR_2in$1_0.B vco_core_3_0.vco_delay_cell_3_7.in 0.17036f
C781 vco_core_1_0.vco_delay_cell_1$1_0.pgt VCO_decoder_cells_0.VCO2_11_sel 0.82941f
C782 VCO_decoder_cells_0.VCO_selection_0.NAND_3in_dek_0.a VCO_decoder_cells_0.VCO_selection_0.NAND_3in_dek_0.b 0.47217f
C783 VCO_decoder_cells_0.VCO3_selection_0.inverter_dek_1.in VCO_decoder_cells_0.VCO2_selection_0.NAND_3in_dek_0.y 0.01089f
C784 VCO_decoder_cells_0.000000_n a_9777_n3464# 0.01052f
C785 VCO_decoder_cells_0.after_000111 VCO_decoder_cells_0.011 0.73396f
C786 a_9993_n3938# VCO_decoder_cells_0.VCO2_selection_0.NAND_3in_dek_0.y 0.0405f
C787 VCO_decoder_cells_0.100 NOR_2in$1_0.B 0.08793f
C788 f2 VCO_decoder_cells_0.101 0.04843f
C789 VCO_decoder_cells_0.after_000111_n VCO_decoder_cells_0.VCO2_selection_0.NAND_3in_dek_2.y 0.34438f
C790 vco_core_0_0.vp a_41821_n2018# 0.02266f
C791 VCO_decoder_cells_0.000000 NOR_2in$1_0.B 0.07672f
C792 vco_core_2_0.vco_delay_cell_2$6_6.in VCO_decoder_cells_0.VCO3_11_sel 0.20227f
C793 VCO_decoder_cells_0.VCO2_selection_0.NAND_4in_dek_0.b VCO_decoder_cells_0.VCO2_selection_0.NAND_3in_dek_2.y 0.0321f
C794 NOR_2in$1_0.Out VP 0.49594f
C795 a_40662_1826# vco_core_1_0.vco_delay_cell_1$1_3.in 0.08217f
C796 NOR_2in$1_0.A VCO_decoder_cells_0.f5_n 0.09222f
C797 vco_passgate_4.OI a_40101_4818# 0.24133f
C798 VCO_decoder_cells_0.100 VCO_decoder_cells_0.101 9.01426f
C799 VP PFD_passgate_1.B 0.37761f
C800 VCO_decoder_cells_0.000000 VCO_decoder_cells_0.101 0.23113f
C801 VCO_MUX_0.VCO_sel f4 0.05386f
C802 VCO_decoder_cells_0.VCO3_selection_0.NAND_4in_dek_1.d VCO_decoder_cells_0.VCO3_5_sel 0.10524f
C803 vco_core_3_0.vco_delay_cell_3_8.in vco_core_3_0.vco_delay_cell_3_7.in 0.16384f
C804 vco_core_4_0.vco_delay_cell_4_8.out PFD_passgate_0.B 0.64466f
C805 vco_core_1_0.vco_delay_cell_1$1_0.in vco_core_1_0.out 0.04273f
C806 VCO_decoder_cells_0.after_001111_n VCO_decoder_cells_0.001 0.17023f
C807 VCO_decoder_cells_0.VCO2_5_sel vco_core_1_0.vco_delay_cell_1$1_2.in 0.04411f
C808 vco_core_1_0.vco_delay_cell_1$1_3.out VCO_decoder_cells_0.VCO2_11_sel 0.1053f
C809 NOR_2in$1_0.B VCO_decoder_cells_0.after_001111 0.05451f
C810 VCO_decoder_cells_0.VCO3_selection_0.inverter_dek_1.in VCO_decoder_cells_0.VCO3_selection_0.NAND_3in_dek_3.y 0.30343f
C811 VCO_decoder_cells_0.101 VCO_decoder_cells_0.after_001111 0.13162f
C812 VCO_MUX_0.VCO_sel m2_4279_n6788# 0.06041f
C813 vco_core_2_0.nen5 vco_core_2_0.out 0.36491f
C814 vco_core_3_0.vco_delay_cell_3_0.pgt vco_core_3_0.vco_delay_cell_3_5.in 0.75942f
C815 VCO_decoder_cells_0.VCO2_5_sel VCO_decoder_cells_0.VCO2_selection_0.NAND_2in_dek_0.y 0.46141f
C816 vco_core_4_0.vco_delay_cell_4_6.dn PFD_passgate_0.B 0.12651f
C817 VCO_MUX_0.VCO2_in VP 2.68002f
C818 a_37194_2990# vco_core_1_0.vco_delay_cell_1$1_0.in 0.06482f
C819 m2_3617_957# VCO_decoder_cells_0.after_001111 0.09901f
C820 f4 VCO_decoder_cells_0.000 0.04746f
C821 a_41752_1356# vco_core_1_0.vco_delay_cell_1$1_0.pgt 0.17441f
C822 PFD_passgate_3.in_p VP 1.34503f
C823 vco_core_3_0.vco_delay_cell_3_0.pgt a_19702_n6301# 0.01323f
C824 VCO_decoder_cells_0.after_000111_n NOR_2in$1_0.B 0.10235f
C825 VCO_decoder_cells_0.f5_n VCO_decoder_cells_0.after_000011_n 0.13789f
C826 VCO_decoder_cells_0.VCO2_selection_0.NAND_4in_dek_0.b NOR_2in$1_0.B 0.01181f
C827 VCO_decoder_cells_0.3bit_to_8_outs_0.inverter_dek_1.in f2 0.02774f
C828 vco_core_2_0.vco_delay_cell_2$6_2.in a_38741_4818# 0.06478f
C829 VCO_decoder_cells_0.after_000111_n VCO_decoder_cells_0.101 0.1882f
C830 vco_core_0_0.vp vco_core_1_0.nen11 0.01125f
C831 VCO_decoder_cells_0.VCO2_selection_0.NAND_4in_dek_0.b VCO_decoder_cells_0.101 0.27738f
C832 VCO_decoder_cells_0.111 VCO_decoder_cells_0.VCO2_selection_0.NAND_4in_dek_1.d 0.28756f
C833 c0 VCO_decoder_cells_0.3bit_to_8_outs_0.inverter_dek_10.in 0.2704f
C834 vco_core_4_0.vco_delay_cell_4_0.in vco_passgate_0.OI 4.19887f
C835 a_34662_n7843# a_34662_n6301# 0.01952f
C836 inverter_x1_2.OUT vco_passgate_0.OI 0.21945f
C837 vco_core_0_0.vco_delay_cell_0$1_0.pgt vco_passgate_1.OI 0.0267f
C838 VCO_MUX_0.passgate_scaled_0.en_ 0_buf_1.out 0.24026f
C839 PFD_passgate_4.B a_40662_1826# 0.19114f
C840 m2_4850_n2745# VCO_decoder_cells_0.3bit_to_8_outs_0.NAND_3in_dek_6.y 0.11606f
C841 vco_core_1_0.vco_delay_cell_1$1_3.out a_41752_1356# 0.10186f
C842 VP VCO_decoder_cells_0.3bit_to_8_outs_0.inverter_dek_10.in 0.36498f
C843 VCO_decoder_cells_0.VCO3_5_sel vco_core_2_0.vco_delay_cell_2$6_0.pgt 0.43302f
C844 NOR_2in$1_0.B vco_passgate_1.en 0.08099f
C845 VCO_decoder_cells_0.3bit_to_8_outs_0.NAND_3in_dek_2.y VCO_decoder_cells_0.3bit_to_8_outs_0.c2_n 0.28637f
C846 vco_core_2_0.vco_delay_cell_2$6_6.in vco_core_2_0.vco_delay_cell_2$6_6.out 0.27669f
C847 VCO_decoder_cells_0.110 NOR_2in$1_0.B 0.07888f
C848 m2_11509_2835# VCO_decoder_cells_0.VCO3_selection_0.inverter_dek_0.out 0.09636f
C849 VCO_decoder_cells_0.VCO5_selection_0.NAND_2in_dek_0.b VP 0.27591f
C850 VCO_decoder_cells_0.after_000011_n a_10630_1054# 0.02888f
C851 VCO_decoder_cells_0.VCO3_selection_0.NAND_3in_dek_4.b VCO_decoder_cells_0.001 0.24644f
C852 VCO_decoder_cells_0.110 VCO_decoder_cells_0.101 7.10697f
C853 vco_core_1_0.vco_delay_cell_1$1_0.in vco_core_1_0.nen11 0.04239f
C854 vco_core_1_0.vco_delay_cell_1$1_6.out vco_core_1_0.vco_delay_cell_1$1_5.in 0.22477f
C855 vco_core_1_0.vco_delay_cell_1$1_0.pgt a_42228_3420# 0.15878f
C856 NOR_2in$1_0.A VCO_decoder_cells_0.VCO2_selection_0.NAND_2in_dek_0.y 0.01138f
C857 m2_4850_n2087# VCO_decoder_cells_0.101 0.0959f
C858 vco_core_4_0.vco_delay_cell_4_7.out vco_passgate_0.OI 4.20193f
C859 a_10160_3010# VCO_decoder_cells_0.VCO3_selection_0.NAND_3in_dek_0.y 0.04031f
C860 vco_core_3_0.vco_delay_cell_3_0.pgt PFD_passgate_1.B 2.51705f
C861 vco_passgate_3.OI vco_core_1_0.vco_delay_cell_1$1_5.in 0.68668f
C862 VCO_decoder_cells_0.111 VCO_MUX_0.VCO_sel 0.06854f
C863 VCO_decoder_cells_0.after_001111_n c0 0.01897f
C864 vco_core_2_0.nen11 vco_core_2_0.out 0.16619f
C865 vco_core_4_0.vco_delay_cell_4_0.up vco_core_4_0.pgt 0.19866f
C866 a_19702_n7843# vco_core_3_0.vco_delay_cell_3_5.in 0.05782f
C867 VCO_decoder_cells_0.after_001111_n VP 0.6405f
C868 vco_core_3_0.vco_delay_cell_3_2.in vco_core_3_0.vco_delay_cell_3_1.in 0.16384f
C869 a_3531_n3074# a_3747_n3074# 0.01537f
C870 VCO_decoder_cells_0.VCO2_selection_0.NAND_3in_dek_1.a VCO_decoder_cells_0.VCO2_selection_0.NAND_3in_dek_1.y 0.42095f
C871 VCO_decoder_cells_0.VCO2_selection_0.NAND_4in_dek_0.d a_11212_n5894# 0.01165f
C872 a_9777_n5420# VCO_decoder_cells_0.f5_n 0.01091f
C873 m2_4965_n6706# VCO_decoder_cells_0.VCO_selection_0.NAND_3in_dek_0.c 0.01019f
C874 VCO_decoder_cells_0.110 m2_4850_n1101# 0.0959f
C875 a_19702_n7843# a_19702_n6301# 0.01952f
C876 vco_core_0_0.out a_42501_n2018# 0.07779f
C877 vco_passgate_1.en_ NOR_2in$1_0.B 0.01017f
C878 a_30922_n5509# a_30922_n4047# 0.01952f
C879 VCO_decoder_cells_0.after_001111_n VCO_decoder_cells_0.row_section_decoding_0.NAND_2in_dek_0.b 0.13449f
C880 VCO_decoder_cells_0.after_000011 a_4246_1132# 0.04427f
C881 VCO_MUX_0.VCO_sel VCO_decoder_cells_0.after_000111 0.07629f
C882 a_45884_n1282# VP 2.71808f
C883 VCO_decoder_cells_0.111 VCO_decoder_cells_0.000 0.08448f
C884 VCO_decoder_cells_0.VCO2_selection_0.NAND_4in_dek_0.d a_9993_n5420# 0.04041f
C885 vco_core_3_0.out vco_core_3_0.vco_delay_cell_3_7.out 0.06333f
C886 a_34662_n5509# vco_passgate_1.OI 0.03815f
C887 VCO_decoder_cells_0.VCO2_5_sel vco_core_1_0.out 0.21369f
C888 VCO_decoder_cells_0.110 VCO_decoder_cells_0.3bit_to_8_outs_0.inverter_dek_1.in 0.28097f
C889 VCO_decoder_cells_0.100 VCO_decoder_cells_0.VCO3_selection_0.NAND_2in_dek_0.y 0.03692f
C890 vco_core_1_0.vco_delay_cell_1$1_1.out a_37196_1356# 0.09176f
C891 vco_core_2_0.nen5 vco_core_2_0.vco_delay_cell_2$6_0.pgt 0.39403f
C892 NOR_2in$1_0.A f0 0.05473f
C893 a_37381_7152# PFD_passgate_3.B 0.09528f
C894 VCO_decoder_cells_0.row_section_decoding_0.NAND_3in_dek_0.c f1 0.08253f
C895 PFD_passgate_3.B a_37381_6360# 0.09894f
C896 VCO_decoder_cells_0.VCO3_5_sel a_44190_7593# 0.02667f
C897 VCO_decoder_cells_0.101 VCO_decoder_cells_0.VCO3_selection_0.NAND_4in_dek_1.c 0.23445f
C898 m2_4640_n185# f4 0.01312f
C899 vco_core_4_0.vco_delay_cell_4_3.in vco_core_4_0.vco_delay_cell_4_4.in 0.11087f
C900 VCO_decoder_cells_0.after_000111 VCO_decoder_cells_0.000 0.17509f
C901 VP vco_core_1_0.vco_delay_cell_1$1_0.pgt 1.04369f
C902 VCO_decoder_cells_0.VCO3_selection_0.NAND_3in_dek_0.y a_11106_3010# 0.01058f
C903 VCO_decoder_cells_0.after_001111 VCO_decoder_cells_0.VCO3_selection_0.NAND_2in_dek_0.y 0.24697f
C904 VCO_MUX_0.VCO_sel VCO_decoder_cells_0.VCO_selection_0.NAND_3in_dek_0.b 0.41768f
C905 a_23442_n5509# vco_core_3_0.vco_delay_cell_3_5.in 0.10114f
C906 vco_core_3_0.vco_delay_cell_3_1.in a_38402_n6301# 0.05096f
C907 vco_passgate_4.OI PFD_passgate_3.B 1.00701f
C908 NOR_2in$1_0.A VCO_decoder_cells_0.VCO4_selection_0.NAND_3in_dek_1.y 0.08727f
C909 VCO_decoder_cells_0.VCO3_selection_0.NAND_3in_dek_4.b VP 0.34128f
C910 m2_50398_n1771# out 0.06678f
C911 vco_core_3_0.vco_delay_cell_3_1.in vco_core_3_0.vco_delay_cell_3_1.out 0.16488f
C912 VCO_MUX_0.passgate_scaled_2.en_ vco_passgate_1.en 0.34952f
C913 vco_core_4_0.vco_delay_cell_4_1.in vco_core_4_0.vco_delay_cell_4_1.up 0.08248f
C914 vco_core_3_0.vco_delay_cell_3_1.in vco_core_3_0.nen11 0.317f
C915 a_45132_n11460# VP 1.35308f
C916 VCO_decoder_cells_0.after_000111 VCO_decoder_cells_0.VCO3_selection_0.NAND_3in_dek_0.y 0.35071f
C917 a_11359_n3464# VCO_decoder_cells_0.VCO2_selection_0.NAND_4in_dek_1.d 0.01071f
C918 a_30922_n4047# vco_core_3_0.out 0.05572f
C919 f5 VCO_decoder_cells_0.after_001111_n 0.59304f
C920 VCO_decoder_cells_0.VCO4_selection_0.NAND_2in_dek_0.y m2_3226_n5537# 0.01141f
C921 VCO_decoder_cells_0.111 VCO_decoder_cells_0.VCO2_selection_0.NAND_4in_dek_0.d 0.22423f
C922 f0 VCO_decoder_cells_0.after_000011_n 0.04799f
C923 VCO_decoder_cells_0.VCO2_11_sel VCO_decoder_cells_0.VCO2_selection_0.inverter_dek_0.out 0.37134f
C924 VCO_decoder_cells_0.VCO3_11_sel vco_passgate_4.OI 0.65252f
C925 a_45282_n1282# a_45884_n1282# 0.92278f
C926 a_44680_n1157# VCO_MUX_0.VCO_sel 0.02015f
C927 VCO_decoder_cells_0.after_001111_n f3 0.05898f
C928 a_4361_n6871# a_4577_n6871# 0.01537f
C929 VCO_decoder_cells_0.f5_n a_9944_3010# 0.01052f
C930 vco_core_4_0.vco_delay_cell_4_4.dn vco_core_4_0.vco_delay_cell_4_4.up 0.03587f
C931 vco_core_1_0.out vco_core_1_0.vco_delay_cell_1$1_6.in 0.17865f
C932 vco_core_0_0.vco_delay_cell_0$1_0.pgt vco_core_0_0.vco_delay_cell_0$1_3.in 0.07604f
C933 a_27182_n5509# a_27182_n4047# 0.01952f
C934 VCO_decoder_cells_0.VCO2_5_sel vco_core_1_0.nen11 0.03397f
C935 vco_passgate_1.OI a_34662_n6301# 0.03946f
C936 c1 VCO_decoder_cells_0.3bit_to_8_outs_0.NAND_3in_dek_6.y 0.34309f
C937 vco_core_1_0.vco_delay_cell_1$1_4.in a_40664_1356# 0.11019f
C938 NOR_2in$1_0.A m2_3226_n5455# 0.05713f
C939 VCO_decoder_cells_0.VCO2_selection_0.NAND_4in_dek_0.d VCO_decoder_cells_0.after_000111 0.46594f
C940 VCO_decoder_cells_0.VCO4_selection_0.NAND_3in_dek_1.y VCO_decoder_cells_0.after_000011_n 0.13109f
C941 vco_core_2_0.nen11 vco_core_2_0.vco_delay_cell_2$6_0.pgt 0.23188f
C942 vco_passgate_3.OI VCO_MUX_0.VCO2_sel 1.80737f
C943 VCO_decoder_cells_0.VCO3_11_sel VCO_decoder_cells_0.VCO3_selection_0.NAND_4in_dek_0.b 0.54024f
C944 NOR_2in$1_0.A vco_core_3_0.vco_delay_cell_3_5.in 0.31645f
C945 a_14717_n4830# VP 0.04522f
C946 VCO_decoder_cells_0.after_001111 VCO_decoder_cells_0.VCO_selection_0.NAND_3in_dek_0.a 0.0105f
C947 VCO_MUX_0.VCO3_sel vco_passgate_1.en 0.23865f
C948 vco_passgate_1.OI a_39218_n4047# 0.39086f
C949 vco_core_0_0.vp vco_core_1_0.vco_delay_cell_1$1_0.pgt 0.02928f
C950 a_23442_n5509# PFD_passgate_1.B 0.22557f
C951 m2_4702_n5455# VCO_decoder_cells_0.after_000111_n 0.09983f
C952 VCO_decoder_cells_0.after_000011 VCO_decoder_cells_0.f5_n 0.84124f
C953 VCO_decoder_cells_0.010 NOR_2in$1_0.B 0.07268f
C954 VCO_decoder_cells_0.011 VCO_decoder_cells_0.VCO4_selection_0.NAND_4in_dek_0.d 0.28756f
C955 f2 VCO_decoder_cells_0.011 0.06251f
C956 vco_in VCO_MUX_0.VCO2_sel 0.15873f
C957 VCO_decoder_cells_0.f5_n VCO_decoder_cells_0.VCO2_selection_0.NAND_3in_dek_0.y 0.39327f
C958 VCO_decoder_cells_0.010 VCO_decoder_cells_0.101 0.22403f
C959 VCO_decoder_cells_0.011 VCO_decoder_cells_0.100 7.56694f
C960 VCO_decoder_cells_0.VCO3_selection_0.NAND_4in_dek_0.b VCO_decoder_cells_0.VCO3_selection_0.NAND_4in_dek_0.c 0.25954f
C961 VCO_decoder_cells_0.011 VCO_decoder_cells_0.000000 0.65301f
C962 a_4269_n5362# VCO_decoder_cells_0.after_000111_n 0.01524f
C963 vco_core_4_0.vco_delay_cell_4_10.out vco_core_4_0.vco_delay_cell_4_8.up 0.08248f
C964 VCO_decoder_cells_0.VCO3_selection_0.NAND_3in_dek_3.y a_10160_n428# 0.04041f
C965 VCO_decoder_cells_0.after_000111_n a_9777_n3938# 0.01171f
C966 VCO_decoder_cells_0.VCO3_selection_0.NAND_3in_dek_4.b f5 0.44337f
C967 vco_core_1_0.vco_delay_cell_1$1_0.in vco_core_1_0.vco_delay_cell_1$1_0.pgt 0.59556f
C968 a_10624_1528# a_10840_1528# 0.01537f
C969 inverter_x1_2.OUT vco_in 0.06863f
C970 VCO_decoder_cells_0.011 VCO_decoder_cells_0.after_001111 0.53335f
C971 vco_core_2_0.out vco_core_2_0.vco_delay_cell_2$6_5.out 0.12978f
C972 VCO_decoder_cells_0.000000_n a_10624_1528# 0.03036f
C973 vco_passgate_1.OI vco_core_3_0.vco_delay_cell_3_5.in 2.85595f
C974 a_23442_n4047# vco_core_3_0.out 0.05979f
C975 vco_passgate_4.OI vco_core_2_0.vco_delay_cell_2$6_6.out 1.19283f
C976 vco_passgate_3.OI vco_core_1_0.vco_delay_cell_1$1_1.out 0.82277f
C977 VCO_decoder_cells_0.VCO3_selection_0.NAND_4in_dek_0.b VCO_decoder_cells_0.after_000011_n 0.07867f
C978 vco_core_1_0.nen11 vco_core_1_0.vco_delay_cell_1$1_6.in 0.02615f
C979 inverter_x1_12.IN VCO_MUX_0.VCO2_sel 0.07709f
C980 NOR_2in$1_0.A NOR_2in$1_0.Out 0.21935f
C981 VCO_decoder_cells_0.VCO3_selection_0.NAND_4in_dek_1.d VCO_decoder_cells_0.VCO3_selection_0.NAND_4in_dek_1.a 0.02181f
C982 m2_9698_n7271# VCO_decoder_cells_0.after_000011_n 0.04473f
C983 VCO_decoder_cells_0.3bit_to_8_outs_0.c0_n VCO_decoder_cells_0.3bit_to_8_outs_0.inverter_dek_10.in 0.25962f
C984 vco_passgate_1.OI a_19702_n6301# 0.07098f
C985 NOR_2in$1_0.A PFD_passgate_1.B 3.55868f
C986 VCO_decoder_cells_0.VCO3_selection_0.inverter_dek_0.out VCO_decoder_cells_0.VCO3_selection_0.NAND_4in_dek_1.c 0.03762f
C987 a_41750_1826# vco_core_1_0.vco_delay_cell_1$1_0.pgt 0.01718f
C988 a_10160_n902# VCO_decoder_cells_0.VCO3_selection_0.NAND_3in_dek_4.b 0.04031f
C989 f4 VCO_decoder_cells_0.000000_n 0.16965f
C990 VCO_decoder_cells_0.VCO3_selection_0.NAND_4in_dek_0.b a_10160_1528# 0.03929f
C991 vco_core_2_0.vco_delay_cell_2$6_0.pgt vco_core_2_0.vco_delay_cell_2$6_0.in 0.13434f
C992 PFD_passgate_3.in_p PFD_passgate_3.B 0.19442f
C993 VCO_decoder_cells_0.after_000111_n VCO_decoder_cells_0.011 0.58521f
C994 NOR_2in$1_1.Out VCO_MUX_0.VCO3_sel 0.08116f
C995 a_11310_n428# a_11526_n428# 0.01537f
C996 VCO_MUX_0.VCO2_in out 0.33545f
C997 vco_passgate_0.OI vco_core_4_0.vco_delay_cell_4_9.up 0.61027f
C998 VCO_decoder_cells_0.VCO3_selection_0.NAND_4in_dek_1.d VCO_decoder_cells_0.VCO3_selection_0.NAND_4in_dek_1.b 0.13482f
C999 a_44530_n11335# a_45132_n11460# 0.55039f
C1000 PFD_passgate_1.B a_23442_n6301# 0.23521f
C1001 VCO_MUX_0.passgate_scaled_0.en_ inverter_x1_2.IN 0.34739f
C1002 VCO_decoder_cells_0.VCO3_5_sel VP 1.80293f
C1003 vco_passgate_3.OI vco_core_1_0.vco_delay_cell_1$1_2.out 0.62263f
C1004 a_4506_2110# a_4722_2110# 0.01537f
C1005 a_41750_1826# vco_core_1_0.vco_delay_cell_1$1_3.out 0.08852f
C1006 vco_core_0_0.out VCO_MUX_0.VCO_sel 0.02089f
C1007 a_42005_8614# vco_passgate_4.OI 0.21516f
C1008 vco_core_4_0.vco_delay_cell_4_0.dn vco_core_4_0.vco_delay_cell_4_0.up 0.03587f
C1009 vco_core_0_0.vco_delay_cell_0$1_3.in a_42501_n2486# 0.12322f
C1010 a_3084_n350# a_3300_n350# 0.01537f
C1011 VCO_decoder_cells_0.110 VCO_decoder_cells_0.011 0.59226f
C1012 a_39508_3420# vco_core_1_0.out 0.06797f
C1013 a_11212_n5894# a_11428_n5894# 0.01537f
C1014 vco_core_4_0.vco_delay_cell_4_2.up vco_passgate_0.OI 0.61251f
C1015 f4 VCO_decoder_cells_0.001 0.05903f
C1016 vco_passgate_1.OI PFD_passgate_1.B 2.75376f
C1017 VCO_decoder_cells_0.row_section_decoding_0.NAND_3in_dek_0.b m2_4640_n185# 0.15697f
C1018 a_5000_n4888# a_4784_n4888# 0.01537f
C1019 a_38402_n7843# vco_core_3_0.vco_delay_cell_3_0.pgt 0.25491f
C1020 VCO_decoder_cells_0.VCO3_11_sel vco_core_2_0.vco_delay_cell_2$6_0.out 0.05583f
C1021 a_3770_154# f2 0.03128f
C1022 m2_10650_n7353# VCO_decoder_cells_0.VCO5_selection_0.NAND_2in_dek_0.a 0.21717f
C1023 vco_core_4_0.vco_delay_cell_4_8.dn vco_core_4_0.pgt 0.02009f
C1024 VCO_decoder_cells_0.VCO4_selection_0.NAND_3in_dek_1.y VCO_decoder_cells_0.VCO4_selection_0.NAND_4in_dek_0.b 0.76403f
C1025 vco_core_0_0.vco_delay_cell_0$1_0.pgt a_41855_n486# 0.12984f
C1026 PFD_passgate_1.B vco_core_3_0.vco_delay_cell_3_4.in 0.58284f
C1027 m2_5122_n2745# VCO_decoder_cells_0.011 0.09563f
C1028 VCO_decoder_cells_0.3bit_to_8_outs_0.inverter_dek_8.in VCO_decoder_cells_0.3bit_to_8_outs_0.inverter_dek_10.in 0.12853f
C1029 VP VCO_decoder_cells_0.VCO2_selection_0.inverter_dek_0.out 0.49174f
C1030 VCO_decoder_cells_0.VCO3_selection_0.NAND_4in_dek_1.d a_11094_n428# 0.03758f
C1031 VCO_MUX_0.VCO_sel f2 0.05386f
C1032 VCO_decoder_cells_0.011 VCO_decoder_cells_0.VCO2_selection_0.NAND_3in_dek_1.a 0.1436f
C1033 vco_core_4_0.vco_delay_cell_4_9.out vco_core_4_0.pgt 0.96495f
C1034 VCO_decoder_cells_0.VCO2_selection_0.NAND_3in_dek_2.y NOR_2in$1_0.B 0.02117f
C1035 VCO_MUX_0.VCO_sel VCO_decoder_cells_0.100 0.08244f
C1036 VCO_MUX_0.VCO_sel VCO_decoder_cells_0.000000 0.06221f
C1037 VCO_decoder_cells_0.after_000011 f0 0.04983f
C1038 VCO_decoder_cells_0.111 VCO_decoder_cells_0.000000_n 6.71849f
C1039 VCO_MUX_0.VCO3_in VCO_MUX_0.VCO2_in 1.92638f
C1040 VCO_decoder_cells_0.VCO2_5_sel vco_core_1_0.vco_delay_cell_1$1_0.pgt 0.52308f
C1041 vco_core_2_0.nen5 VP 0.05064f
C1042 VCO_decoder_cells_0.VCO2_selection_0.NAND_3in_dek_2.y VCO_decoder_cells_0.101 0.29162f
C1043 a_46598_6964# VP 2.8605f
C1044 vco_core_2_0.vco_delay_cell_2$6_5.out vco_core_2_0.vco_delay_cell_2$6_0.pgt 0.24721f
C1045 vco_core_2_0.vco_delay_cell_2$6_0.pgt a_38741_4818# 0.12615f
C1046 NOR_2in$1_0.A VCO_decoder_cells_0.after_001111_n 0.07922f
C1047 a_4246_154# f1 0.03649f
C1048 a_37194_1826# vco_core_1_0.vco_delay_cell_1$1_1.out 0.08216f
C1049 vco_in vco_passgate_0.OI 0.03897f
C1050 VCO_decoder_cells_0.VCO3_selection_0.NAND_4in_dek_0.c a_11094_1054# 0.01412f
C1051 VCO_decoder_cells_0.VCO4_selection_0.NAND_3in_dek_0.y VCO_decoder_cells_0.VCO4_selection_0.NAND_4in_dek_0.d 0.86172f
C1052 a_45943_n5690# 0_buf_0.out 1.51066f
C1053 PFD_passgate_0.B vco_core_4_0.vco_delay_cell_4_4.dn 0.12091f
C1054 a_41821_n2018# vco_core_0_0.vco_delay_cell_0$1_3.in 0.06851f
C1055 VCO_MUX_0.VCO_sel VCO_decoder_cells_0.after_001111 0.06626f
C1056 f2 VCO_decoder_cells_0.000 0.04803f
C1057 VCO_decoder_cells_0.VCO2_selection_0.NAND_4in_dek_0.a VCO_decoder_cells_0.VCO2_selection_0.NAND_2in_dek_0.y 0.41308f
C1058 VCO_decoder_cells_0.after_000011 VCO_decoder_cells_0.VCO4_selection_0.NAND_3in_dek_1.y 0.8311f
C1059 VCO_decoder_cells_0.000000 VCO_decoder_cells_0.VCO4_selection_0.NAND_3in_dek_0.y 0.41436f
C1060 VCO_decoder_cells_0.after_000111 VCO_decoder_cells_0.000000_n 0.30747f
C1061 VCO_decoder_cells_0.row_section_decoding_0.NAND_3in_dek_0.c a_4246_154# 0.04544f
C1062 a_4053_n5362# VCO_decoder_cells_0.VCO4_selection_0.NAND_4in_dek_0.b 0.03944f
C1063 VCO_decoder_cells_0.100 VCO_decoder_cells_0.000 0.31413f
C1064 vco_core_1_0.vco_delay_cell_1$1_7.in vco_core_1_0.vco_delay_cell_1$1_0.pgt 0.33104f
C1065 VCO_decoder_cells_0.000000 VCO_decoder_cells_0.000 0.22105f
C1066 vco_core_2_0.vco_delay_cell_2$6_9.out PFD_passgate_3.B 0.01579f
C1067 VCO_decoder_cells_0.VCO3_selection_0.NAND_4in_dek_0.d VCO_decoder_cells_0.100 0.21794f
C1068 VCO_MUX_0.passgate_scaled_0.en_ VP 0.3903f
C1069 VCO_decoder_cells_0.111 m2_4965_n6788# 0.01725f
C1070 VCO_decoder_cells_0.000000 VCO_decoder_cells_0.VCO3_selection_0.NAND_4in_dek_0.d 0.25386f
C1071 vco_passgate_3.OI a_37196_1356# 0.19055f
C1072 vco_core_3_0.vco_delay_cell_3_0.pgt vco_core_3_0.vco_delay_cell_3_7.out 0.02151f
C1073 vco_core_2_0.vco_delay_cell_2$6_2.in vco_core_2_0.vco_delay_cell_2$6_1.in 0.27102f
C1074 f4 VP 0.63871f
C1075 VCO_decoder_cells_0.111 VCO_decoder_cells_0.001 0.07151f
C1076 VCO_decoder_cells_0.011 VCO_decoder_cells_0.3bit_to_8_outs_0.NAND_3in_dek_2.y 0.02922f
C1077 VCO_MUX_0.VCO_sel VCO_decoder_cells_0.after_000111_n 0.0653f
C1078 a_4506_2110# VP 0.05475f
C1079 VCO_decoder_cells_0.after_001111 VCO_decoder_cells_0.000 0.48322f
C1080 VCO_decoder_cells_0.after_001111_n VCO_decoder_cells_0.after_000011_n 0.30412f
C1081 NOR_2in$1_0.B VCO_decoder_cells_0.101 0.11615f
C1082 vco_core_2_0.vco_delay_cell_2$6_9.out VCO_decoder_cells_0.VCO3_11_sel 0.01475f
C1083 vco_core_2_0.vco_delay_cell_2$6_5.in a_38741_7152# 0.04639f
C1084 a_9944_n428# VCO_decoder_cells_0.000000 0.01106f
C1085 VCO_decoder_cells_0.row_section_decoding_0.NAND_2in_dek_0.b f4 0.1347f
C1086 vco_core_1_0.vco_delay_cell_1$1_5.in vco_core_1_0.out 0.47775f
C1087 vco_core_1_0.vco_delay_cell_1$1_0.pgt vco_core_1_0.vco_delay_cell_1$1_6.in 0.2113f
C1088 NOR_2in$1_0.B vco_core_3_0.vco_delay_cell_3_8.in 0.17061f
C1089 VCO_decoder_cells_0.after_000111 VCO_decoder_cells_0.001 0.95836f
C1090 vco_core_4_0.vco_delay_cell_4_8.out vco_core_4_0.vco_delay_cell_4_7.out 0.11087f
C1091 VCO_MUX_0.VCO_sel vco_passgate_1.en 0.19285f
C1092 vco_core_2_0.nen11 VP 0.07345f
C1093 VCO_decoder_cells_0.VCO3_selection_0.NAND_3in_dek_0.y VCO_decoder_cells_0.after_001111 0.41908f
C1094 VCO_decoder_cells_0.110 VCO_MUX_0.VCO_sel 0.09682f
C1095 VCO_decoder_cells_0.after_000111_n VCO_decoder_cells_0.000 0.10045f
C1096 VCO_decoder_cells_0.VCO3_selection_0.NAND_4in_dek_0.b VCO_decoder_cells_0.after_000011 0.32466f
C1097 a_40662_1826# vco_core_1_0.vco_delay_cell_1$1_4.in 0.08419f
C1098 vco_passgate_3.OI a_37196_3420# 0.18946f
C1099 vco_core_1_0.vco_delay_cell_1$1_0.out vco_core_1_0.vco_delay_cell_1$1_1.out 0.32125f
C1100 a_11359_n3464# VCO_decoder_cells_0.VCO2_11_sel 0.04651f
C1101 VCO_decoder_cells_0.VCO2_selection_0.NAND_4in_dek_0.d VCO_decoder_cells_0.100 0.05217f
C1102 PFD_passgate_4.B a_38350_2990# 0.18219f
C1103 VCO_decoder_cells_0.000000_n VCO_decoder_cells_0.VCO3_selection_0.NAND_4in_dek_1.b 0.32763f
C1104 vco_core_3_0.vco_delay_cell_3_0.pgt a_30922_n4047# 0.25216f
C1105 vco_core_4_0.vco_delay_cell_4_7.dn PFD_passgate_0.B 0.12651f
C1106 vco_core_4_0.vco_delay_cell_4_10.out PFD_passgate_0.B 0.64466f
C1107 VP a_40664_3420# 0.01069f
C1108 vco_core_4_0.vco_delay_cell_4_7.out vco_core_4_0.vco_delay_cell_4_6.dn 0.0652f
C1109 a_10253_n7436# VCO_decoder_cells_0.000000 0.02888f
C1110 VCO_decoder_cells_0.row_section_decoding_0.NAND_3in_dek_0.b VCO_decoder_cells_0.000000_n 0.39028f
C1111 VCO_decoder_cells_0.VCO2_selection_0.NAND_3in_dek_1.b VCO_decoder_cells_0.VCO2_selection_0.NAND_3in_dek_0.y 0.17088f
C1112 m2_4965_n6788# VCO_decoder_cells_0.VCO_selection_0.NAND_3in_dek_0.b 0.05881f
C1113 a_39218_n5509# NOR_2in$1_0.B 0.08473f
C1114 VCO_decoder_cells_0.010 VCO_decoder_cells_0.011 10.4343f
C1115 VCO_decoder_cells_0.after_000111 a_10692_n5420# 0.01191f
C1116 vco_passgate_4.OI a_37381_4818# 0.24133f
C1117 a_37381_8614# vco_core_2_0.vco_delay_cell_2$6_5.in 0.01238f
C1118 VCO_decoder_cells_0.110 VCO_decoder_cells_0.000 0.12359f
C1119 VCO_decoder_cells_0.001 VCO_decoder_cells_0.VCO_selection_0.NAND_3in_dek_0.b 0.01816f
C1120 f1 VCO_decoder_cells_0.f5_n 0.0269f
C1121 VCO_decoder_cells_0.VCO3_selection_0.NAND_4in_dek_1.d VCO_decoder_cells_0.000000 0.23671f
C1122 a_43760_3221# a_44362_3221# 0.37543f
C1123 vco_core_3_0.nen5 NOR_2in$1_0.B 0.16166f
C1124 a_11106_3010# VCO_decoder_cells_0.VCO3_selection_0.NAND_2in_dek_1.y 0.04346f
C1125 m2_11231_1611# VCO_decoder_cells_0.000000 0.05245f
C1126 vco_core_4_0.vco_delay_cell_4_5.dn vco_passgate_0.OI 0.05179f
C1127 vco_core_4_0.vco_delay_cell_4_9.dn vco_passgate_0.OI 0.05179f
C1128 VCO_decoder_cells_0.VCO3_selection_0.NAND_3in_dek_4.a VCO_decoder_cells_0.VCO3_selection_0.NAND_4in_dek_1.d 0.01546f
C1129 a_11111_n902# VCO_decoder_cells_0.VCO3_selection_0.NAND_3in_dek_3.y 0.01661f
C1130 f5 f4 9.55798f
C1131 VCO_MUX_0.VCO_sel VCO_decoder_cells_0.VCO5_selection_0.NAND_2in_dek_0.a 0.01252f
C1132 VCO_decoder_cells_0.111 VP 1.0865f
C1133 VCO_decoder_cells_0.VCO2_selection_0.NAND_4in_dek_0.d VCO_decoder_cells_0.after_000111_n 0.28501f
C1134 a_43760_3221# VP 0.79812f
C1135 f4 f3 7.3101f
C1136 vco_core_1_0.vco_delay_cell_1$1_5.in vco_core_1_0.nen11 0.06538f
C1137 0_buf_1.out vco_passgate_1.en 0.07606f
C1138 VCO_decoder_cells_0.VCO2_selection_0.NAND_4in_dek_0.d VCO_decoder_cells_0.VCO2_selection_0.NAND_4in_dek_0.b 0.12828f
C1139 a_39508_1356# vco_core_1_0.vco_delay_cell_1$1_0.pgt 0.19842f
C1140 VCO_decoder_cells_0.3bit_to_8_outs_0.inverter_dek_1.in m2_4850_n1101# 0.11606f
C1141 VCO_decoder_cells_0.VCO3_5_sel VCO_decoder_cells_0.VCO2_5_sel 0.07444f
C1142 vco_passgate_3.OI vco_core_1_0.vco_delay_cell_1$1_6.out 0.22293f
C1143 c0 VCO_decoder_cells_0.after_000111 0.02161f
C1144 a_3634_n4888# a_3850_n4888# 0.01537f
C1145 VCO_decoder_cells_0.after_000111 VP 1.13625f
C1146 vco_core_1_0.vco_delay_cell_1$1_2.in vco_core_1_0.vco_delay_cell_1$1_2.out 0.32016f
C1147 VCO_decoder_cells_0.VCO5_selection_0.NAND_2in_dek_0.a VCO_decoder_cells_0.000 0.21295f
C1148 a_30922_n7843# a_30922_n6301# 0.01952f
C1149 PFD_passgate_4.B a_38350_1826# 0.1911f
C1150 VCO_MUX_0.VCO3_sel a_46168_2592# 0.07068f
C1151 vco_core_4_0.vco_delay_cell_4_8.out vco_passgate_0.OI 4.40002f
C1152 vco_core_3_0.vco_delay_cell_3_0.pgt a_23442_n4047# 0.2833f
C1153 vco_core_2_0.vco_delay_cell_2$6_6.in a_40101_7152# 0.06305f
C1154 a_4211_n3392# VCO_decoder_cells_0.3bit_to_8_outs_0.c2_n 0.01054f
C1155 VCO_decoder_cells_0.VCO3_5_sel PFD_passgate_3.B 1.23671f
C1156 c2 c0 0.39549f
C1157 vco_core_4_0.vco_delay_cell_4_4.in vco_core_4_0.pgt 0.96674f
C1158 a_3510_2110# VP 0.0693f
C1159 c2 VP 0.40507f
C1160 vco_passgate_3.OI vco_in 0.03867f
C1161 m2_11027_2917# VCO_decoder_cells_0.VCO3_selection_0.NAND_2in_dek_0.y 0.01411f
C1162 vco_core_3_0.nen11 NOR_2in$1_0.B 0.05512f
C1163 vco_core_1_0.vco_delay_cell_1$1_0.pgt a_39508_3420# 0.18377f
C1164 VCO_decoder_cells_0.VCO3_selection_0.NAND_4in_dek_1.d VCO_decoder_cells_0.110 0.28764f
C1165 vco_core_4_0.vco_delay_cell_4_6.dn vco_passgate_0.OI 0.05179f
C1166 VCO_decoder_cells_0.VCO3_selection_0.inverter_dek_0.out VCO_decoder_cells_0.101 0.011f
C1167 m2_11351_n2321# VCO_decoder_cells_0.VCO2_selection_0.NAND_3in_dek_1.y 0.12029f
C1168 vco_passgate_1.OI a_38402_n7843# 0.40519f
C1169 VCO_decoder_cells_0.VCO3_selection_0.NAND_4in_dek_1.a VP 0.29321f
C1170 VP VCO_decoder_cells_0.VCO_selection_0.NAND_3in_dek_0.b 0.33018f
C1171 VCO_decoder_cells_0.VCO3_5_sel VCO_decoder_cells_0.VCO3_11_sel 2.1903f
C1172 a_40101_8614# vco_core_2_0.out 0.06874f
C1173 vco_core_3_0.out vco_core_3_0.vco_delay_cell_3_7.in 0.20776f
C1174 VCO_decoder_cells_0.VCO2_selection_0.NAND_3in_dek_1.a a_10738_n1982# 0.0102f
C1175 VCO_decoder_cells_0.111 f5 2.91518f
C1176 m2_3889_793# VCO_decoder_cells_0.after_000011_n 0.11753f
C1177 VP VCO_decoder_cells_0.VCO3_selection_0.NAND_4in_dek_1.b 0.66981f
C1178 vco_core_1_0.vco_delay_cell_1$1_0.out a_37196_1356# 0.11032f
C1179 vco_core_2_0.vco_delay_cell_2$6_4.out vco_core_2_0.vco_delay_cell_2$6_5.in 0.27104f
C1180 NOR_2in$1_0.A vco_core_3_0.vco_delay_cell_3_7.out 0.03472f
C1181 VCO_decoder_cells_0.row_section_decoding_0.NAND_3in_dek_0.b VP 0.23472f
C1182 vco_core_2_0.vco_delay_cell_2$6_0.in a_40101_4818# 0.01238f
C1183 vco_core_4_0.vco_delay_cell_4_9.dn vco_core_4_0.vco_delay_cell_4_9.up 0.03587f
C1184 VCO_MUX_0.inverter_dek_0.out VCO_MUX_0.VCO2_in 0.05084f
C1185 VCO_decoder_cells_0.111 f3 0.06074f
C1186 a_44680_n1157# VP 0.79545f
C1187 VCO_MUX_0.VCO_sel VCO_decoder_cells_0.010 0.07692f
C1188 a_34662_n4047# vco_core_3_0.vco_delay_cell_3_7.in 0.0657f
C1189 VCO_decoder_cells_0.after_001111_n VCO_decoder_cells_0.after_000011 0.80969f
C1190 a_30922_n7843# vco_core_3_0.vco_delay_cell_3_3.in 0.06619f
C1191 a_27182_n5509# vco_passgate_1.OI 0.03777f
C1192 f5 VCO_decoder_cells_0.after_000111 1.13983f
C1193 c0 VCO_decoder_cells_0.3bit_to_8_outs_0.inverter_dek_6.in 0.25953f
C1194 vco_in inverter_x1_12.IN 0.10076f
C1195 VCO_decoder_cells_0.111 VCO_decoder_cells_0.3bit_to_8_outs_0.NAND_3in_dek_0.y 0.24089f
C1196 vco_core_2_0.vco_delay_cell_2$6_8.in vco_passgate_4.OI 1.73058f
C1197 VP VCO_decoder_cells_0.3bit_to_8_outs_0.inverter_dek_6.in 0.36497f
C1198 PFD_passgate_3.B a_34661_6360# 0.09013f
C1199 f0 f1 6.86686f
C1200 f3 VCO_decoder_cells_0.after_000111 0.03994f
C1201 VCO_decoder_cells_0.VCO3_selection_0.NAND_4in_dek_1.d VCO_decoder_cells_0.VCO3_selection_0.NAND_4in_dek_1.c 0.6133f
C1202 VCO_MUX_0.VCO2_sel vco_core_1_0.nen11 0.02273f
C1203 VCO_decoder_cells_0.010 VCO_decoder_cells_0.VCO4_selection_0.NAND_3in_dek_0.y 0.23396f
C1204 vco_core_3_0.nen11 vco_core_3_0.nen5 0.07546f
C1205 VCO_decoder_cells_0.010 VCO_decoder_cells_0.000 0.65656f
C1206 f2 VCO_decoder_cells_0.000000_n 0.05187f
C1207 VCO_decoder_cells_0.VCO3_selection_0.NAND_3in_dek_3.y VCO_decoder_cells_0.after_001111_n 0.28531f
C1208 VCO_decoder_cells_0.row_section_decoding_0.NAND_3in_dek_0.c f0 0.31826f
C1209 VCO_decoder_cells_0.000000_n VCO_decoder_cells_0.100 3.9327f
C1210 vco_passgate_1.OI vco_core_3_0.vco_delay_cell_3_7.out 0.6168f
C1211 VCO_decoder_cells_0.000000_n VCO_decoder_cells_0.000000 2.27874f
C1212 vco_passgate_3.OI a_37194_1826# 0.02393f
C1213 vco_core_1_0.out vco_core_1_0.vco_delay_cell_1$1_2.out 0.17911f
C1214 vco_core_0_0.vco_delay_cell_0$1_0.pgt vco_core_0_0.vco_delay_cell_0$1_2.in 0.07815f
C1215 a_10927_n3464# VCO_decoder_cells_0.VCO2_selection_0.NAND_4in_dek_1.d 0.03758f
C1216 VCO_decoder_cells_0.VCO4_selection_0.NAND_2in_dek_0.y m2_3226_n5455# 0.01039f
C1217 VCO_decoder_cells_0.010 VCO_decoder_cells_0.VCO3_selection_0.NAND_3in_dek_0.y 0.01572f
C1218 VCO_decoder_cells_0.011 NOR_2in$1_0.B 0.07466f
C1219 VCO_MUX_0.passgate_scaled_0.en_ out 0.16547f
C1220 a_42467_n486# VP 0.01383f
C1221 VCO_decoder_cells_0.3bit_to_8_outs_0.NAND_3in_dek_0.y c2 1.10471f
C1222 VCO_decoder_cells_0.000000_n VCO_decoder_cells_0.after_001111 0.18243f
C1223 vco_core_4_0.vco_delay_cell_4_8.dn vco_core_4_0.vco_delay_cell_4_8.up 0.03587f
C1224 a_44680_n1157# a_45282_n1282# 0.55039f
C1225 m2_50398_n2585# out 0.06678f
C1226 VCO_MUX_0.VCO3_sel VCO_MUX_0.passgate_scaled_2.en_ 0.11717f
C1227 VCO_decoder_cells_0.011 VCO_decoder_cells_0.101 0.15598f
C1228 a_40662_2990# vco_core_1_0.vco_delay_cell_1$1_0.in 0.06387f
C1229 VCO_MUX_0.VCO2_in VCO_MUX_0.VCO2_sel 0.29304f
C1230 a_39506_2990# vco_core_1_0.vco_delay_cell_1$1_0.pgt 0.02264f
C1231 VCO_decoder_cells_0.row_section_decoding_0.NAND_3in_dek_0.b f5 0.2068f
C1232 a_37196_3420# vco_core_1_0.vco_delay_cell_1$1_2.in 0.08272f
C1233 a_5000_n4888# VCO_decoder_cells_0.000000_n 0.01052f
C1234 a_23442_n5509# a_23442_n4047# 0.01952f
C1235 vco_core_1_0.vco_delay_cell_1$1_5.in vco_core_1_0.vco_delay_cell_1$1_0.pgt 0.0983f
C1236 vco_passgate_1.OI a_27182_n6301# 0.03842f
C1237 f2 VCO_decoder_cells_0.001 0.05922f
C1238 VCO_decoder_cells_0.VCO2_11_sel vco_passgate_1.en 0.61426f
C1239 VCO_decoder_cells_0.after_001111_n VCO_decoder_cells_0.VCO2_selection_0.NAND_4in_dek_0.a 0.32405f
C1240 a_40101_8614# vco_core_2_0.vco_delay_cell_2$6_0.pgt 0.12196f
C1241 VCO_decoder_cells_0.100 VCO_decoder_cells_0.001 0.18786f
C1242 vco_core_3_0.nen11 a_38402_n6301# 0.01596f
C1243 VCO_decoder_cells_0.000000 VCO_decoder_cells_0.001 2.66885f
C1244 NOR_2in$1_0.A f4 0.05848f
C1245 vco_core_2_0.nen11 PFD_passgate_3.B 0.17342f
C1246 VCO_decoder_cells_0.row_section_decoding_0.NAND_3in_dek_0.b f3 0.03046f
C1247 VCO_MUX_0.VCO_in VCO_MUX_0.VCO2_in 0.03269f
C1248 a_45996_6964# a_46598_6964# 0.92278f
C1249 vco_passgate_1.OI a_30922_n4047# 0.40519f
C1250 VCO_decoder_cells_0.after_000111_n VCO_decoder_cells_0.000000_n 2.42511f
C1251 VCO_decoder_cells_0.3bit_to_8_outs_0.inverter_dek_10.in VCO_decoder_cells_0.3bit_to_8_outs_0.NAND_3in_dek_6.y 0.26874f
C1252 m2_11509_2835# VCO_decoder_cells_0.VCO3_selection_0.NAND_2in_dek_1.y 0.01141f
C1253 a_27182_n6301# vco_core_3_0.vco_delay_cell_3_4.in 0.05096f
C1254 VCO_decoder_cells_0.VCO3_selection_0.NAND_3in_dek_4.a VCO_decoder_cells_0.001 0.24573f
C1255 vco_core_3_0.vco_delay_cell_3_1.out vco_core_3_0.nen11 0.08365f
C1256 vco_core_0_0.vco_delay_cell_0$1_0.pgt vco_passgate_3.OI 0.02238f
C1257 VCO_decoder_cells_0.VCO2_selection_0.NAND_3in_dek_2.y VCO_decoder_cells_0.VCO2_selection_0.NAND_4in_dek_1.d 0.0811f
C1258 vco_core_1_0.vco_delay_cell_1$1_5.in vco_core_1_0.vco_delay_cell_1$1_3.out 0.27933f
C1259 VCO_decoder_cells_0.VCO3_selection_0.NAND_3in_dek_4.b VCO_decoder_cells_0.VCO3_selection_0.NAND_3in_dek_3.y 0.76585f
C1260 VCO_decoder_cells_0.001 VCO_decoder_cells_0.after_001111 0.32544f
C1261 vco_core_2_0.nen11 VCO_decoder_cells_0.VCO3_11_sel 0.62972f
C1262 vco_core_2_0.out vco_core_2_0.vco_delay_cell_2$6_5.in 0.12978f
C1263 a_46598_6964# VCO_MUX_0.VCO3_in 1.51703f
C1264 vco_passgate_3.OI vco_core_1_0.vco_delay_cell_1$1_0.out 0.69478f
C1265 vco_core_0_0.out VP 0.3984f
C1266 PFD_passgate_4.B PFD_passgate_4.in_p 0.2025f
C1267 VCO_decoder_cells_0.110 VCO_decoder_cells_0.000000_n 0.2135f
C1268 a_9944_n902# f5 0.01533f
C1269 a_43760_3221# VCO_decoder_cells_0.VCO2_5_sel 0.02832f
C1270 VCO_decoder_cells_0.row_section_decoding_0.NAND_3in_dek_0.b a_3084_n350# 0.02956f
C1271 PFD_passgate_4.B vco_core_1_0.vco_delay_cell_1$1_3.in 0.10131f
C1272 a_42467_n486# vco_core_0_0.vp 0.15553f
C1273 VCO_decoder_cells_0.3bit_to_8_outs_0.NAND_3in_dek_0.y VCO_decoder_cells_0.3bit_to_8_outs_0.inverter_dek_6.in 0.12853f
C1274 vco_core_3_0.vco_delay_cell_3_5.in vco_core_3_0.vco_delay_cell_3_5.out 0.16626f
C1275 vco_core_2_0.vco_delay_cell_2$6_0.pgt vco_core_2_0.vco_delay_cell_2$6_1.in 0.32772f
C1276 f4 VCO_decoder_cells_0.after_000011_n 0.04146f
C1277 vco_passgate_4.OI a_40101_7152# 0.01208f
C1278 VCO_decoder_cells_0.after_000111_n VCO_decoder_cells_0.001 0.56352f
C1279 VCO_decoder_cells_0.000000_n a_9944_1528# 0.0105f
C1280 vco_passgate_4.OI a_40101_6360# 0.01208f
C1281 VCO_decoder_cells_0.VCO2_selection_0.inverter_dek_0.out VCO_decoder_cells_0.VCO2_selection_0.NAND_4in_dek_1.c 0.02631f
C1282 a_40664_3420# vco_core_1_0.vco_delay_cell_1$1_6.in 0.10901f
C1283 inverter_x1_2.IN vco_passgate_1.en 0.04214f
C1284 vco_core_4_0.vco_delay_cell_4_1.up vco_passgate_0.OI 0.61166f
C1285 VCO_decoder_cells_0.100 VCO_decoder_cells_0.VCO3_selection_0.NAND_2in_dek_1.y 0.02262f
C1286 VCO_MUX_0.VCO3_sel PFD_passgate_4.B 0.01753f
C1287 a_4784_n5362# VCO_decoder_cells_0.VCO4_selection_0.NAND_3in_dek_1.y 0.04037f
C1288 VCO_decoder_cells_0.110 m2_4965_n6788# 0.01068f
C1289 a_39506_1826# vco_core_1_0.vco_delay_cell_1$1_0.pgt 0.02985f
C1290 a_44137_n5061# VP 0.75513f
C1291 a_9944_n902# a_10160_n902# 0.01537f
C1292 vco_passgate_3.OI vco_core_1_0.vco_delay_cell_1$1_2.in 0.76782f
C1293 vco_core_0_0.in vco_core_0_0.out 0.16351f
C1294 vco_core_2_0.vco_delay_cell_2$6_6.in a_34661_4818# 0.05569f
C1295 vco_core_2_0.vco_delay_cell_2$6_8.in vco_core_2_0.vco_delay_cell_2$6_0.out 0.25657f
C1296 PFD_passgate_3.B vco_core_2_0.vco_delay_cell_2$6_0.in 0.16586f
C1297 m2_4164_957# VCO_decoder_cells_0.row_section_decoding_0.NAND_2in_dek_0.b 0.25201f
C1298 VCO_decoder_cells_0.VCO3_selection_0.inverter_dek_1.in m2_11724_n1077# 0.0115f
C1299 VCO_decoder_cells_0.3bit_to_8_outs_0.c0_n c2 2.61125f
C1300 c0 VCO_decoder_cells_0.VCO4_selection_0.NAND_4in_dek_0.d 0.01282f
C1301 vco_core_4_0.vco_delay_cell_4_10.dn vco_core_4_0.pgt 0.02009f
C1302 a_42005_8614# vco_core_2_0.nen5 0.07115f
C1303 VCO_decoder_cells_0.VCO4_selection_0.NAND_4in_dek_0.d a_3850_n4888# 0.03576f
C1304 VCO_decoder_cells_0.110 VCO_decoder_cells_0.001 0.12997f
C1305 a_11094_n428# a_11310_n428# 0.01537f
C1306 VP VCO_decoder_cells_0.VCO4_selection_0.NAND_4in_dek_0.d 0.25876f
C1307 f2 VP 0.92868f
C1308 m2_3889_793# VCO_decoder_cells_0.after_000011 0.11888f
C1309 c0 VCO_decoder_cells_0.000000 0.02387f
C1310 VCO_decoder_cells_0.100 VP 2.00496f
C1311 VCO_decoder_cells_0.VCO2_selection_0.NAND_4in_dek_0.b a_10692_n5420# 0.0394f
C1312 VCO_decoder_cells_0.000000 VP 0.75798f
C1313 vco_passgate_1.OI a_23442_n4047# 0.40529f
C1314 VCO_decoder_cells_0.111 NOR_2in$1_0.A 0.08224f
C1315 VCO_decoder_cells_0.VCO3_11_sel vco_core_2_0.vco_delay_cell_2$6_0.in 0.12636f
C1316 VCO_MUX_0.VCO_sel a_44078_n653# 0.01927f
C1317 a_45884_n1282# VCO_MUX_0.VCO_in 1.5029f
C1318 m2_3226_n5455# m2_3226_n5537# 0.08407f
C1319 VCO_decoder_cells_0.VCO3_selection_0.NAND_3in_dek_4.a VP 0.33597f
C1320 vco_core_0_0.out vco_core_0_0.vp 0.48949f
C1321 a_38741_8614# vco_passgate_4.OI 0.24133f
C1322 VCO_decoder_cells_0.row_section_decoding_0.NAND_2in_dek_0.b f2 0.01465f
C1323 a_38741_6360# vco_core_2_0.vco_delay_cell_2$6_2.in 0.04737f
C1324 VCO_MUX_0.VCO_sel NOR_2in$1_0.B 0.06445f
C1325 a_43928_n10831# VP 0.74128f
C1326 c0 VCO_decoder_cells_0.after_001111 0.02067f
C1327 a_39218_n4047# vco_core_3_0.vco_delay_cell_3_0.in 0.06863f
C1328 a_37196_3420# vco_core_1_0.out 0.18762f
C1329 VCO_MUX_0.VCO2_sel vco_core_1_0.vco_delay_cell_1$1_0.pgt 0.02224f
C1330 a_10996_n5894# a_11212_n5894# 0.01537f
C1331 PFD_passgate_1.B vco_core_3_0.vco_delay_cell_3_5.out 0.56995f
C1332 VP VCO_decoder_cells_0.after_001111 0.60942f
C1333 VCO_MUX_0.VCO_sel VCO_decoder_cells_0.101 0.05674f
C1334 NOR_2in$1_0.A VCO_decoder_cells_0.after_000111 0.13249f
C1335 VCO_decoder_cells_0.3bit_to_8_outs_0.c0_n VCO_decoder_cells_0.row_section_decoding_0.NAND_3in_dek_0.b 0.03951f
C1336 a_30922_n7843# vco_core_3_0.vco_delay_cell_3_0.pgt 0.26202f
C1337 VCO_decoder_cells_0.VCO5_selection_0.NAND_2in_dek_0.a inverter_x1_2.IN 0.35572f
C1338 VCO_decoder_cells_0.001 VCO_decoder_cells_0.VCO2_selection_0.NAND_3in_dek_1.a 0.01714f
C1339 vco_core_0_0.vco_delay_cell_0$1_1.in vco_core_0_0.vco_delay_cell_0$1_0.in 0.25002f
C1340 vco_core_4_0.vco_delay_cell_4_2.dn vco_core_4_0.vco_delay_cell_4_2.in 0.0652f
C1341 vco_core_4_0.vco_delay_cell_4_0.out vco_core_4_0.pgt 1.1032f
C1342 NOR_2in$1_0.B VCO_decoder_cells_0.VCO4_selection_0.NAND_3in_dek_0.y 0.51708f
C1343 VCO_decoder_cells_0.after_000111_n c0 0.01966f
C1344 NOR_2in$1_0.B VCO_decoder_cells_0.000 0.06011f
C1345 VCO_decoder_cells_0.111 VCO_decoder_cells_0.after_000011_n 0.58687f
C1346 VCO_decoder_cells_0.after_000111_n VP 1.11271f
C1347 vco_core_2_0.vco_delay_cell_2$6_5.in vco_core_2_0.vco_delay_cell_2$6_0.pgt 0.34811f
C1348 VCO_decoder_cells_0.3bit_to_8_outs_0.c0_n VCO_decoder_cells_0.3bit_to_8_outs_0.inverter_dek_6.in 0.27048f
C1349 VP VCO_decoder_cells_0.row_section_decoding_0.NAND_2in_dek_0.a 0.25959f
C1350 VCO_decoder_cells_0.101 VCO_decoder_cells_0.000 0.13175f
C1351 VCO_decoder_cells_0.VCO2_selection_0.NAND_4in_dek_0.b VP 0.36603f
C1352 a_37194_1826# vco_core_1_0.vco_delay_cell_1$1_0.out 0.08429f
C1353 VCO_decoder_cells_0.VCO3_selection_0.NAND_4in_dek_0.d VCO_decoder_cells_0.101 0.06932f
C1354 a_9777_n5420# a_9993_n5420# 0.01537f
C1355 a_41821_n2018# vco_core_0_0.vco_delay_cell_0$1_2.in 0.11652f
C1356 m2_11027_2917# VCO_decoder_cells_0.VCO3_selection_0.NAND_3in_dek_0.y 0.21721f
C1357 VCO_decoder_cells_0.row_section_decoding_0.NAND_2in_dek_0.b VCO_decoder_cells_0.after_000111_n 0.26063f
C1358 VCO_decoder_cells_0.row_section_decoding_0.NAND_2in_dek_0.b VCO_decoder_cells_0.row_section_decoding_0.NAND_2in_dek_0.a 0.48962f
C1359 f5 f2 0.56376f
C1360 vco_core_1_0.vco_delay_cell_1$1_1.out vco_core_1_0.vco_delay_cell_1$1_0.pgt 0.30631f
C1361 a_45394_7089# VP 0.81588f
C1362 c0 VCO_decoder_cells_0.3bit_to_8_outs_0.c1_n 1.48402f
C1363 VP vco_passgate_1.en 1.33909f
C1364 VCO_decoder_cells_0.after_000111 VCO_decoder_cells_0.after_000011_n 0.57353f
C1365 vco_core_2_0.vco_delay_cell_2$6_0.pgt a_36021_4818# 0.12537f
C1366 vco_core_2_0.vco_delay_cell_2$6_9.out vco_core_2_0.vco_delay_cell_2$6_8.in 0.36005f
C1367 vco_core_2_0.vco_delay_cell_2$6_5.out PFD_passgate_3.B 0.13296f
C1368 VCO_decoder_cells_0.110 VP 1.22598f
C1369 f5 VCO_decoder_cells_0.100 0.49371f
C1370 VP VCO_decoder_cells_0.3bit_to_8_outs_0.c1_n 0.46417f
C1371 f5 VCO_decoder_cells_0.000000 0.28579f
C1372 VCO_decoder_cells_0.after_001111_n f1 0.05479f
C1373 vco_core_3_0.vco_delay_cell_3_0.pgt vco_core_3_0.vco_delay_cell_3_7.in 0.59557f
C1374 a_40662_2990# vco_core_1_0.vco_delay_cell_1$1_6.in 0.0826f
C1375 f3 f2 7.91903f
C1376 vco_core_1_0.vco_delay_cell_1$1_6.out vco_core_1_0.out 0.14856f
C1377 VCO_decoder_cells_0.VCO3_selection_0.NAND_3in_dek_4.a f5 0.24512f
C1378 VCO_decoder_cells_0.VCO2_selection_0.NAND_3in_dek_0.y VCO_decoder_cells_0.VCO2_selection_0.inverter_dek_0.out 0.25437f
C1379 VCO_decoder_cells_0.3bit_to_8_outs_0.NAND_3in_dek_2.y VCO_decoder_cells_0.001 0.28097f
C1380 f3 VCO_decoder_cells_0.100 0.03494f
C1381 f3 VCO_decoder_cells_0.000000 0.04457f
C1382 vco_core_4_0.pgt vco_core_4_0.vco_delay_cell_4_6.up 0.21552f
C1383 vco_passgate_3.OI vco_core_1_0.out 1.28785f
C1384 f5 VCO_decoder_cells_0.after_001111 0.31216f
C1385 VCO_decoder_cells_0.010 VCO_decoder_cells_0.000000_n 2.8578f
C1386 VCO_decoder_cells_0.VCO2_selection_0.NAND_4in_dek_0.d NOR_2in$1_0.B 0.01148f
C1387 VCO_decoder_cells_0.3bit_to_8_outs_0.NAND_3in_dek_0.y f2 0.01527f
C1388 vco_passgate_4.OI vco_passgate_3.OI 0.87442f
C1389 PFD_passgate_0.B vco_core_4_0.vco_delay_cell_4_3.dn 0.12091f
C1390 vco_core_4_0.vco_delay_cell_4_8.dn PFD_passgate_0.B 0.12651f
C1391 VCO_decoder_cells_0.VCO2_selection_0.NAND_4in_dek_0.d VCO_decoder_cells_0.101 0.22888f
C1392 NOR_2in$1_0.B vco_core_3_0.vco_delay_cell_3_9.in 0.18833f
C1393 vco_core_1_0.vco_delay_cell_1$1_0.pgt vco_core_1_0.vco_delay_cell_1$1_2.out 0.23467f
C1394 VCO_decoder_cells_0.111 VCO_decoder_cells_0.VCO2_selection_0.NAND_4in_dek_1.c 0.2388f
C1395 f3 VCO_decoder_cells_0.after_001111 0.04745f
C1396 vco_passgate_3.OI a_37194_2990# 0.01949f
C1397 m2_11351_n2075# VCO_decoder_cells_0.VCO2_selection_0.NAND_3in_dek_0.y 0.08407f
C1398 VP VCO_decoder_cells_0.VCO2_selection_0.NAND_3in_dek_1.a 0.3818f
C1399 vco_passgate_1.en_ VP 1.46892f
C1400 vco_core_3_0.vco_delay_cell_3_0.in PFD_passgate_1.B 0.54355f
C1401 vco_core_3_0.vco_delay_cell_3_1.in vco_core_3_0.vco_delay_cell_3_0.pgt 0.64244f
C1402 f5 VCO_decoder_cells_0.after_000111_n 0.85605f
C1403 vco_passgate_4.OI vco_in 0.01426f
C1404 vco_core_4_0.vco_delay_cell_4_4.in vco_core_4_0.vco_delay_cell_4_4.up 0.08248f
C1405 VCO_decoder_cells_0.VCO5_selection_0.NAND_2in_dek_0.a VP 0.29743f
C1406 VCO_decoder_cells_0.after_000011_n VCO_decoder_cells_0.VCO3_selection_0.NAND_4in_dek_1.b 0.10958f
C1407 vco_core_3_0.vco_delay_cell_3_9.in vco_core_3_0.vco_delay_cell_3_8.in 0.16384f
C1408 a_44530_n11335# a_43928_n10831# 0.48912f
C1409 vco_core_4_0.vco_delay_cell_4_9.out PFD_passgate_0.B 0.64466f
C1410 a_9944_3010# a_10160_3010# 0.01537f
C1411 vco_core_0_0.vp vco_passgate_1.en 0.50238f
C1412 vco_core_4_0.vco_delay_cell_4_4.dn vco_passgate_0.OI 0.05373f
C1413 VCO_decoder_cells_0.after_000011 f4 0.09244f
C1414 VP VCO_decoder_cells_0.VCO3_selection_0.NAND_4in_dek_1.c 0.66281f
C1415 VCO_decoder_cells_0.after_000111_n f3 0.25422f
C1416 NOR_2in$1_1.Out VP 0.44707f
C1417 f3 VCO_decoder_cells_0.row_section_decoding_0.NAND_2in_dek_0.a 0.40795f
C1418 VCO_decoder_cells_0.010 VCO_decoder_cells_0.001 7.25445f
C1419 VCO_MUX_0.VCO_sel PFD_passgate_2.in_p 0.12895f
C1420 a_37381_8614# vco_core_2_0.vco_delay_cell_2$6_4.out 0.06327f
C1421 VCO_decoder_cells_0.110 f5 0.25093f
C1422 VP a_38352_3420# 0.01031f
C1423 vco_core_1_0.vco_delay_cell_1$1_6.out vco_core_1_0.nen11 0.18557f
C1424 vco_core_3_0.vco_delay_cell_3_0.pgt vco_passgate_1.en 0.15346f
C1425 VCO_MUX_0.VCO_sel VCO_MUX_0.VCO3_sel 0.10704f
C1426 m2_4965_n6706# VCO_decoder_cells_0.VCO_selection_0.NAND_3in_dek_0.b 0.14249f
C1427 vco_passgate_3.OI vco_core_1_0.nen11 0.80519f
C1428 m2_5122_n2087# VCO_decoder_cells_0.3bit_to_8_outs_0.inverter_dek_6.in 0.09561f
C1429 VCO_decoder_cells_0.110 f3 0.06192f
C1430 c0 VCO_decoder_cells_0.3bit_to_8_outs_0.NAND_3in_dek_2.y 0.36286f
C1431 VCO_MUX_0.VCO3_sel vco_core_1_0.nen5 0.11172f
C1432 vco_passgate_4.OI a_34661_4818# 0.27705f
C1433 VP VCO_decoder_cells_0.3bit_to_8_outs_0.NAND_3in_dek_2.y 0.44187f
C1434 VCO_decoder_cells_0.row_section_decoding_0.NAND_3in_dek_0.c a_3300_n350# 0.01013f
C1435 VCO_decoder_cells_0.000 VCO_decoder_cells_0.VCO3_selection_0.NAND_2in_dek_0.y 0.24804f
C1436 VCO_decoder_cells_0.VCO3_selection_0.inverter_dek_0.out VCO_decoder_cells_0.VCO3_selection_0.NAND_4in_dek_0.d 0.12721f
C1437 VCO_MUX_0.passgate_scaled_0.en_ VCO_MUX_0.inverter_dek_0.out 0.02344f
C1438 VCO_decoder_cells_0.110 VCO_decoder_cells_0.3bit_to_8_outs_0.NAND_3in_dek_0.y 0.3678f
C1439 a_30922_n5509# vco_core_3_0.vco_delay_cell_3_8.in 0.04645f
C1440 vco_core_2_0.vco_delay_cell_2$6_9.out a_40101_7152# 0.01171f
C1441 vco_core_2_0.vco_delay_cell_2$6_3.in a_36021_4818# 0.01238f
C1442 m2_4640_957# f2 0.01316f
C1443 VCO_decoder_cells_0.3bit_to_8_outs_0.c0_n f2 0.03691f
C1444 VCO_decoder_cells_0.VCO4_selection_0.NAND_4in_dek_0.b a_3634_n4888# 0.01057f
C1445 f0 VCO_decoder_cells_0.f5_n 0.03226f
C1446 VCO_decoder_cells_0.VCO2_selection_0.NAND_3in_dek_2.y VCO_decoder_cells_0.VCO2_11_sel 0.55422f
C1447 f5 VCO_decoder_cells_0.VCO2_selection_0.NAND_3in_dek_1.a 0.1687f
C1448 vco_core_0_0.vco_delay_cell_0$1_0.pgt a_42501_n2486# 0.11593f
C1449 vco_in PFD_passgate_1.B 0.33664f
C1450 vco_core_4_0.vco_delay_cell_4_7.dn vco_passgate_0.OI 0.05179f
C1451 a_37196_1356# vco_core_1_0.vco_delay_cell_1$1_0.pgt 0.19314f
C1452 vco_passgate_1.en_ vco_core_3_0.vco_delay_cell_3_0.pgt 0.01182f
C1453 VCO_decoder_cells_0.VCO3_selection_0.NAND_3in_dek_0.y VCO_decoder_cells_0.VCO3_selection_0.NAND_2in_dek_0.y 0.66079f
C1454 a_4211_n1430# VCO_decoder_cells_0.3bit_to_8_outs_0.NAND_3in_dek_0.y 0.01402f
C1455 vco_core_4_0.vco_delay_cell_4_10.out vco_passgate_0.OI 4.53822f
C1456 VCO_MUX_0.VCO_sel VCO_decoder_cells_0.VCO_selection_0.NAND_3in_dek_0.a 0.43387f
C1457 VCO_decoder_cells_0.VCO3_5_sel vco_core_2_0.vco_delay_cell_2$6_8.in 0.32998f
C1458 vco_core_4_0.vco_delay_cell_4_3.in vco_core_4_0.pgt 0.96674f
C1459 a_3418_n4888# a_3634_n4888# 0.01537f
C1460 m2_4702_n5455# VCO_decoder_cells_0.000 0.01001f
C1461 VCO_decoder_cells_0.111 VCO_decoder_cells_0.after_000011 1.733f
C1462 VCO_MUX_0.VCO3_sel 0_buf_1.out 0.04066f
C1463 NOR_2in$1_0.B vco_core_3_0.out 0.52555f
C1464 VCO_decoder_cells_0.010 VP 1.31241f
C1465 a_27182_n7843# a_27182_n6301# 0.01952f
C1466 PFD_passgate_4.B a_36106_1826# 0.19123f
C1467 VCO_MUX_0.VCO3_sel a_44964_2717# 0.01405f
C1468 a_41855_n914# vco_core_0_0.vco_delay_cell_0$1_0.in 0.11652f
C1469 vco_core_2_0.vco_delay_cell_2$6_6.in a_37381_7152# 0.06287f
C1470 vco_in PFD_passgate_3.in_p 0.04368f
C1471 vco_core_3_0.out vco_core_3_0.vco_delay_cell_3_8.in 0.20776f
C1472 VCO_decoder_cells_0.after_000011 VCO_decoder_cells_0.after_000111 0.34562f
C1473 vco_core_1_0.vco_delay_cell_1$1_0.pgt a_37196_3420# 0.18657f
C1474 VCO_MUX_0.VCO_sel VCO_decoder_cells_0.011 0.05387f
C1475 m2_4640_957# VCO_decoder_cells_0.row_section_decoding_0.NAND_2in_dek_0.a 0.14662f
C1476 c1 VCO_decoder_cells_0.3bit_to_8_outs_0.inverter_dek_10.in 0.41678f
C1477 a_11310_n428# VCO_decoder_cells_0.VCO3_selection_0.NAND_4in_dek_1.c 0.01209f
C1478 VCO_decoder_cells_0.VCO3_selection_0.NAND_3in_dek_4.b VCO_decoder_cells_0.VCO3_selection_0.inverter_dek_1.in 0.40929f
C1479 VCO_decoder_cells_0.after_000111 VCO_decoder_cells_0.VCO2_selection_0.NAND_3in_dek_0.y 0.3231f
C1480 vco_passgate_1.OI a_30922_n7843# 0.40519f
C1481 vco_core_2_0.vco_delay_cell_2$6_6.in vco_passgate_4.OI 1.45215f
C1482 VCO_MUX_0.passgate_scaled_0.en_ VCO_MUX_0.VCO2_sel 0.11721f
C1483 NOR_2in$1_0.A f2 0.05357f
C1484 NOR_2in$1_0.A vco_core_3_0.vco_delay_cell_3_7.in 0.0445f
C1485 vco_core_2_0.vco_delay_cell_2$6_1.in a_40101_4818# 0.06478f
C1486 VCO_decoder_cells_0.VCO2_selection_0.NAND_4in_dek_0.b VCO_decoder_cells_0.VCO2_5_sel 0.5221f
C1487 a_37381_8614# vco_core_2_0.out 0.06891f
C1488 NOR_2in$1_0.A VCO_decoder_cells_0.100 0.0863f
C1489 NOR_2in$1_0.A VCO_decoder_cells_0.000000 0.05814f
C1490 vco_core_4_0.vco_delay_cell_4_2.in vco_core_4_0.vco_delay_cell_4_3.in 0.11087f
C1491 vco_core_4_0.vco_delay_cell_4_0.in vco_core_4_0.vco_delay_cell_4_0.up 0.08233f
C1492 VCO_decoder_cells_0.011 VCO_decoder_cells_0.VCO4_selection_0.NAND_3in_dek_0.y 0.23901f
C1493 VP a_4722_628# 0.06931f
C1494 VCO_MUX_0.passgate_scaled_0.en_ VCO_MUX_0.VCO_in 0.01223f
C1495 VCO_decoder_cells_0.3bit_to_8_outs_0.c0_n VCO_decoder_cells_0.3bit_to_8_outs_0.c1_n 3.57634f
C1496 VCO_decoder_cells_0.011 VCO_decoder_cells_0.000 0.25829f
C1497 VCO_decoder_cells_0.VCO3_selection_0.NAND_3in_dek_3.y VCO_decoder_cells_0.after_000111 0.39182f
C1498 VCO_decoder_cells_0.000000_n NOR_2in$1_0.B 0.07959f
C1499 a_4722_154# VP 0.06931f
C1500 VCO_decoder_cells_0.VCO3_selection_0.NAND_4in_dek_0.c VCO_decoder_cells_0.100 0.10008f
C1501 VCO_decoder_cells_0.VCO3_selection_0.NAND_4in_dek_0.c VCO_decoder_cells_0.000000 0.24492f
C1502 NOR_2in$1_0.A VCO_decoder_cells_0.after_001111 0.05607f
C1503 VCO_decoder_cells_0.000000_n VCO_decoder_cells_0.101 0.15391f
C1504 0_buf_1.in vco_core_4_0.vco_delay_cell_4_4.in 0.11087f
C1505 vco_core_3_0.nen5 vco_core_3_0.out 0.38454f
C1506 c0 VCO_decoder_cells_0.3bit_to_8_outs_0.c2_n 0.69276f
C1507 VCO_decoder_cells_0.VCO4_selection_0.NAND_4in_dek_0.d VCO_decoder_cells_0.after_000011_n 0.02957f
C1508 f2 VCO_decoder_cells_0.after_000011_n 0.04403f
C1509 NOR_2in$1_0.A vco_core_3_0.vco_delay_cell_3_1.in 0.21708f
C1510 f5 VCO_decoder_cells_0.010 0.88906f
C1511 VP VCO_decoder_cells_0.3bit_to_8_outs_0.c2_n 0.45928f
C1512 vco_passgate_1.OI vco_core_3_0.vco_delay_cell_3_7.in 2.77927f
C1513 VCO_decoder_cells_0.100 VCO_decoder_cells_0.after_000011_n 0.22407f
C1514 a_3747_n3392# VCO_decoder_cells_0.3bit_to_8_outs_0.inverter_dek_8.in 0.0504f
C1515 VCO_decoder_cells_0.000000 VCO_decoder_cells_0.after_000011_n 11.7407f
C1516 PFD_passgate_0.B vco_core_4_0.vco_delay_cell_4_4.in 0.64278f
C1517 NOR_2in$1_0.A VCO_decoder_cells_0.after_000111_n 0.12923f
C1518 vco_core_1_0.out vco_core_1_0.vco_delay_cell_1$1_2.in 0.50725f
C1519 m2_5122_n2087# VCO_decoder_cells_0.100 0.09563f
C1520 vco_core_1_0.vco_delay_cell_1$1_6.out vco_core_1_0.vco_delay_cell_1$1_0.pgt 0.11329f
C1521 NOR_2in$1_0.A VCO_decoder_cells_0.VCO2_selection_0.NAND_4in_dek_0.b 0.04328f
C1522 VCO_decoder_cells_0.VCO3_selection_0.NAND_3in_dek_3.y VCO_decoder_cells_0.VCO3_selection_0.NAND_4in_dek_1.a 0.01069f
C1523 VCO_decoder_cells_0.010 f3 0.04836f
C1524 out vco_passgate_1.en 0.08631f
C1525 NOR_2in$1_0.B VCO_decoder_cells_0.001 0.05879f
C1526 vco_core_2_0.vco_delay_cell_2$6_0.pgt VCO_MUX_0.VCO3_sel 0.04431f
C1527 vco_core_1_0.vco_delay_cell_1$1_4.in vco_core_1_0.vco_delay_cell_1$1_3.in 0.32178f
C1528 a_42005_7152# PFD_passgate_3.B 0.08683f
C1529 VCO_decoder_cells_0.after_000111 VCO_decoder_cells_0.VCO2_selection_0.NAND_4in_dek_0.a 0.47401f
C1530 vco_passgate_3.OI vco_core_1_0.vco_delay_cell_1$1_0.pgt 22.8166f
C1531 PFD_passgate_3.B a_41461_6360# 0.09279f
C1532 VCO_decoder_cells_0.101 VCO_decoder_cells_0.001 0.13481f
C1533 VCO_decoder_cells_0.after_000011_n VCO_decoder_cells_0.after_001111 0.44469f
C1534 VCO_decoder_cells_0.after_000111_n VCO_decoder_cells_0.VCO3_selection_0.NAND_4in_dek_0.c 0.44383f
C1535 vco_core_4_0.vco_delay_cell_4_3.dn vco_core_4_0.vco_delay_cell_4_3.up 0.03587f
C1536 VCO_decoder_cells_0.VCO4_selection_0.NAND_3in_dek_0.y a_4784_n4888# 0.0394f
C1537 a_10160_1054# VCO_decoder_cells_0.VCO3_selection_0.NAND_4in_dek_1.b 0.03924f
C1538 vco_core_4_0.vco_delay_cell_4_9.out vco_core_4_0.vco_delay_cell_4_10.up 0.08248f
C1539 VCO_decoder_cells_0.row_section_decoding_0.NAND_3in_dek_0.b VCO_decoder_cells_0.row_section_decoding_0.NAND_3in_dek_0.a 0.5636f
C1540 a_37194_2990# vco_core_1_0.vco_delay_cell_1$1_2.in 0.07362f
C1541 NOR_2in$1_0.A vco_passgate_1.en 0.03443f
C1542 VCO_decoder_cells_0.VCO3_selection_0.NAND_3in_dek_3.y VCO_decoder_cells_0.VCO3_selection_0.NAND_4in_dek_1.b 0.04988f
C1543 NOR_2in$1_0.A VCO_decoder_cells_0.110 0.08426f
C1544 a_34662_n5509# vco_core_3_0.vco_delay_cell_3_5.in 0.10114f
C1545 vco_core_1_0.vco_delay_cell_1$1_7.in a_38352_1356# 0.09176f
C1546 VCO_decoder_cells_0.3bit_to_8_outs_0.inverter_dek_8.in VCO_decoder_cells_0.3bit_to_8_outs_0.c1_n 0.41685f
C1547 vco_core_2_0.nen11 vco_core_2_0.vco_delay_cell_2$6_8.in 0.10264f
C1548 VCO_decoder_cells_0.111 a_4571_n7189# 0.02873f
C1549 VCO_decoder_cells_0.VCO3_11_sel a_41461_6360# 0.04211f
C1550 vco_passgate_1.OI vco_core_3_0.vco_delay_cell_3_1.in 2.67133f
C1551 vco_passgate_3.OI vco_core_1_0.vco_delay_cell_1$1_3.out 0.21606f
C1552 VCO_decoder_cells_0.after_000111_n VCO_decoder_cells_0.after_000011_n 3.03877f
C1553 VP VCO_decoder_cells_0.VCO2_selection_0.NAND_3in_dek_2.y 0.38832f
C1554 a_38350_2990# vco_core_1_0.vco_delay_cell_1$1_0.in 0.06454f
C1555 vco_core_3_0.nen11 vco_core_3_0.out 0.09275f
C1556 vco_core_1_0.vco_delay_cell_1$1_3.in VCO_decoder_cells_0.VCO2_11_sel 0.07309f
C1557 f3 a_4722_628# 0.01488f
C1558 vco_core_3_0.vco_delay_cell_3_2.in vco_core_3_0.vco_delay_cell_3_3.in 0.16384f
C1559 a_37381_8614# vco_core_2_0.vco_delay_cell_2$6_0.pgt 0.12114f
C1560 VCO_decoder_cells_0.VCO3_selection_0.NAND_4in_dek_0.d a_11310_1054# 0.01047f
C1561 VCO_decoder_cells_0.100 VCO_decoder_cells_0.VCO2_selection_0.NAND_4in_dek_1.c 0.04774f
C1562 vco_core_2_0.out vco_core_2_0.vco_delay_cell_2$6_4.out 0.41796f
C1563 a_4571_n7189# VCO_decoder_cells_0.after_000111 0.01175f
C1564 a_45394_7089# a_45996_6964# 0.55039f
C1565 vco_core_0_0.vco_delay_cell_0$1_0.in VP 0.01011f
C1566 m2_11027_2917# VCO_decoder_cells_0.VCO3_selection_0.NAND_2in_dek_1.y 0.05931f
C1567 f4 f1 0.18518f
C1568 m2_4965_n6706# VCO_decoder_cells_0.after_001111 0.01109f
C1569 VCO_decoder_cells_0.VCO3_selection_0.inverter_dek_1.in VCO_decoder_cells_0.VCO3_5_sel 0.01117f
C1570 a_46168_2592# VP 2.81321f
C1571 VCO_decoder_cells_0.110 VCO_decoder_cells_0.after_000011_n 0.30227f
C1572 NOR_2in$1_0.A vco_passgate_1.en_ 0.0136f
C1573 vco_passgate_1.OI vco_passgate_1.en 3.34079f
C1574 vco_core_4_0.vco_delay_cell_4_0.up vco_passgate_0.OI 0.61015f
C1575 PFD_passgate_4.B vco_core_1_0.vco_delay_cell_1$1_4.in 0.12893f
C1576 a_3747_n1748# VCO_decoder_cells_0.3bit_to_8_outs_0.inverter_dek_6.in 0.0504f
C1577 vco_core_0_0.out vco_core_0_0.vco_delay_cell_0$1_3.in 0.25282f
C1578 a_3986_2110# f4 0.0306f
C1579 NOR_2in$1_0.A m2_3226_n5701# 0.09745f
C1580 vco_core_2_0.vco_delay_cell_2$6_0.pgt vco_core_2_0.vco_delay_cell_2$6_2.in 0.43391f
C1581 VP VCO_decoder_cells_0.VCO2_selection_0.NAND_3in_dek_1.y 0.49308f
C1582 VCO_decoder_cells_0.VCO3_11_sel VCO_decoder_cells_0.VCO3_selection_0.NAND_4in_dek_1.c 0.0605f
C1583 a_11143_n3464# a_11359_n3464# 0.01537f
C1584 VCO_decoder_cells_0.VCO3_11_sel NOR_2in$1_1.Out 0.14923f
C1585 VCO_MUX_0.VCO3_in vco_passgate_1.en 0.14201f
C1586 a_44078_n653# VP 0.74128f
C1587 c0 NOR_2in$1_0.B 0.0328f
C1588 VCO_MUX_0.VCO_sel VCO_decoder_cells_0.000 0.06844f
C1589 f5 a_9993_n5894# 0.01094f
C1590 VP NOR_2in$1_0.B 1.57868f
C1591 a_34662_n5509# PFD_passgate_1.B 0.22557f
C1592 vco_core_1_0.vco_delay_cell_1$1_3.in a_41752_1356# 0.11032f
C1593 VP VCO_decoder_cells_0.101 2.33084f
C1594 VCO_decoder_cells_0.3bit_to_8_outs_0.NAND_3in_dek_0.y VCO_decoder_cells_0.3bit_to_8_outs_0.c2_n 0.02316f
C1595 a_9944_1528# a_10160_1528# 0.01537f
C1596 VCO_decoder_cells_0.111 m2_5122_n1101# 0.09563f
C1597 vco_core_0_0.in vco_core_0_0.vco_delay_cell_0$1_0.in 0.08247f
C1598 PFD_passgate_3.B vco_core_2_0.vco_delay_cell_2$6_1.in 0.22454f
C1599 vco_passgate_4.OI a_37381_7152# 0.01208f
C1600 VCO_decoder_cells_0.after_000111_n VCO_decoder_cells_0.VCO2_selection_0.NAND_4in_dek_1.c 0.32885f
C1601 VCO_decoder_cells_0.VCO3_selection_0.NAND_4in_dek_0.c VCO_decoder_cells_0.VCO3_selection_0.NAND_4in_dek_1.c 0.05413f
C1602 a_9777_n5420# VCO_decoder_cells_0.after_000111_n 0.01052f
C1603 vco_passgate_4.OI a_37381_6360# 0.01208f
C1604 VCO_decoder_cells_0.after_001111_n VCO_decoder_cells_0.f5_n 10.0376f
C1605 vco_core_3_0.vco_delay_cell_3_7.out vco_core_3_0.vco_delay_cell_3_0.in 0.34959f
C1606 VCO_decoder_cells_0.VCO4_selection_0.NAND_4in_dek_0.b VCO_decoder_cells_0.VCO4_selection_0.NAND_4in_dek_0.d 0.05539f
C1607 PFD_passgate_4.B VCO_decoder_cells_0.VCO2_11_sel 0.93178f
C1608 VCO_decoder_cells_0.after_000111_n a_10673_n3938# 0.01187f
C1609 a_4211_n1430# a_4427_n1430# 0.01537f
C1610 vco_passgate_1.en_ vco_passgate_1.OI 0.2302f
C1611 a_4053_n5362# VCO_decoder_cells_0.VCO4_selection_0.NAND_3in_dek_1.y 0.01168f
C1612 VCO_decoder_cells_0.110 m2_4965_n6706# 0.04473f
C1613 VCO_decoder_cells_0.VCO5_selection_0.NAND_2in_dek_0.a VCO_decoder_cells_0.after_000011_n 0.16775f
C1614 a_37194_1826# vco_core_1_0.vco_delay_cell_1$1_0.pgt 0.02435f
C1615 VCO_decoder_cells_0.VCO3_11_sel vco_core_2_0.vco_delay_cell_2$6_1.in 0.04815f
C1616 vco_core_0_0.vco_delay_cell_0$1_0.in vco_core_0_0.vp 0.48529f
C1617 VCO_decoder_cells_0.3bit_to_8_outs_0.inverter_dek_8.in VCO_decoder_cells_0.3bit_to_8_outs_0.NAND_3in_dek_2.y 0.26874f
C1618 VCO_decoder_cells_0.VCO4_selection_0.NAND_4in_dek_0.d a_3418_n4888# 0.01071f
C1619 VCO_decoder_cells_0.after_000011_n VCO_decoder_cells_0.VCO3_selection_0.NAND_4in_dek_1.c 0.22102f
C1620 vco_core_3_0.nen11 inverter_x1_2.IN 0.01436f
C1621 VCO_decoder_cells_0.110 VCO_decoder_cells_0.VCO2_selection_0.NAND_4in_dek_1.c 0.23496f
C1622 a_37194_2990# vco_core_1_0.out 0.08207f
C1623 m2_4164_957# VCO_decoder_cells_0.after_000011 0.14307f
C1624 VCO_MUX_0.VCO3_sel inverter_x1_2.IN 0.31565f
C1625 VCO_decoder_cells_0.VCO3_selection_0.NAND_3in_dek_0.y VCO_decoder_cells_0.000 0.30477f
C1626 c2 VCO_decoder_cells_0.3bit_to_8_outs_0.NAND_3in_dek_3.y 0.28643f
C1627 VCO_decoder_cells_0.111 f1 0.06434f
C1628 VCO_decoder_cells_0.3bit_to_8_outs_0.inverter_dek_1.in VP 0.39586f
C1629 a_36021_8614# vco_passgate_4.OI 0.2056f
C1630 vco_core_0_0.vp NOR_2in$1_0.B 0.01437f
C1631 a_41855_n486# a_42467_n486# 0.01898f
C1632 VP vco_core_3_0.nen5 0.06327f
C1633 PFD_passgate_1.B a_34662_n6301# 0.23521f
C1634 VCO_decoder_cells_0.after_000011 f2 0.04441f
C1635 VCO_decoder_cells_0.after_000111_n VCO_decoder_cells_0.VCO4_selection_0.NAND_4in_dek_0.b 0.46352f
C1636 vco_core_2_0.vco_delay_cell_2$6_4.out vco_core_2_0.vco_delay_cell_2$6_0.pgt 0.32819f
C1637 f5 NOR_2in$1_0.B 0.08359f
C1638 vco_core_3_0.vco_delay_cell_3_5.in a_19702_n6301# 0.04376f
C1639 VCO_decoder_cells_0.after_000011 VCO_decoder_cells_0.100 0.12994f
C1640 vco_core_2_0.vco_delay_cell_2$6_9.out vco_core_2_0.vco_delay_cell_2$6_6.in 0.55816f
C1641 a_23442_n7843# vco_core_3_0.vco_delay_cell_3_0.pgt 0.28312f
C1642 VCO_decoder_cells_0.after_000011 VCO_decoder_cells_0.000000 0.22964f
C1643 vco_core_0_0.vco_delay_cell_0$1_0.pgt vco_core_1_0.vco_delay_cell_1$1_0.pgt 0.01221f
C1644 VCO_decoder_cells_0.VCO3_selection_0.NAND_3in_dek_4.b VCO_decoder_cells_0.f5_n 0.29464f
C1645 a_45734_n11460# 0_buf_1.out 1.51025f
C1646 VCO_decoder_cells_0.VCO3_5_sel vco_in 0.41259f
C1647 f5 VCO_decoder_cells_0.101 0.7761f
C1648 f1 VCO_decoder_cells_0.after_000111 0.03979f
C1649 NOR_2in$1_0.A VCO_decoder_cells_0.010 0.05392f
C1650 vco_core_3_0.vco_delay_cell_3_0.pgt NOR_2in$1_0.B 1.05144f
C1651 VCO_decoder_cells_0.100 VCO_decoder_cells_0.VCO2_selection_0.NAND_3in_dek_0.y 0.24529f
C1652 VCO_decoder_cells_0.VCO2_selection_0.NAND_3in_dek_1.a VCO_decoder_cells_0.VCO2_selection_0.NAND_4in_dek_1.c 0.01453f
C1653 vco_core_1_0.nen11 vco_core_1_0.out 0.06664f
C1654 f3 NOR_2in$1_0.B 0.05451f
C1655 f2 VCO_decoder_cells_0.row_section_decoding_0.NAND_3in_dek_0.a 0.17531f
C1656 a_4211_n3074# VCO_decoder_cells_0.3bit_to_8_outs_0.inverter_dek_10.in 0.01402f
C1657 f3 VCO_decoder_cells_0.101 0.04787f
C1658 vco_core_1_0.vco_delay_cell_1$1_0.out vco_core_1_0.vco_delay_cell_1$1_0.pgt 0.27187f
C1659 VP VCO_MUX_0.passgate_scaled_2.en_ 0.36362f
C1660 vco_core_4_0.pgt vco_core_4_0.vco_delay_cell_4_7.up 0.21552f
C1661 VCO_decoder_cells_0.after_000011 VCO_decoder_cells_0.after_001111 9.83764f
C1662 VCO_decoder_cells_0.3bit_to_8_outs_0.c0_n VCO_decoder_cells_0.3bit_to_8_outs_0.c2_n 1.12688f
C1663 vco_core_2_0.vco_delay_cell_2$6_5.in PFD_passgate_3.B 0.12406f
C1664 m2_10650_n7353# inverter_x1_2.IN 0.05882f
C1665 m2_4850_n3731# VCO_decoder_cells_0.3bit_to_8_outs_0.NAND_3in_dek_2.y 0.11606f
C1666 vco_core_3_0.vco_delay_cell_3_0.pgt vco_core_3_0.vco_delay_cell_3_8.in 0.75171f
C1667 VCO_decoder_cells_0.001 VCO_decoder_cells_0.VCO_selection_0.NAND_3in_dek_0.a 0.0159f
C1668 PFD_passgate_0.B vco_core_4_0.vco_delay_cell_4_2.dn 0.12091f
C1669 vco_core_2_0.vco_delay_cell_2$6_3.in vco_core_2_0.vco_delay_cell_2$6_2.in 0.27102f
C1670 VCO_decoder_cells_0.000000_n VCO_decoder_cells_0.011 0.20406f
C1671 PFD_passgate_4.in_p VP 1.45545f
C1672 VCO_decoder_cells_0.VCO3_selection_0.NAND_3in_dek_3.y VCO_decoder_cells_0.000000 0.15493f
C1673 vco_core_4_0.vco_delay_cell_4_10.dn PFD_passgate_0.B 0.12651f
C1674 VCO_decoder_cells_0.VCO3_selection_0.inverter_dek_0.out VCO_decoder_cells_0.VCO3_selection_0.NAND_2in_dek_1.y 0.26015f
C1675 m2_11231_1611# VCO_decoder_cells_0.VCO3_selection_0.NAND_4in_dek_0.d 0.05819f
C1676 VCO_decoder_cells_0.VCO3_selection_0.NAND_2in_dek_0.y VCO_decoder_cells_0.VCO3_selection_0.NAND_2in_dek_1.y 0.35282f
C1677 VCO_decoder_cells_0.3bit_to_8_outs_0.inverter_dek_6.in VCO_decoder_cells_0.3bit_to_8_outs_0.NAND_3in_dek_3.y 0.26874f
C1678 VCO_decoder_cells_0.VCO3_selection_0.NAND_3in_dek_4.a VCO_decoder_cells_0.VCO3_selection_0.NAND_3in_dek_3.y 0.17477f
C1679 VCO_MUX_0.VCO3_sel a_44362_3221# 0.01723f
C1680 a_10457_n3938# a_10673_n3938# 0.01537f
C1681 VCO_decoder_cells_0.row_section_decoding_0.NAND_3in_dek_0.a VCO_decoder_cells_0.after_001111 0.01847f
C1682 vco_core_3_0.vco_delay_cell_3_5.in PFD_passgate_1.B 3.73786f
C1683 vco_core_4_0.vco_delay_cell_4_5.up vco_core_4_0.pgt 0.1794f
C1684 VCO_decoder_cells_0.after_000111_n VCO_decoder_cells_0.after_000011 12.5879f
C1685 VCO_decoder_cells_0.010 VCO_decoder_cells_0.after_000011_n 1.96052f
C1686 VCO_decoder_cells_0.after_000011 VCO_decoder_cells_0.row_section_decoding_0.NAND_2in_dek_0.a 0.36368f
C1687 PFD_passgate_2.in_p VP 1.65721f
C1688 VCO_decoder_cells_0.VCO2_selection_0.NAND_4in_dek_0.b VCO_decoder_cells_0.after_000011 0.04072f
C1689 VCO_decoder_cells_0.after_000111_n VCO_decoder_cells_0.VCO2_selection_0.NAND_3in_dek_0.y 0.24842f
C1690 VCO_decoder_cells_0.VCO3_selection_0.inverter_dek_0.out VP 0.38516f
C1691 VP vco_core_3_0.nen11 0.07448f
C1692 vco_core_4_0.vco_delay_cell_4_8.out vco_core_4_0.vco_delay_cell_4_7.dn 0.0652f
C1693 VP VCO_decoder_cells_0.VCO3_selection_0.NAND_2in_dek_0.y 0.2966f
C1694 vco_core_1_0.vco_delay_cell_1$1_0.pgt vco_core_1_0.vco_delay_cell_1$1_2.in 0.21112f
C1695 a_39218_n5509# vco_core_3_0.vco_delay_cell_3_0.pgt 0.01612f
C1696 m2_50398_n2585# 0_buf_0.out 0.04414f
C1697 vco_core_4_0.vco_delay_cell_4_10.out vco_core_4_0.vco_delay_cell_4_8.out 0.11087f
C1698 PFD_passgate_1.B a_19702_n6301# 0.21773f
C1699 VCO_MUX_0.VCO3_sel VP 1.81932f
C1700 c2 a_3531_n1748# 0.01052f
C1701 VCO_decoder_cells_0.row_section_decoding_0.NAND_3in_dek_0.b f1 0.14745f
C1702 vco_passgate_4.OI PFD_passgate_3.in_p 0.24509f
C1703 VCO_decoder_cells_0.011 VCO_decoder_cells_0.001 2.6922f
C1704 vco_core_3_0.vco_delay_cell_3_2.in vco_core_3_0.vco_delay_cell_3_0.pgt 0.77704f
C1705 VCO_decoder_cells_0.after_001111_n f0 0.06478f
C1706 vco_core_3_0.vco_delay_cell_3_0.pgt vco_core_3_0.nen5 0.5167f
C1707 VCO_decoder_cells_0.110 VCO_decoder_cells_0.after_000011 0.12543f
C1708 VCO_decoder_cells_0.100 VCO_decoder_cells_0.VCO2_selection_0.NAND_4in_dek_0.a 0.35985f
C1709 vco_core_4_0.vco_delay_cell_4_0.out PFD_passgate_0.B 1.00182f
C1710 VCO_decoder_cells_0.VCO2_11_sel VCO_decoder_cells_0.VCO2_selection_0.NAND_4in_dek_1.d 0.11235f
C1711 a_10630_n428# VCO_decoder_cells_0.000000 0.02897f
C1712 VCO_decoder_cells_0.row_section_decoding_0.NAND_3in_dek_0.b VCO_decoder_cells_0.row_section_decoding_0.NAND_3in_dek_0.c 1.06099f
C1713 VCO_decoder_cells_0.3bit_to_8_outs_0.NAND_3in_dek_0.y VCO_decoder_cells_0.3bit_to_8_outs_0.inverter_dek_1.in 0.26874f
C1714 vco_core_0_0.in PFD_passgate_2.in_p 0.24308f
C1715 a_45341_n5690# VP 1.38394f
C1716 VCO_decoder_cells_0.3bit_to_8_outs_0.inverter_dek_8.in VCO_decoder_cells_0.3bit_to_8_outs_0.c2_n 1.10362f
C1717 a_38350_1826# vco_core_1_0.vco_delay_cell_1$1_7.in 0.08216f
C1718 vco_passgate_3.OI a_40664_1356# 0.17009f
C1719 vco_passgate_4.OI vco_core_2_0.vco_delay_cell_2$6_0.out 0.42887f
C1720 m2_11509_2917# m2_11509_2835# 0.08407f
C1721 VCO_decoder_cells_0.after_001111_n VCO_decoder_cells_0.VCO4_selection_0.NAND_3in_dek_1.y 0.29975f
C1722 PFD_passgate_4.B VP 0.46191f
C1723 VCO_decoder_cells_0.VCO3_selection_0.NAND_3in_dek_3.y VCO_decoder_cells_0.110 0.2176f
C1724 vco_core_2_0.out vco_core_2_0.vco_delay_cell_2$6_0.pgt 1.49944f
C1725 VP VCO_decoder_cells_0.VCO_selection_0.NAND_3in_dek_0.a 0.41308f
C1726 PFD_passgate_2.in_p vco_core_0_0.vp 0.18906f
C1727 m2_51016_n1607# VCO_MUX_0.passgate_scaled_1.en_ 0.08956f
C1728 VCO_MUX_0.VCO_sel VCO_decoder_cells_0.VCO2_11_sel 1.37545f
C1729 VCO_decoder_cells_0.VCO2_selection_0.NAND_3in_dek_1.a VCO_decoder_cells_0.VCO2_selection_0.NAND_3in_dek_0.y 0.39995f
C1730 a_10253_n1982# VCO_decoder_cells_0.VCO2_selection_0.NAND_3in_dek_1.b 0.04346f
C1731 vco_core_1_0.vco_delay_cell_1$1_6.out a_40664_3420# 0.0827f
C1732 vco_core_4_0.vco_delay_cell_4_3.dn vco_passgate_0.OI 0.05277f
C1733 VCO_decoder_cells_0.VCO2_selection_0.NAND_4in_dek_0.b VCO_decoder_cells_0.VCO2_selection_0.NAND_4in_dek_0.a 0.6006f
C1734 vco_core_0_0.in a_42501_n2018# 0.12756f
C1735 a_3531_n1748# VCO_decoder_cells_0.3bit_to_8_outs_0.inverter_dek_6.in 0.01962f
C1736 NOR_2in$1_0.B VCO_decoder_cells_0.VCO2_5_sel 0.03852f
C1737 vco_core_4_0.vco_delay_cell_4_8.dn vco_passgate_0.OI 0.05203f
C1738 vco_passgate_3.OI a_40664_3420# 0.15861f
C1739 vco_core_2_0.vco_delay_cell_2$6_5.out a_40101_7152# 0.04639f
C1740 VCO_decoder_cells_0.VCO3_5_sel vco_core_2_0.vco_delay_cell_2$6_6.in 0.2122f
C1741 VCO_decoder_cells_0.VCO3_selection_0.NAND_4in_dek_0.b a_11094_1054# 0.01152f
C1742 vco_core_3_0.vco_delay_cell_3_1.out vco_core_3_0.vco_delay_cell_3_0.pgt 0.01137f
C1743 vco_core_2_0.vco_delay_cell_2$6_6.out a_36021_4818# 0.06478f
C1744 PFD_passgate_4.B a_42226_2990# 0.17766f
C1745 vco_core_3_0.vco_delay_cell_3_0.pgt vco_core_3_0.nen11 0.66686f
C1746 VCO_decoder_cells_0.VCO3_selection_0.inverter_dek_1.in VCO_decoder_cells_0.VCO3_selection_0.NAND_4in_dek_1.a 0.28463f
C1747 VCO_decoder_cells_0.110 VCO_decoder_cells_0.VCO2_selection_0.NAND_4in_dek_0.a 0.23725f
C1748 a_10457_n3938# VCO_decoder_cells_0.VCO2_selection_0.NAND_3in_dek_0.y 0.01364f
C1749 VCO_MUX_0.VCO_sel VCO_decoder_cells_0.000000_n 0.05386f
C1750 VCO_decoder_cells_0.011 VP 1.82426f
C1751 vco_core_4_0.vco_delay_cell_4_9.out vco_passgate_0.OI 4.39691f
C1752 a_41750_1826# vco_core_1_0.vco_delay_cell_1$1_3.in 0.08414f
C1753 vco_passgate_4.OI a_41461_4818# 0.24368f
C1754 vco_core_3_0.vco_delay_cell_3_2.in a_34662_n7843# 0.06619f
C1755 vco_core_4_0.vco_delay_cell_4_2.in vco_core_4_0.pgt 0.96674f
C1756 a_43535_n5061# a_44137_n5061# 0.37543f
C1757 vco_core_1_0.vco_delay_cell_1$1_0.pgt vco_core_1_0.out 1.41371f
C1758 vco_core_1_0.vco_delay_cell_1$1_0.in a_36108_1356# 0.11189f
C1759 a_3531_n1430# VCO_decoder_cells_0.3bit_to_8_outs_0.NAND_3in_dek_0.y 0.01962f
C1760 VCO_decoder_cells_0.000000_n VCO_decoder_cells_0.VCO4_selection_0.NAND_3in_dek_0.y 0.29061f
C1761 vco_passgate_4.OI vco_core_1_0.vco_delay_cell_1$1_0.pgt 0.15584f
C1762 VCO_decoder_cells_0.VCO2_selection_0.NAND_3in_dek_2.y VCO_decoder_cells_0.after_000011_n 0.01003f
C1763 VCO_decoder_cells_0.3bit_to_8_outs_0.c0_n VCO_decoder_cells_0.3bit_to_8_outs_0.inverter_dek_1.in 0.36287f
C1764 a_41855_n914# vco_core_0_0.vco_delay_cell_0$1_1.in 0.06725f
C1765 vco_core_2_0.vco_delay_cell_2$6_9.out vco_passgate_4.OI 0.45567f
C1766 VCO_MUX_0.VCO_sel inverter_x1_2.IN 0.0187f
C1767 VCO_decoder_cells_0.000000_n VCO_decoder_cells_0.000 0.12728f
C1768 vco_core_2_0.out a_36021_7152# 0.0406f
C1769 a_38741_8614# vco_core_2_0.vco_delay_cell_2$6_5.out 0.01238f
C1770 NOR_2in$1_0.A NOR_2in$1_0.B 1.79043f
C1771 vco_core_2_0.out a_44190_7593# 0.2664f
C1772 VCO_decoder_cells_0.3bit_to_8_outs_0.inverter_dek_8.in NOR_2in$1_0.B 0.0155f
C1773 PFD_passgate_4.B vco_core_1_0.vco_delay_cell_1$1_0.in 1.2259f
C1774 NOR_2in$1_0.A VCO_decoder_cells_0.101 0.06085f
C1775 vco_core_3_0.out vco_core_3_0.vco_delay_cell_3_9.in 0.37921f
C1776 VCO_MUX_0.VCO_sel VCO_decoder_cells_0.001 0.07698f
C1777 a_37194_2990# vco_core_1_0.vco_delay_cell_1$1_0.pgt 0.02587f
C1778 a_23442_n7843# a_23442_n6301# 0.01952f
C1779 vco_core_0_0.vco_delay_cell_0$1_1.in a_41209_n2018# 0.12457f
C1780 VCO_decoder_cells_0.VCO5_selection_0.NAND_2in_dek_0.a VCO_decoder_cells_0.VCO2_selection_0.NAND_4in_dek_0.a 0.01609f
C1781 NOR_2in$1_0.A vco_core_3_0.vco_delay_cell_3_8.in 0.04454f
C1782 vco_core_2_0.vco_delay_cell_2$6_6.in a_34661_6360# 0.04966f
C1783 PFD_passgate_4.B a_41750_1826# 0.18108f
C1784 vco_core_1_0.nen5 a_42228_3420# 0.03634f
C1785 VCO_decoder_cells_0.001 VCO_decoder_cells_0.000 10.7991f
C1786 VCO_decoder_cells_0.VCO3_selection_0.NAND_3in_dek_4.b a_11111_n902# 0.03353f
C1787 a_10630_n902# VCO_decoder_cells_0.VCO3_selection_0.NAND_3in_dek_4.a 0.04346f
C1788 VCO_decoder_cells_0.after_000011 VCO_decoder_cells_0.010 0.67406f
C1789 vco_passgate_1.OI a_23442_n7843# 0.40529f
C1790 NOR_2in$1_0.B VCO_decoder_cells_0.after_000011_n 0.11455f
C1791 c2 c1 5.27378f
C1792 vco_core_4_0.vco_delay_cell_4_10.dn vco_core_4_0.vco_delay_cell_4_10.up 0.03587f
C1793 f5 VCO_decoder_cells_0.011 0.41686f
C1794 vco_passgate_1.OI NOR_2in$1_0.B 1.91741f
C1795 f2 f1 6.58131f
C1796 m2_11509_2671# VCO_decoder_cells_0.VCO3_selection_0.inverter_dek_0.out 0.0959f
C1797 a_43326_n10831# a_43928_n10831# 0.37543f
C1798 a_40662_2990# vco_core_1_0.vco_delay_cell_1$1_6.out 0.09024f
C1799 VCO_decoder_cells_0.after_000011_n VCO_decoder_cells_0.101 0.47886f
C1800 f4 VCO_decoder_cells_0.f5_n 0.05533f
C1801 PFD_passgate_4.in_p VCO_decoder_cells_0.VCO2_5_sel 0.02052f
C1802 vco_core_1_0.vco_delay_cell_1$1_0.pgt vco_core_1_0.nen11 0.81673f
C1803 f1 VCO_decoder_cells_0.100 0.03084f
C1804 f1 VCO_decoder_cells_0.000000 0.04438f
C1805 VP VCO_decoder_cells_0.VCO2_selection_0.NAND_4in_dek_1.d 0.26462f
C1806 VCO_decoder_cells_0.VCO2_selection_0.NAND_3in_dek_2.y VCO_decoder_cells_0.VCO2_selection_0.NAND_4in_dek_1.c 0.16546f
C1807 f3 VCO_decoder_cells_0.011 0.06222f
C1808 inverter_x1_2.IN 0_buf_1.out 2.51487f
C1809 VCO_decoder_cells_0.001 VCO_decoder_cells_0.VCO3_selection_0.NAND_3in_dek_0.y 0.23478f
C1810 NOR_2in$1_0.A vco_core_3_0.vco_delay_cell_3_2.in 0.03226f
C1811 VCO_decoder_cells_0.row_section_decoding_0.NAND_3in_dek_0.c f2 0.22405f
C1812 a_3770_154# VP 0.06931f
C1813 VCO_decoder_cells_0.VCO2_selection_0.NAND_3in_dek_2.y a_10673_n3938# 0.04038f
C1814 VP VCO_MUX_0.passgate_scaled_1.en_ 0.27941f
C1815 vco_passgate_1.OI vco_core_3_0.vco_delay_cell_3_8.in 2.68206f
C1816 PFD_passgate_0.B vco_core_4_0.vco_delay_cell_4_3.in 0.64278f
C1817 a_31345_3300# VP 0.04494f
C1818 f1 VCO_decoder_cells_0.after_001111 0.04707f
C1819 VCO_decoder_cells_0.VCO2_selection_0.NAND_4in_dek_0.d a_11428_n5894# 0.01077f
C1820 VCO_decoder_cells_0.3bit_to_8_outs_0.c1_n VCO_decoder_cells_0.3bit_to_8_outs_0.NAND_3in_dek_3.y 0.34306f
C1821 m2_4279_n6788# VCO_decoder_cells_0.VCO_selection_0.NAND_3in_dek_0.c 0.36407f
C1822 a_9993_n5420# VCO_decoder_cells_0.f5_n 0.01022f
C1823 out VCO_MUX_0.passgate_scaled_2.en_ 0.16529f
C1824 vco_core_1_0.vco_delay_cell_1$1_3.out vco_core_1_0.nen11 0.0715f
C1825 vco_core_2_0.vco_delay_cell_2$6_8.in a_42005_7152# 0.11295f
C1826 m2_4850_n2087# VCO_decoder_cells_0.3bit_to_8_outs_0.NAND_3in_dek_3.y 0.11606f
C1827 VCO_MUX_0.VCO3_sel VCO_decoder_cells_0.VCO2_5_sel 0.0225f
C1828 vco_core_2_0.nen11 vco_core_2_0.vco_delay_cell_2$6_6.in 0.03362f
C1829 a_3531_n3392# a_3747_n3392# 0.01537f
C1830 VCO_MUX_0.VCO_sel VP 1.85199f
C1831 a_39218_n5509# vco_passgate_1.OI 0.03787f
C1832 VCO_decoder_cells_0.after_000111_n f1 0.05737f
C1833 vco_core_1_0.nen5 VP 0.09373f
C1834 VCO_decoder_cells_0.VCO3_selection_0.NAND_4in_dek_0.d VCO_decoder_cells_0.VCO3_selection_0.NAND_2in_dek_1.y 0.01105f
C1835 VCO_decoder_cells_0.3bit_to_8_outs_0.NAND_3in_dek_2.y VCO_decoder_cells_0.3bit_to_8_outs_0.NAND_3in_dek_6.y 0.04432f
C1836 vco_core_2_0.vco_delay_cell_2$6_0.pgt a_36021_7152# 0.0421f
C1837 vco_core_1_0.vco_delay_cell_1$1_1.out a_38352_1356# 0.11019f
C1838 VCO_decoder_cells_0.after_000111 a_9777_n5894# 0.0125f
C1839 vco_core_4_0.pgt inverter_x1_2.IN 0.33435f
C1840 a_38741_7152# PFD_passgate_3.B 0.09418f
C1841 VCO_MUX_0.VCO3_sel PFD_passgate_3.B 0.03035f
C1842 vco_core_2_0.vco_delay_cell_2$6_0.out a_41461_4818# 0.01238f
C1843 vco_passgate_1.OI vco_core_3_0.vco_delay_cell_3_2.in 2.79027f
C1844 a_27182_n4047# vco_core_3_0.vco_delay_cell_3_9.in 0.0657f
C1845 PFD_passgate_3.B a_38741_6360# 0.09861f
C1846 vco_passgate_1.OI vco_core_3_0.nen5 0.832f
C1847 a_9944_1054# a_10160_1054# 0.01537f
C1848 VP VCO_decoder_cells_0.VCO4_selection_0.NAND_3in_dek_0.y 0.3899f
C1849 NOR_2in$1_0.A a_38402_n6301# 0.04964f
C1850 PFD_passgate_4.B VCO_decoder_cells_0.VCO2_5_sel 0.57949f
C1851 a_14717_n4830# NOR_2in$1_0.Out 0.03063f
C1852 VP VCO_decoder_cells_0.000 3.89088f
C1853 vco_core_1_0.vco_delay_cell_1$1_4.in VCO_decoder_cells_0.VCO2_11_sel 0.03096f
C1854 VCO_decoder_cells_0.VCO3_11_sel VCO_decoder_cells_0.VCO3_selection_0.inverter_dek_0.out 0.46898f
C1855 VCO_decoder_cells_0.VCO3_selection_0.NAND_4in_dek_0.d VP 0.26672f
C1856 VCO_MUX_0.VCO3_sel out 0.47929f
C1857 VCO_decoder_cells_0.VCO3_selection_0.NAND_3in_dek_0.y VCO_decoder_cells_0.VCO3_selection_0.NAND_2in_dek_1.y 0.32931f
C1858 a_4427_n1430# VCO_decoder_cells_0.3bit_to_8_outs_0.inverter_dek_1.in 0.04031f
C1859 a_27182_n5509# vco_core_3_0.vco_delay_cell_3_5.in 0.10114f
C1860 VCO_decoder_cells_0.110 f1 0.06066f
C1861 vco_core_0_0.in VCO_MUX_0.VCO_sel 0.02933f
C1862 NOR_2in$1_0.A vco_core_3_0.vco_delay_cell_3_1.out 0.07124f
C1863 VCO_decoder_cells_0.VCO3_11_sel VCO_MUX_0.VCO3_sel 0.03255f
C1864 VCO_decoder_cells_0.VCO3_5_sel vco_passgate_4.OI 0.70418f
C1865 NOR_2in$1_0.A vco_core_3_0.nen11 0.6439f
C1866 VCO_decoder_cells_0.111 VCO_decoder_cells_0.f5_n 0.23777f
C1867 a_44362_3221# a_44964_2717# 0.48912f
C1868 a_45734_n11460# VP 2.56035f
C1869 a_34662_n4047# vco_core_3_0.out 0.05572f
C1870 vco_core_4_0.vco_delay_cell_4_4.in vco_passgate_0.OI 4.50788f
C1871 VP VCO_decoder_cells_0.VCO3_selection_0.NAND_3in_dek_0.y 0.36391f
C1872 VCO_decoder_cells_0.VCO4_selection_0.NAND_2in_dek_0.y m2_3226_n5701# 0.11888f
C1873 PFD_passgate_4.B vco_core_1_0.vco_delay_cell_1$1_7.in 0.12892f
C1874 VCO_decoder_cells_0.111 VCO_decoder_cells_0.VCO_selection_0.NAND_3in_dek_0.c 0.21472f
C1875 vco_core_2_0.out VP 0.37382f
C1876 VCO_decoder_cells_0.VCO3_selection_0.inverter_dek_1.in m2_11724_n995# 0.01049f
C1877 VCO_decoder_cells_0.VCO3_selection_0.inverter_dek_0.out VCO_decoder_cells_0.VCO3_selection_0.NAND_4in_dek_0.c 0.02684f
C1878 vco_core_0_0.vco_delay_cell_0$1_1.in a_41209_n2486# 0.12373f
C1879 VCO_decoder_cells_0.VCO3_selection_0.NAND_4in_dek_0.c VCO_decoder_cells_0.VCO3_selection_0.NAND_2in_dek_0.y 0.01222f
C1880 vco_core_2_0.vco_delay_cell_2$6_0.pgt vco_core_2_0.vco_delay_cell_2$6_3.in 0.40549f
C1881 a_3770_154# f3 0.0206f
C1882 VCO_decoder_cells_0.010 VCO_decoder_cells_0.3bit_to_8_outs_0.NAND_3in_dek_6.y 0.28099f
C1883 VCO_MUX_0.VCO_sel vco_core_0_0.vp 0.8832f
C1884 VCO_MUX_0.VCO3_in VCO_MUX_0.passgate_scaled_2.en_ 0.27773f
C1885 VP 0_buf_1.out 2.16334f
C1886 a_45282_n1282# VCO_MUX_0.VCO_sel 0.02275f
C1887 VCO_decoder_cells_0.after_001111 a_9777_n1982# 0.0118f
C1888 VCO_decoder_cells_0.f5_n VCO_decoder_cells_0.after_000111 0.9442f
C1889 vco_core_3_0.vco_delay_cell_3_7.out vco_core_3_0.vco_delay_cell_3_5.in 0.60303f
C1890 a_44964_2717# VP 0.84545f
C1891 NOR_2in$1_0.B VCO_decoder_cells_0.VCO4_selection_0.NAND_4in_dek_0.b 0.59832f
C1892 vco_passgate_1.OI a_38402_n6301# 0.03713f
C1893 VCO_MUX_0.VCO_sel f5 0.07022f
C1894 VCO_decoder_cells_0.after_000011 VCO_decoder_cells_0.VCO2_selection_0.NAND_3in_dek_2.y 0.45296f
C1895 VCO_decoder_cells_0.VCO3_selection_0.NAND_3in_dek_4.a VCO_decoder_cells_0.VCO3_selection_0.inverter_dek_1.in 0.37068f
C1896 VCO_decoder_cells_0.after_000111 VCO_decoder_cells_0.VCO_selection_0.NAND_3in_dek_0.c 0.30508f
C1897 VCO_decoder_cells_0.VCO2_selection_0.NAND_3in_dek_2.y VCO_decoder_cells_0.VCO2_selection_0.NAND_3in_dek_0.y 0.3671f
C1898 VCO_decoder_cells_0.VCO2_selection_0.NAND_4in_dek_0.d VP 0.34095f
C1899 vco_core_0_0.in vco_core_0_0.vco_delay_cell_0$1_1.in 0.20207f
C1900 vco_passgate_1.OI vco_core_3_0.vco_delay_cell_3_1.out 0.61322f
C1901 a_10927_n3464# a_11143_n3464# 0.01537f
C1902 PFD_passgate_3.B vco_core_2_0.vco_delay_cell_2$6_2.in 0.21487f
C1903 VCO_MUX_0.VCO_sel f3 0.05386f
C1904 vco_passgate_1.OI vco_core_3_0.nen11 1.41537f
C1905 PFD_passgate_4.B vco_core_1_0.vco_delay_cell_1$1_6.in 0.03774f
C1906 f4 f0 0.06364f
C1907 NOR_2in$1_0.B a_3418_n4888# 0.04773f
C1908 a_38352_3420# vco_core_1_0.vco_delay_cell_1$1_2.out 0.08272f
C1909 a_27182_n5509# PFD_passgate_1.B 0.22557f
C1910 f5 VCO_decoder_cells_0.000 0.29173f
C1911 VCO_MUX_0.VCO3_sel VCO_MUX_0.VCO3_in 0.50895f
C1912 VCO_decoder_cells_0.VCO3_selection_0.NAND_4in_dek_1.d VP 0.2161f
C1913 VCO_decoder_cells_0.VCO3_11_sel vco_core_2_0.vco_delay_cell_2$6_2.in 0.0438f
C1914 vco_core_2_0.nen5 vco_passgate_4.OI 0.41314f
C1915 m2_3304_957# VCO_decoder_cells_0.after_000111 0.11798f
C1916 vco_core_0_0.vco_delay_cell_0$1_1.in vco_core_0_0.vp 0.64441f
C1917 vco_passgate_4.OI a_34661_6360# 0.04555f
C1918 vco_core_4_0.vco_delay_cell_4_1.dn vco_core_4_0.vco_delay_cell_4_1.in 0.0652f
C1919 a_30922_n6301# vco_core_3_0.vco_delay_cell_3_3.in 0.05096f
C1920 VCO_decoder_cells_0.VCO_selection_0.NAND_3in_dek_0.b VCO_decoder_cells_0.VCO_selection_0.NAND_3in_dek_0.c 0.27921f
C1921 VCO_decoder_cells_0.after_000111_n a_9993_n3938# 0.01094f
C1922 VCO_decoder_cells_0.VCO2_selection_0.NAND_3in_dek_0.y VCO_decoder_cells_0.VCO2_selection_0.NAND_3in_dek_1.y 0.38021f
C1923 f3 VCO_decoder_cells_0.000 0.04768f
C1924 a_9993_n5894# VCO_decoder_cells_0.VCO2_selection_0.NAND_4in_dek_0.a 0.03851f
C1925 VCO_decoder_cells_0.after_000011 NOR_2in$1_0.B 0.12083f
C1926 vco_core_1_0.vco_delay_cell_1$1_0.in a_36106_1826# 0.10123f
C1927 VCO_decoder_cells_0.after_000011 VCO_decoder_cells_0.101 1.00026f
C1928 VCO_decoder_cells_0.000000_n a_10840_1528# 0.01187f
C1929 NOR_2in$1_0.B VCO_decoder_cells_0.VCO2_selection_0.NAND_3in_dek_0.y 0.02394f
C1930 vco_core_3_0.vco_delay_cell_3_7.out PFD_passgate_1.B 0.01814f
C1931 a_27182_n4047# vco_core_3_0.out 0.05572f
C1932 VCO_decoder_cells_0.3bit_to_8_outs_0.inverter_dek_8.in a_4211_n3392# 0.01402f
C1933 VCO_decoder_cells_0.VCO2_selection_0.NAND_3in_dek_2.y a_11143_n3464# 0.01192f
C1934 VCO_decoder_cells_0.101 VCO_decoder_cells_0.VCO2_selection_0.NAND_3in_dek_0.y 0.05935f
C1935 NOR_2in$1_0.A VCO_decoder_cells_0.011 0.05392f
C1936 VCO_decoder_cells_0.3bit_to_8_outs_0.c2_n VCO_decoder_cells_0.3bit_to_8_outs_0.NAND_3in_dek_6.y 0.28637f
C1937 vco_core_4_0.pgt vco_core_4_0.vco_delay_cell_4_8.up 0.21552f
C1938 vco_core_1_0.vco_delay_cell_1$1_3.out vco_core_1_0.vco_delay_cell_1$1_0.pgt 0.03008f
C1939 c2 a_4211_n1748# 0.01052f
C1940 VCO_decoder_cells_0.after_000111 VCO_decoder_cells_0.VCO2_selection_0.NAND_2in_dek_0.y 0.15544f
C1941 vco_core_2_0.vco_delay_cell_2$6_5.out vco_core_2_0.vco_delay_cell_2$6_6.in 0.14637f
C1942 VCO_decoder_cells_0.VCO3_5_sel PFD_passgate_3.in_p 0.02709f
C1943 VCO_decoder_cells_0.VCO3_selection_0.NAND_4in_dek_0.c VCO_decoder_cells_0.011 0.25251f
C1944 PFD_passgate_0.B vco_core_4_0.vco_delay_cell_4_1.dn 0.12091f
C1945 a_9777_n1982# VCO_decoder_cells_0.VCO2_selection_0.NAND_3in_dek_1.a 0.04346f
C1946 vco_core_2_0.vco_delay_cell_2$6_0.pgt VP 0.11775f
C1947 PFD_passgate_1.B a_27182_n6301# 0.23521f
C1948 vco_core_2_0.vco_delay_cell_2$6_4.out PFD_passgate_3.B 0.12165f
C1949 vco_core_4_0.vco_delay_cell_4_4.up vco_core_4_0.pgt 0.19866f
C1950 a_9944_n902# VCO_decoder_cells_0.f5_n 0.01052f
C1951 VCO_decoder_cells_0.111 f0 0.07163f
C1952 VCO_decoder_cells_0.000000_n VCO_decoder_cells_0.001 0.12088f
C1953 vco_core_2_0.nen11 vco_passgate_4.OI 1.24784f
C1954 vco_in VCO_decoder_cells_0.000000 0.03699f
C1955 vco_core_3_0.vco_delay_cell_3_0.pgt vco_core_3_0.vco_delay_cell_3_9.in 0.36908f
C1956 VCO_decoder_cells_0.011 VCO_decoder_cells_0.after_000011_n 0.1657f
C1957 a_40664_3420# vco_core_1_0.out 0.06749f
C1958 VCO_decoder_cells_0.010 f1 0.04836f
C1959 vco_core_4_0.vco_delay_cell_4_0.out vco_core_4_0.vco_delay_cell_4_0.in 0.14049f
C1960 a_3531_n3074# VCO_decoder_cells_0.3bit_to_8_outs_0.inverter_dek_10.in 0.01962f
C1961 a_41855_n486# vco_core_0_0.vco_delay_cell_0$1_0.in 0.12324f
C1962 vco_core_4_0.pgt vco_core_3_0.vco_delay_cell_3_0.pgt 0.35259f
C1963 a_4784_n5362# a_5000_n5362# 0.01537f
C1964 vco_passgate_1.en 0_buf_0.out 0.82714f
C1965 f0 VCO_decoder_cells_0.after_000111 0.04812f
C1966 a_40101_6360# vco_core_2_0.vco_delay_cell_2$6_1.in 0.04737f
C1967 a_29701_7737# NOR_2in$1_1.Out 0.03063f
C1968 a_38350_2990# vco_core_1_0.vco_delay_cell_1$1_2.out 0.07362f
C1969 vco_core_4_0.vco_delay_cell_4_3.in vco_core_4_0.vco_delay_cell_4_3.up 0.08248f
C1970 a_41209_n2486# a_41821_n2486# 0.01898f
C1971 VCO_MUX_0.VCO_sel VCO_decoder_cells_0.VCO2_5_sel 0.22024f
C1972 vco_core_0_0.vco_delay_cell_0$1_0.pgt a_42467_n486# 0.11445f
C1973 VP vco_core_3_0.out 0.38058f
C1974 m2_4640_n185# f5 0.0427f
C1975 VCO_decoder_cells_0.3bit_to_8_outs_0.inverter_dek_6.in a_4211_n1748# 0.01402f
C1976 vco_core_1_0.nen5 VCO_decoder_cells_0.VCO2_5_sel 0.2011f
C1977 out VCO_MUX_0.passgate_scaled_1.en_ 0.59631f
C1978 VCO_decoder_cells_0.VCO3_selection_0.NAND_4in_dek_1.d a_11310_n428# 0.01274f
C1979 VP VCO_decoder_cells_0.VCO2_11_sel 0.90549f
C1980 f5 a_10463_n5894# 0.02899f
C1981 a_43760_3221# vco_core_1_0.out 0.26541f
C1982 a_4784_n4888# VCO_decoder_cells_0.after_000011_n 0.01463f
C1983 a_44190_7593# VP 0.76507f
C1984 a_5047_n7189# VCO_decoder_cells_0.VCO_selection_0.NAND_3in_dek_0.c 0.04355f
C1985 vco_core_2_0.vco_delay_cell_2$6_0.pgt a_40101_4818# 0.12803f
C1986 c1 VCO_decoder_cells_0.3bit_to_8_outs_0.c1_n 0.54519f
C1987 a_4722_154# f1 0.0104f
C1988 VCO_MUX_0.passgate_scaled_0.en_ VCO_MUX_0.VCO2_in 0.27858f
C1989 a_38350_1826# vco_core_1_0.vco_delay_cell_1$1_1.out 0.08419f
C1990 vco_passgate_4.OI vco_core_2_0.vco_delay_cell_2$6_0.in 1.22311f
C1991 VCO_MUX_0.VCO_sel out 0.13664f
C1992 VCO_decoder_cells_0.VCO3_selection_0.NAND_4in_dek_0.c a_11310_1054# 0.01073f
C1993 vco_in vco_passgate_1.en 0.12829f
C1994 a_42501_n2018# vco_core_0_0.vco_delay_cell_0$1_3.in 0.1165f
C1995 a_10476_n5420# a_10692_n5420# 0.01537f
C1996 m2_4850_n2745# VCO_decoder_cells_0.010 0.0959f
C1997 vco_core_4_0.vco_delay_cell_4_2.dn vco_passgate_0.OI 0.05383f
C1998 a_40664_3420# vco_core_1_0.nen11 0.02441f
C1999 c0 VCO_decoder_cells_0.000000_n 0.5716f
C2000 vco_core_4_0.vco_delay_cell_4_10.dn vco_passgate_0.OI 0.05179f
C2001 vco_core_0_0.vp a_41821_n2486# 0.18178f
C2002 VCO_decoder_cells_0.111 VCO_decoder_cells_0.VCO2_selection_0.NAND_3in_dek_1.b 0.01474f
C2003 vco_core_0_0.vco_delay_cell_0$1_0.pgt vco_core_0_0.out 0.05972f
C2004 NOR_2in$1_0.A VCO_MUX_0.VCO_sel 0.34806f
C2005 a_5047_n6871# VCO_decoder_cells_0.VCO_selection_0.NAND_3in_dek_0.b 0.04346f
C2006 VCO_decoder_cells_0.000000_n VP 1.27653f
C2007 VCO_decoder_cells_0.VCO3_selection_0.NAND_4in_dek_1.a m2_11724_n1077# 0.09639f
C2008 VCO_decoder_cells_0.VCO4_selection_0.NAND_3in_dek_1.y VCO_decoder_cells_0.VCO_selection_0.NAND_3in_dek_0.b 0.01069f
C2009 a_3531_n3392# VCO_decoder_cells_0.3bit_to_8_outs_0.c2_n 0.01057f
C2010 VCO_decoder_cells_0.VCO3_5_sel vco_core_2_0.vco_delay_cell_2$6_9.out 0.04716f
C2011 VCO_decoder_cells_0.row_section_decoding_0.NAND_3in_dek_0.b f0 0.43231f
C2012 vco_passgate_3.OI a_38352_1356# 0.17222f
C2013 vco_core_0_0.out a_43476_n653# 0.28058f
C2014 a_4427_n3392# VCO_decoder_cells_0.3bit_to_8_outs_0.NAND_3in_dek_2.y 0.04031f
C2015 vco_core_4_0.vco_delay_cell_4_7.out vco_core_4_0.vco_delay_cell_4_6.up 0.08248f
C2016 VCO_decoder_cells_0.after_000011_n VCO_decoder_cells_0.VCO2_selection_0.NAND_4in_dek_1.d 0.23618f
C2017 0_buf_1.in vco_core_4_0.vco_delay_cell_4_5.up 0.06518f
C2018 VCO_decoder_cells_0.VCO3_selection_0.NAND_4in_dek_0.b VCO_decoder_cells_0.after_000111 0.03725f
C2019 VCO_decoder_cells_0.row_section_decoding_0.NAND_2in_dek_0.b VCO_decoder_cells_0.000000_n 0.01561f
C2020 a_4722_2110# VP 0.07094f
C2021 a_11526_n428# VCO_decoder_cells_0.VCO3_5_sel 0.04651f
C2022 vco_core_0_0.in a_41855_n914# 0.12828f
C2023 VCO_decoder_cells_0.VCO3_11_sel VCO_decoder_cells_0.VCO3_selection_0.NAND_4in_dek_0.d 0.15486f
C2024 vco_core_2_0.out PFD_passgate_3.B 0.12627f
C2025 VCO_decoder_cells_0.VCO2_selection_0.NAND_4in_dek_0.d VCO_decoder_cells_0.VCO2_5_sel 0.07961f
C2026 NOR_2in$1_0.A VCO_decoder_cells_0.000 0.07591f
C2027 VP inverter_x1_2.IN 1.20942f
C2028 a_10160_n428# VCO_decoder_cells_0.000000 0.01064f
C2029 vco_core_3_0.vco_delay_cell_3_0.pgt vco_core_3_0.out 5.42021f
C2030 f2 VCO_decoder_cells_0.f5_n 0.02728f
C2031 vco_passgate_1.en_ vco_in 0.07003f
C2032 VCO_decoder_cells_0.3bit_to_8_outs_0.inverter_dek_8.in VCO_decoder_cells_0.000 0.33934f
C2033 m2_4702_n5455# VCO_decoder_cells_0.after_000011 0.0134f
C2034 VCO_decoder_cells_0.f5_n VCO_decoder_cells_0.100 0.49294f
C2035 vco_core_0_0.in a_41209_n2018# 0.12527f
C2036 VP VCO_decoder_cells_0.001 1.60487f
C2037 VCO_decoder_cells_0.f5_n VCO_decoder_cells_0.000000 0.19061f
C2038 VCO_MUX_0.VCO_sel VCO_decoder_cells_0.after_000011_n 0.06339f
C2039 vco_core_4_0.vco_delay_cell_4_0.out vco_passgate_0.OI 4.91455f
C2040 a_41855_n914# vco_core_0_0.vp 0.02255f
C2041 VCO_MUX_0.VCO_sel vco_passgate_1.OI 0.04671f
C2042 a_43535_n5061# NOR_2in$1_0.B 0.02085f
C2043 vco_passgate_3.OI a_38352_3420# 0.17204f
C2044 vco_core_2_0.out VCO_decoder_cells_0.VCO3_11_sel 0.01923f
C2045 out 0_buf_1.out 0.08746f
C2046 VCO_decoder_cells_0.VCO3_selection_0.NAND_4in_dek_0.c VCO_decoder_cells_0.VCO3_selection_0.NAND_4in_dek_0.d 0.65522f
C2047 a_4269_n5362# VCO_decoder_cells_0.after_000011 0.01052f
C2048 vco_core_2_0.nen11 vco_core_2_0.vco_delay_cell_2$6_0.out 0.05282f
C2049 vco_core_4_0.vco_delay_cell_4_1.in vco_core_4_0.pgt 0.96674f
C2050 PFD_passgate_4.B a_39506_2990# 0.18219f
C2051 VCO_decoder_cells_0.after_001111_n f4 0.14088f
C2052 vco_core_3_0.vco_delay_cell_3_0.pgt a_34662_n4047# 0.25023f
C2053 VCO_decoder_cells_0.101 VCO_decoder_cells_0.3bit_to_8_outs_0.NAND_3in_dek_3.y 0.28097f
C2054 vco_core_1_0.vco_delay_cell_1$1_0.in VCO_decoder_cells_0.VCO2_11_sel 0.17772f
C2055 PFD_passgate_4.B vco_core_1_0.vco_delay_cell_1$1_5.in 0.09279f
C2056 VP a_42228_3420# 0.02197f
C2057 VCO_MUX_0.VCO_sel VCO_MUX_0.VCO3_in 0.02235f
C2058 VCO_decoder_cells_0.f5_n VCO_decoder_cells_0.after_001111 0.97174f
C2059 a_4427_n3074# VCO_decoder_cells_0.3bit_to_8_outs_0.NAND_3in_dek_6.y 0.04031f
C2060 VCO_decoder_cells_0.VCO4_selection_0.NAND_3in_dek_0.y VCO_decoder_cells_0.after_000011_n 0.47786f
C2061 VCO_decoder_cells_0.VCO4_selection_0.NAND_2in_dek_0.y NOR_2in$1_0.B 0.0107f
C2062 vco_core_2_0.vco_delay_cell_2$6_5.out vco_passgate_4.OI 1.15335f
C2063 vco_passgate_4.OI a_38741_4818# 0.24133f
C2064 VCO_decoder_cells_0.after_000011_n VCO_decoder_cells_0.000 0.75607f
C2065 VCO_decoder_cells_0.VCO2_selection_0.NAND_4in_dek_1.c VCO_decoder_cells_0.VCO2_selection_0.NAND_4in_dek_1.d 0.86654f
C2066 VCO_decoder_cells_0.after_001111 VCO_decoder_cells_0.VCO_selection_0.NAND_3in_dek_0.c 0.06821f
C2067 a_38741_8614# vco_core_2_0.vco_delay_cell_2$6_5.in 0.06326f
C2068 VCO_decoder_cells_0.VCO3_selection_0.NAND_4in_dek_0.b VCO_decoder_cells_0.VCO3_selection_0.NAND_4in_dek_1.b 0.17897f
C2069 VCO_decoder_cells_0.VCO3_selection_0.NAND_4in_dek_0.d VCO_decoder_cells_0.after_000011_n 0.01201f
C2070 f5 VCO_decoder_cells_0.000000_n 0.16421f
C2071 0_buf_1.in vco_core_4_0.pgt 0.64318f
C2072 a_4427_n1748# VCO_decoder_cells_0.3bit_to_8_outs_0.NAND_3in_dek_3.y 0.04031f
C2073 NOR_2in$1_0.A VCO_decoder_cells_0.VCO2_selection_0.NAND_4in_dek_0.d 0.06239f
C2074 a_41750_1826# VCO_decoder_cells_0.VCO2_11_sel 0.07636f
C2075 VCO_decoder_cells_0.after_000111_n VCO_decoder_cells_0.f5_n 2.12772f
C2076 f3 VCO_decoder_cells_0.000000_n 0.10065f
C2077 VCO_decoder_cells_0.VCO2_selection_0.NAND_4in_dek_0.b VCO_decoder_cells_0.f5_n 0.33742f
C2078 VCO_decoder_cells_0.after_000011 VCO_decoder_cells_0.011 0.18463f
C2079 NOR_2in$1_0.A vco_core_3_0.vco_delay_cell_3_9.in 0.04987f
C2080 PFD_passgate_0.B vco_core_4_0.pgt 2.10615f
C2081 vco_passgate_0.OI vco_core_4_0.vco_delay_cell_4_6.up 0.61027f
C2082 VCO_MUX_0.VCO2_sel PFD_passgate_4.in_p 0.11486f
C2083 VCO_decoder_cells_0.011 VCO_decoder_cells_0.VCO2_selection_0.NAND_3in_dek_0.y 0.06346f
C2084 a_44362_3221# VP 0.78693f
C2085 f1 NOR_2in$1_0.B 0.05451f
C2086 vco_core_4_0.vco_delay_cell_4_1.in vco_core_4_0.vco_delay_cell_4_2.in 0.11087f
C2087 m2_3304_957# VCO_decoder_cells_0.after_001111 0.08643f
C2088 VP VCO_decoder_cells_0.VCO3_selection_0.NAND_2in_dek_1.y 0.29026f
C2089 m2_10551_n263# VCO_decoder_cells_0.000000 0.25209f
C2090 a_9993_n3464# VCO_decoder_cells_0.VCO2_selection_0.NAND_4in_dek_1.c 0.04031f
C2091 vco_core_3_0.vco_delay_cell_3_0.pgt vco_core_3_0.vco_delay_cell_3_3.in 0.93555f
C2092 a_40664_1356# vco_core_1_0.vco_delay_cell_1$1_0.pgt 0.18522f
C2093 VCO_decoder_cells_0.3bit_to_8_outs_0.inverter_dek_1.in VCO_decoder_cells_0.3bit_to_8_outs_0.NAND_3in_dek_3.y 0.04432f
C2094 a_4722_2110# f3 0.03145f
C2095 f1 VCO_decoder_cells_0.101 0.04857f
C2096 vco_core_0_0.out a_42501_n2486# 0.081f
C2097 a_34662_n5509# vco_core_3_0.vco_delay_cell_3_7.in 0.04645f
C2098 VCO_decoder_cells_0.110 VCO_decoder_cells_0.f5_n 0.15803f
C2099 vco_core_3_0.vco_delay_cell_3_0.pgt inverter_x1_2.IN 0.04814f
C2100 f5 VCO_decoder_cells_0.001 0.4634f
C2101 vco_core_2_0.nen11 a_41461_4818# 0.0453f
C2102 vco_core_2_0.vco_delay_cell_2$6_0.in vco_core_2_0.vco_delay_cell_2$6_0.out 0.26806f
C2103 vco_core_2_0.vco_delay_cell_2$6_2.in a_37381_4818# 0.01238f
C2104 c0 VP 1.4567f
C2105 vco_core_4_0.vco_delay_cell_4_2.dn vco_core_4_0.vco_delay_cell_4_2.up 0.03587f
C2106 VCO_decoder_cells_0.100 VCO_decoder_cells_0.VCO2_selection_0.NAND_2in_dek_0.y 0.21838f
C2107 a_3084_n350# VCO_decoder_cells_0.000000_n 0.04078f
C2108 vco_core_0_0.vco_delay_cell_0$1_0.pgt vco_passgate_1.en 0.01923f
C2109 VCO_MUX_0.VCO3_in 0_buf_1.out 0.06219f
C2110 VCO_decoder_cells_0.VCO3_selection_0.NAND_3in_dek_3.y VCO_decoder_cells_0.011 0.23245f
C2111 m2_3304_957# VCO_decoder_cells_0.after_000111_n 0.01436f
C2112 a_23442_n7843# vco_core_3_0.vco_delay_cell_3_5.out 0.06619f
C2113 f3 VCO_decoder_cells_0.001 0.05912f
C2114 PFD_passgate_4.B a_39506_1826# 0.1911f
C2115 VCO_MUX_0.VCO3_sel VCO_MUX_0.VCO2_sel 0.41396f
C2116 vco_core_2_0.vco_delay_cell_2$6_0.pgt PFD_passgate_3.B 1.40892f
C2117 vco_core_3_0.vco_delay_cell_3_0.pgt a_27182_n4047# 0.24606f
C2118 VCO_decoder_cells_0.111 VCO_decoder_cells_0.after_001111_n 0.15563f
C2119 vco_core_2_0.nen11 vco_core_2_0.vco_delay_cell_2$6_9.out 0.06428f
C2120 vco_passgate_1.OI vco_core_3_0.vco_delay_cell_3_9.in 2.74178f
C2121 VCO_decoder_cells_0.row_section_decoding_0.NAND_2in_dek_0.b VP 0.22486f
C2122 vco_core_4_0.vco_delay_cell_4_0.out vco_core_4_0.vco_delay_cell_4_9.up 0.08248f
C2123 m2_11509_2917# VCO_decoder_cells_0.VCO3_selection_0.inverter_dek_0.out 0.05575f
C2124 PFD_passgate_0.B vco_core_4_0.vco_delay_cell_4_2.in 0.64278f
C2125 VCO_MUX_0.VCO_in VCO_MUX_0.VCO3_sel 0.05561f
C2126 vco_core_1_0.vco_delay_cell_1$1_0.pgt a_40664_3420# 0.17303f
C2127 VCO_decoder_cells_0.VCO3_11_sel vco_core_2_0.vco_delay_cell_2$6_0.pgt 0.37856f
C2128 vco_passgate_1.OI vco_core_4_0.pgt 0.10445f
C2129 vco_core_1_0.vco_delay_cell_1$1_7.in vco_core_1_0.vco_delay_cell_1$1_4.in 0.32016f
C2130 a_42467_n914# vco_core_0_0.out 0.13129f
C2131 a_23442_n5509# vco_core_3_0.out 0.04124f
C2132 vco_core_0_0.in VP 0.48292f
C2133 a_42005_8614# vco_core_2_0.out 0.07282f
C2134 VCO_decoder_cells_0.after_001111_n VCO_decoder_cells_0.after_000111 1.05794f
C2135 VCO_MUX_0.VCO_sel VCO_decoder_cells_0.VCO4_selection_0.NAND_4in_dek_0.b 0.01393f
C2136 f2 f0 0.40176f
C2137 PFD_passgate_4.B VCO_MUX_0.VCO2_sel 0.03032f
C2138 VCO_decoder_cells_0.VCO2_selection_0.NAND_3in_dek_1.a a_10954_n1982# 0.03125f
C2139 VCO_decoder_cells_0.VCO2_5_sel VCO_decoder_cells_0.VCO2_11_sel 0.88475f
C2140 VCO_decoder_cells_0.VCO2_selection_0.NAND_4in_dek_0.d a_10996_n5894# 0.03597f
C2141 VCO_decoder_cells_0.VCO2_selection_0.NAND_4in_dek_0.b VCO_decoder_cells_0.VCO2_selection_0.NAND_2in_dek_0.y 0.26541f
C2142 f0 VCO_decoder_cells_0.100 0.03301f
C2143 f0 VCO_decoder_cells_0.000000 0.05228f
C2144 a_4571_n7189# VCO_decoder_cells_0.VCO_selection_0.NAND_3in_dek_0.a 0.04332f
C2145 VCO_decoder_cells_0.110 m2_10551_n263# 0.01109f
C2146 vco_core_2_0.vco_delay_cell_2$6_0.in a_41461_4818# 0.06459f
C2147 VCO_decoder_cells_0.after_001111_n a_3510_2110# 0.04555f
C2148 m2_11724_n995# m2_11724_n1077# 0.08407f
C2149 VCO_decoder_cells_0.VCO5_selection_0.NAND_2in_dek_0.a a_10729_n7436# 0.01213f
C2150 vco_core_0_0.vp VP 1.61931f
C2151 a_45282_n1282# VP 1.36332f
C2152 VCO_decoder_cells_0.VCO2_selection_0.NAND_3in_dek_0.y VCO_decoder_cells_0.VCO2_selection_0.NAND_4in_dek_1.d 0.06756f
C2153 VCO_decoder_cells_0.VCO4_selection_0.NAND_3in_dek_1.y VCO_decoder_cells_0.VCO4_selection_0.NAND_4in_dek_0.d 0.35719f
C2154 VCO_decoder_cells_0.VCO4_selection_0.NAND_4in_dek_0.b VCO_decoder_cells_0.VCO4_selection_0.NAND_3in_dek_0.y 0.16357f
C2155 f0 VCO_decoder_cells_0.after_001111 0.05549f
C2156 a_30922_n5509# vco_passgate_1.OI 0.03713f
C2157 VCO_decoder_cells_0.VCO3_selection_0.inverter_dek_1.in VCO_decoder_cells_0.VCO2_selection_0.NAND_3in_dek_1.y 0.01612f
C2158 vco_core_1_0.vco_delay_cell_1$1_7.in VCO_decoder_cells_0.VCO2_11_sel 0.02487f
C2159 VCO_decoder_cells_0.000000 VCO_decoder_cells_0.VCO4_selection_0.NAND_3in_dek_1.y 0.02187f
C2160 VCO_decoder_cells_0.3bit_to_8_outs_0.c0_n VCO_decoder_cells_0.000000_n 0.0122f
C2161 vco_core_0_0.vp a_41209_n2486# 0.15679f
C2162 f5 VP 2.74083f
C2163 c1 VCO_decoder_cells_0.3bit_to_8_outs_0.c2_n 0.41096f
C2164 a_36021_7152# PFD_passgate_3.B 0.08989f
C2165 NOR_2in$1_0.A vco_core_3_0.out 0.07821f
C2166 PFD_passgate_3.B a_36021_6360# 0.09552f
C2167 a_10630_1054# VCO_decoder_cells_0.VCO3_selection_0.NAND_4in_dek_1.c 0.04299f
C2168 vco_core_2_0.nen5 VCO_decoder_cells_0.VCO3_5_sel 0.18061f
C2169 VP vco_core_3_0.vco_delay_cell_3_0.pgt 0.01456f
C2170 a_3770_154# VCO_decoder_cells_0.row_section_decoding_0.NAND_3in_dek_0.a 0.04208f
C2171 f3 VP 0.90541f
C2172 a_44739_n5565# a_44137_n5061# 0.48912f
C2173 VCO_decoder_cells_0.3bit_to_8_outs_0.inverter_dek_6.in VCO_decoder_cells_0.3bit_to_8_outs_0.inverter_dek_10.in 0.04331f
C2174 VCO_MUX_0.VCO_sel VCO_decoder_cells_0.after_000011 0.05747f
C2175 f5 VCO_decoder_cells_0.row_section_decoding_0.NAND_2in_dek_0.b 0.25299f
C2176 VCO_decoder_cells_0.VCO3_11_sel VCO_decoder_cells_0.VCO2_11_sel 0.03969f
C2177 PFD_passgate_4.B vco_core_1_0.vco_delay_cell_1$1_1.out 0.12892f
C2178 vco_core_4_0.vco_delay_cell_4_3.in vco_passgate_0.OI 4.54785f
C2179 VCO_decoder_cells_0.after_000111_n f0 0.06552f
C2180 vco_core_0_0.in vco_core_0_0.vp 0.54044f
C2181 VCO_decoder_cells_0.3bit_to_8_outs_0.NAND_3in_dek_0.y c0 0.24627f
C2182 VCO_decoder_cells_0.000000 a_11310_1528# 0.01007f
C2183 vco_core_2_0.vco_delay_cell_2$6_0.pgt vco_core_2_0.vco_delay_cell_2$6_6.out 0.36581f
C2184 VCO_decoder_cells_0.VCO3_selection_0.NAND_3in_dek_4.b VCO_decoder_cells_0.after_000111 0.35283f
C2185 VCO_decoder_cells_0.VCO2_5_sel a_11428_n5894# 0.04651f
C2186 VCO_decoder_cells_0.3bit_to_8_outs_0.NAND_3in_dek_0.y VP 0.36139f
C2187 VCO_decoder_cells_0.row_section_decoding_0.NAND_2in_dek_0.b f3 0.09876f
C2188 m2_51016_n1607# out 0.05425f
C2189 VCO_decoder_cells_0.VCO2_5_sel inverter_x1_2.IN 0.03547f
C2190 vco_core_3_0.vco_delay_cell_3_7.in vco_core_3_0.vco_delay_cell_3_5.in 0.35129f
C2191 NOR_2in$1_0.B vco_core_3_0.vco_delay_cell_3_0.in 0.7746f
C2192 a_44530_n11335# VP 0.79545f
C2193 a_11143_n3464# VCO_decoder_cells_0.VCO2_selection_0.NAND_4in_dek_1.d 0.01228f
C2194 vco_core_1_0.nen5 vco_core_1_0.vco_delay_cell_1$1_5.in 0.01257f
C2195 VCO_decoder_cells_0.after_000111_n VCO_decoder_cells_0.VCO4_selection_0.NAND_3in_dek_1.y 0.34555f
C2196 VCO_decoder_cells_0.after_000011 VCO_decoder_cells_0.000 1.61316f
C2197 VCO_decoder_cells_0.VCO3_selection_0.NAND_4in_dek_0.b VCO_decoder_cells_0.100 0.01095f
C2198 VCO_decoder_cells_0.110 f0 0.06447f
C2199 VCO_decoder_cells_0.VCO3_selection_0.NAND_4in_dek_0.b VCO_decoder_cells_0.000000 0.22248f
C2200 PFD_passgate_3.B vco_core_2_0.vco_delay_cell_2$6_3.in 0.21239f
C2201 m2_51016_n2749# out 0.05411f
C2202 vco_passgate_1.OI vco_core_3_0.out 4.01744f
C2203 PFD_passgate_4.B vco_core_1_0.vco_delay_cell_1$1_2.out 0.03774f
C2204 a_40662_2990# vco_core_1_0.vco_delay_cell_1$1_0.pgt 0.01252f
C2205 a_38352_3420# vco_core_1_0.vco_delay_cell_1$1_2.in 0.10901f
C2206 NOR_2in$1_0.A VCO_decoder_cells_0.000000_n 0.0568f
C2207 m2_9698_n7271# VCO_decoder_cells_0.000000 0.20543f
C2208 VCO_decoder_cells_0.010 VCO_decoder_cells_0.f5_n 0.33346f
C2209 vco_passgate_1.OI a_30922_n6301# 0.03713f
C2210 vco_passgate_0.OI vco_core_3_0.nen11 0.01068f
C2211 vco_core_1_0.vco_delay_cell_1$1_4.in a_39508_1356# 0.09176f
C2212 m2_11351_n2075# VCO_decoder_cells_0.VCO2_selection_0.inverter_dek_0.out 0.05597f
C2213 a_42005_8614# vco_core_2_0.vco_delay_cell_2$6_0.pgt 0.10805f
C2214 VCO_decoder_cells_0.VCO3_selection_0.NAND_4in_dek_0.c a_10840_1528# 0.04041f
C2215 VCO_MUX_0.VCO_sel VCO_MUX_0.inverter_dek_0.out 0.65904f
C2216 vco_core_0_0.vp vco_core_3_0.vco_delay_cell_3_0.pgt 0.06715f
C2217 out inverter_x1_2.IN 0.08635f
C2218 VCO_decoder_cells_0.VCO3_11_sel vco_core_2_0.vco_delay_cell_2$6_3.in 0.04899f
C2219 vco_passgate_1.OI VCO_decoder_cells_0.VCO2_11_sel 0.01251f
C2220 PFD_passgate_0.B inverter_x1_2.IN 0.01837f
C2221 vco_core_2_0.nen11 VCO_decoder_cells_0.VCO3_5_sel 0.05962f
C2222 VCO_decoder_cells_0.after_001111 VCO_decoder_cells_0.VCO2_selection_0.NAND_3in_dek_1.b 0.23189f
C2223 a_45394_7089# a_44792_7593# 0.48912f
C2224 vco_passgate_1.OI a_34662_n4047# 0.40766f
C2225 VCO_decoder_cells_0.000000_n VCO_decoder_cells_0.VCO3_selection_0.NAND_4in_dek_0.c 0.34209f
C2226 m2_11509_2671# VCO_decoder_cells_0.VCO3_selection_0.NAND_2in_dek_1.y 0.11888f
C2227 NOR_2in$1_0.A vco_core_3_0.vco_delay_cell_3_3.in 0.03228f
C2228 a_39218_n5509# vco_core_3_0.vco_delay_cell_3_0.in 0.07459f
C2229 f5 f3 0.29587f
C2230 vco_core_4_0.pgt vco_core_4_0.vco_delay_cell_4_10.up 0.21552f
C2231 VCO_MUX_0.VCO_sel VCO_decoder_cells_0.VCO2_selection_0.NAND_4in_dek_0.a 0.02841f
C2232 vco_core_2_0.vco_delay_cell_2$6_5.out vco_core_2_0.vco_delay_cell_2$6_9.out 0.27148f
C2233 VCO_decoder_cells_0.after_000111_n VCO_decoder_cells_0.VCO3_selection_0.NAND_4in_dek_0.b 0.59951f
C2234 vco_core_3_0.vco_delay_cell_3_7.in PFD_passgate_1.B 0.33702f
C2235 a_4053_n5362# VCO_decoder_cells_0.after_000111_n 0.02011f
C2236 PFD_passgate_0.B vco_core_4_0.vco_delay_cell_4_0.dn 0.12091f
C2237 NOR_2in$1_0.A VCO_decoder_cells_0.001 0.08495f
C2238 VCO_decoder_cells_0.VCO2_selection_0.NAND_4in_dek_0.d VCO_decoder_cells_0.after_000011 0.45092f
C2239 a_36021_6360# vco_core_2_0.vco_delay_cell_2$6_6.out 0.04737f
C2240 vco_core_3_0.nen5 vco_core_3_0.vco_delay_cell_3_0.in 0.39788f
C2241 VCO_decoder_cells_0.000000_n VCO_decoder_cells_0.after_000011_n 13.3821f
C2242 VCO_decoder_cells_0.VCO2_selection_0.NAND_4in_dek_0.d VCO_decoder_cells_0.VCO2_selection_0.NAND_3in_dek_0.y 0.0225f
C2243 a_10160_n902# f5 0.01165f
C2244 VCO_decoder_cells_0.3bit_to_8_outs_0.inverter_dek_8.in VCO_decoder_cells_0.001 0.36785f
C2245 VCO_decoder_cells_0.VCO2_selection_0.NAND_3in_dek_0.y a_10738_n1982# 0.01052f
C2246 VCO_decoder_cells_0.row_section_decoding_0.NAND_3in_dek_0.b a_3300_n350# 0.02843f
C2247 a_3531_n1430# a_3747_n1430# 0.01537f
C2248 a_9777_n5894# a_9993_n5894# 0.01537f
C2249 vco_in NOR_2in$1_0.B 0.03564f
C2250 vco_core_2_0.vco_delay_cell_2$6_5.in vco_core_2_0.vco_delay_cell_2$6_6.in 0.14431f
C2251 VCO_decoder_cells_0.3bit_to_8_outs_0.c0_n c0 1.50769f
C2252 vco_passgate_4.OI a_42005_7152# 0.02082f
C2253 VCO_decoder_cells_0.000000_n a_10160_1528# 0.01026f
C2254 vco_core_4_0.vco_delay_cell_4_3.up vco_core_4_0.pgt 0.19866f
C2255 VCO_MUX_0.VCO2_sel VCO_MUX_0.passgate_scaled_1.en_ 0.41405f
C2256 VCO_MUX_0.VCO3_sel VCO_MUX_0.passgate_scaled_3.en_ 0.41405f
C2257 vco_passgate_4.OI a_41461_6360# 0.01353f
C2258 VCO_decoder_cells_0.3bit_to_8_outs_0.c0_n VP 1.36782f
C2259 a_3583_n5362# VCO_decoder_cells_0.after_000011_n 0.03506f
C2260 m2_51016_n2749# VCO_MUX_0.VCO3_in 0.04414f
C2261 vco_passgate_1.OI vco_core_3_0.vco_delay_cell_3_3.in 2.69018f
C2262 VP VCO_decoder_cells_0.VCO2_5_sel 2.80701f
C2263 vco_core_4_0.vco_delay_cell_4_0.out vco_core_4_0.vco_delay_cell_4_9.dn 0.0652f
C2264 VCO_decoder_cells_0.VCO2_11_sel VCO_decoder_cells_0.VCO2_selection_0.NAND_4in_dek_1.c 0.43349f
C2265 f1 VCO_decoder_cells_0.011 0.063f
C2266 VCO_MUX_0.VCO_in VCO_MUX_0.passgate_scaled_1.en_ 0.01108f
C2267 a_40662_1826# vco_core_1_0.vco_delay_cell_1$1_0.pgt 0.01803f
C2268 vco_passgate_1.OI inverter_x1_2.IN 1.26852f
C2269 m2_4640_957# VCO_decoder_cells_0.row_section_decoding_0.NAND_2in_dek_0.b 0.20543f
C2270 VCO_decoder_cells_0.VCO3_selection_0.inverter_dek_1.in m2_11724_n1241# 0.12029f
C2271 vco_core_3_0.vco_delay_cell_3_1.in PFD_passgate_1.B 0.42256f
C2272 vco_core_2_0.nen11 vco_core_2_0.nen5 0.14391f
C2273 VCO_decoder_cells_0.VCO4_selection_0.NAND_4in_dek_0.d a_4314_n4888# 0.04377f
C2274 VCO_decoder_cells_0.after_000011_n VCO_decoder_cells_0.001 0.81759f
C2275 vco_core_2_0.vco_delay_cell_2$6_6.out vco_core_2_0.vco_delay_cell_2$6_3.in 0.27102f
C2276 VCO_MUX_0.VCO_sel VCO_MUX_0.VCO2_sel 3.73514f
C2277 vco_core_3_0.vco_delay_cell_3_4.in vco_core_3_0.vco_delay_cell_3_3.in 0.16384f
C2278 out gd 9.65447f
C2279 vco_in gd 16.15783f
C2280 VP gd 0.14147p
C2281 m2_10650_n7353# gd 0.05309f ; **FLOATING
C2282 m2_9698_n7271# gd 0.02056f ; **FLOATING
C2283 m2_4965_n6788# gd 0.03946f ; **FLOATING
C2284 m2_4279_n6788# gd 0.06489f ; **FLOATING
C2285 m2_4965_n6706# gd 0.02051f ; **FLOATING
C2286 m2_3226_n5701# gd 0.01157f ; **FLOATING
C2287 m2_3226_n5537# gd 0.0126f ; **FLOATING
C2288 m2_4702_n5455# gd 0.02861f ; **FLOATING
C2289 m2_3226_n5455# gd 0.01947f ; **FLOATING
C2290 m2_51016_n2749# gd 0.01308f ; **FLOATING
C2291 m2_5122_n2745# gd 0.01195f ; **FLOATING
C2292 m2_11351_n2321# gd 0.01191f ; **FLOATING
C2293 m2_51016_n1607# gd 0.01427f ; **FLOATING
C2294 m2_11351_n2075# gd 0.01854f ; **FLOATING
C2295 m2_5122_n2087# gd 0.01195f ; **FLOATING
C2296 m2_50108_n531# gd 0.01949f ; **FLOATING
C2297 m2_11724_n1241# gd 0.01282f ; **FLOATING
C2298 m2_11724_n1077# gd 0.0138f ; **FLOATING
C2299 m2_11724_n995# gd 0.02063f ; **FLOATING
C2300 m2_5122_n1101# gd 0.01195f ; **FLOATING
C2301 m2_10551_n263# gd 0.01365f ; **FLOATING
C2302 m2_4640_n185# gd 0.02045f ; **FLOATING
C2303 m2_4640_957# gd 0.02109f ; **FLOATING
C2304 m2_4164_957# gd 0.01384f ; **FLOATING
C2305 m2_11231_1611# gd 0.03318f ; **FLOATING
C2306 m2_11231_1693# gd 0.02084f ; **FLOATING
C2307 m2_11509_2671# gd 0.01189f ; **FLOATING
C2308 m2_11509_2835# gd 0.01292f ; **FLOATING
C2309 m2_11509_2917# gd 0.0217f ; **FLOATING
C2310 m2_11027_2917# gd 0.05422f ; **FLOATING
C2311 vco_core_4_0.vco_delay_cell_4_5.up gd 2.72863f
C2312 vco_core_4_0.vco_delay_cell_4_4.up gd 1.97117f
C2313 vco_core_4_0.vco_delay_cell_4_3.up gd 3.58064f
C2314 vco_core_4_0.vco_delay_cell_4_2.up gd 1.82569f
C2315 vco_core_4_0.vco_delay_cell_4_1.up gd 7.27303f
C2316 vco_core_4_0.vco_delay_cell_4_0.up gd 2.92141f
C2317 vco_core_4_0.vco_delay_cell_4_1.in gd 1.75495f
C2318 vco_core_4_0.vco_delay_cell_4_5.dn gd 0.65601f
C2319 vco_core_4_0.vco_delay_cell_4_4.dn gd 4.09558f
C2320 vco_core_4_0.vco_delay_cell_4_3.dn gd 53.59782f
C2321 vco_core_4_0.vco_delay_cell_4_2.dn gd 2.55403f
C2322 vco_core_4_0.vco_delay_cell_4_1.dn gd 1.60381f
C2323 vco_core_4_0.vco_delay_cell_4_0.dn gd 1.12871f
C2324 vco_core_4_0.vco_delay_cell_4_6.dn gd 0.6536f
C2325 vco_core_4_0.vco_delay_cell_4_7.dn gd 0.6536f
C2326 vco_core_4_0.vco_delay_cell_4_8.dn gd 2.55197f
C2327 vco_core_4_0.vco_delay_cell_4_10.dn gd 2.69798f
C2328 vco_core_4_0.vco_delay_cell_4_9.dn gd 0.6536f
C2329 vco_core_4_0.vco_delay_cell_4_8.out gd 1.97139f
C2330 vco_core_4_0.vco_delay_cell_4_6.up gd 3.39289f
C2331 vco_core_4_0.vco_delay_cell_4_7.up gd 2.9183f
C2332 vco_core_4_0.vco_delay_cell_4_8.up gd 2.04214f
C2333 vco_core_4_0.vco_delay_cell_4_10.up gd 1.96911f
C2334 vco_core_4_0.vco_delay_cell_4_9.up gd 4.15958f
C2335 a_38402_n7843# gd 0.47921f
C2336 a_34662_n7843# gd 4.20518f
C2337 a_30922_n7843# gd 1.03768f
C2338 a_27182_n7843# gd 1.5341f
C2339 a_23442_n7843# gd 1.03771f
C2340 a_10729_n7436# gd 1.30085f
C2341 a_10253_n7436# gd 0.07627f
C2342 a_9777_n7436# gd 0.07852f
C2343 a_19702_n7843# gd 1.84103f
C2344 a_5047_n7189# gd 0.07852f
C2345 a_4571_n7189# gd 0.07424f
C2346 vco_core_3_0.vco_delay_cell_3_1.out gd 2.95715f
C2347 a_5047_n6871# gd 0.19694f
C2348 a_4577_n6871# gd 0.07673f
C2349 a_4361_n6871# gd 0.06314f
C2350 vco_core_3_0.vco_delay_cell_3_5.out gd 1.75321f
C2351 a_38402_n6301# gd 1.82571f
C2352 a_34662_n6301# gd 33.7849f
C2353 a_30922_n6301# gd 1.08231f
C2354 a_27182_n6301# gd 0.33768f
C2355 a_23442_n6301# gd 0.33768f
C2356 a_19702_n6301# gd 0.34567f
C2357 a_11428_n5894# gd 0.06318f
C2358 a_11212_n5894# gd 0.26226f
C2359 a_10996_n5894# gd 0.27604f
C2360 a_10463_n5894# gd 0.07622f
C2361 a_9993_n5894# gd 1.4895f
C2362 a_9777_n5894# gd 0.0767f
C2363 a_10692_n5420# gd 0.06367f
C2364 a_10476_n5420# gd 2.29409f
C2365 a_9993_n5420# gd 1.82187f
C2366 a_9777_n5420# gd 4.73087f
C2367 a_5000_n5362# gd 0.07669f
C2368 a_4784_n5362# gd 0.24224f
C2369 a_4269_n5362# gd 0.26238f
C2370 a_4053_n5362# gd 1.33771f
C2371 a_3583_n5362# gd 0.0765f
C2372 a_39218_n5509# gd 0.72616f
C2373 a_34662_n5509# gd 0.48537f
C2374 a_30922_n5509# gd 1.80009f
C2375 a_27182_n5509# gd 0.65063f
C2376 a_23442_n5509# gd 0.96357f
C2377 a_14717_n4830# gd 4.00657f
C2378 a_5000_n4888# gd 2.25609f
C2379 a_4784_n4888# gd 0.06306f
C2380 a_4314_n4888# gd 1.39761f
C2381 a_3850_n4888# gd 2.25871f
C2382 a_3634_n4888# gd 2.35931f
C2383 a_3418_n4888# gd 1.56509f
C2384 vco_core_3_0.vco_delay_cell_3_7.out gd 2.40412f
C2385 vco_core_3_0.vco_delay_cell_3_7.in gd 0.15647f
C2386 vco_core_3_0.nen5 gd 3.45146f
C2387 a_39218_n4047# gd 1.28635f
C2388 a_34662_n4047# gd 1.75339f
C2389 a_30922_n4047# gd 0.20132f
C2390 a_27182_n4047# gd 1.01465f
C2391 a_23442_n4047# gd 0.04485f
C2392 a_10673_n3938# gd 0.06311f
C2393 a_10457_n3938# gd 0.07579f
C2394 a_9993_n3938# gd 0.06308f
C2395 a_9777_n3938# gd 0.07671f
C2396 a_11359_n3464# gd 0.3371f
C2397 a_11143_n3464# gd 0.06146f
C2398 a_10927_n3464# gd 0.34624f
C2399 a_10463_n3464# gd 0.07626f
C2400 a_9993_n3464# gd 0.06306f
C2401 a_9777_n3464# gd 0.0767f
C2402 a_4427_n3392# gd 0.06305f
C2403 a_4211_n3392# gd 0.07669f
C2404 a_3747_n3392# gd 0.06307f
C2405 a_3531_n3392# gd 0.0767f
C2406 a_4427_n3074# gd 0.06305f
C2407 a_4211_n3074# gd 0.07669f
C2408 a_3747_n3074# gd 0.06307f
C2409 a_3531_n3074# gd 0.78189f
C2410 0_buf_0.out gd 11.5325f
C2411 vco_passgate_1.en gd 0.4104f
C2412 a_42501_n2486# gd 0.02759f
C2413 a_41821_n2486# gd 0.23024f
C2414 a_41209_n2486# gd 0.35906f
C2415 a_10954_n1982# gd 0.0602f
C2416 a_10738_n1982# gd 0.07673f
C2417 a_10253_n1982# gd 0.07626f
C2418 a_9777_n1982# gd 0.07852f
C2419 a_42501_n2018# gd 0.1558f
C2420 a_41821_n2018# gd 2.63836f
C2421 a_41209_n2018# gd 0.14461f
C2422 a_4427_n1748# gd 0.06305f
C2423 a_4211_n1748# gd 0.07669f
C2424 a_3747_n1748# gd 0.06307f
C2425 a_3531_n1748# gd 1.45695f
C2426 VCO_MUX_0.passgate_scaled_1.en_ gd 1.49514f
C2427 0_buf_1.out gd 7.2509f
C2428 a_4427_n1430# gd 0.06305f
C2429 a_4211_n1430# gd 0.07669f
C2430 a_3747_n1430# gd 0.85024f
C2431 a_3531_n1430# gd 0.86388f
C2432 a_42467_n914# gd 0.55077f
C2433 a_41855_n914# gd 0.4974f
C2434 VCO_decoder_cells_0.VCO3_selection_0.inverter_dek_1.in gd 1.72852f
C2435 a_11327_n902# gd 2.66872f
C2436 a_11111_n902# gd 1.39292f
C2437 a_10630_n902# gd 0.18637f
C2438 a_10160_n902# gd 0.06306f
C2439 a_9944_n902# gd 0.0767f
C2440 VCO_MUX_0.VCO_in gd 5.55242f
C2441 a_44680_n1157# gd 0.05071f
C2442 vco_core_0_0.vco_delay_cell_0$1_1.in gd 0.33012f
C2443 a_11526_n428# gd 0.52622f
C2444 a_11310_n428# gd 0.37777f
C2445 a_11094_n428# gd 0.0741f
C2446 a_10630_n428# gd 0.07626f
C2447 a_10160_n428# gd 0.06306f
C2448 a_9944_n428# gd 0.0767f
C2449 a_3300_n350# gd 0.29908f
C2450 a_3084_n350# gd 0.06059f
C2451 a_42467_n486# gd 0.01002f
C2452 a_41855_n486# gd 0.34719f
C2453 VCO_decoder_cells_0.VCO3_selection_0.NAND_4in_dek_1.a gd 0.14426f
C2454 a_4246_154# gd 0.56841f
C2455 VCO_decoder_cells_0.row_section_decoding_0.NAND_3in_dek_0.c gd 0.56078f
C2456 a_11526_1054# gd 0.48347f
C2457 a_11310_1054# gd 0.80738f
C2458 a_11094_1054# gd 0.42943f
C2459 a_10630_1054# gd 0.07626f
C2460 a_10160_1054# gd 0.06306f
C2461 a_9944_1054# gd 0.0767f
C2462 a_4246_1132# gd 0.3008f
C2463 a_41752_1356# gd 0.23625f
C2464 a_38352_1356# gd 0.53649f
C2465 a_36108_1356# gd 1.16241f
C2466 a_11310_1528# gd 0.07841f
C2467 a_10840_1528# gd 0.71419f
C2468 a_10624_1528# gd 0.07577f
C2469 a_10160_1528# gd 0.06307f
C2470 a_9944_1528# gd 0.0767f
C2471 vco_core_1_0.vco_delay_cell_1$1_4.in gd 0.50245f
C2472 vco_core_1_0.vco_delay_cell_1$1_3.out gd 0.61621f
C2473 a_41750_1826# gd 0.27541f
C2474 a_40662_1826# gd 0.39714f
C2475 a_39506_1826# gd 0.66529f
C2476 a_38350_1826# gd 0.16284f
C2477 a_37194_1826# gd 8.22599f
C2478 a_36106_1826# gd 1.70453f
C2479 a_4506_2110# gd 0.01383f
C2480 a_42226_2990# gd 0.92737f
C2481 a_40662_2990# gd 0.42233f
C2482 a_39506_2990# gd 0.38939f
C2483 a_38350_2990# gd 0.78852f
C2484 a_37194_2990# gd 0.70982f
C2485 VCO_MUX_0.VCO2_in gd 6.16935f
C2486 VCO_decoder_cells_0.VCO3_selection_0.inverter_dek_0.out gd 1.03325f
C2487 a_11106_3010# gd 0.07964f
C2488 a_10630_3010# gd 0.07869f
C2489 a_10160_3010# gd 0.06549f
C2490 a_9944_3010# gd 0.07912f
C2491 a_44964_2717# gd 0.03629f
C2492 vco_core_1_0.vco_delay_cell_1$1_0.in gd 0.56192f
C2493 vco_core_1_0.vco_delay_cell_1$1_6.out gd 2.73595f
C2494 inverter_x1_12.IN gd 6.33527f
C2495 a_31345_3300# gd 6.34007f
C2496 VCO_decoder_cells_0.VCO2_11_sel gd 1.4825f
C2497 vco_core_1_0.out gd 0.24828f
C2498 a_42228_3420# gd 0.25889f
C2499 a_40664_3420# gd 0.22876f
C2500 a_39508_3420# gd 0.31634f
C2501 a_37196_3420# gd 0.24323f
C2502 a_34661_4818# gd 0.81598f
C2503 vco_core_2_0.vco_delay_cell_2$6_0.out gd 1.63444f
C2504 vco_core_2_0.vco_delay_cell_2$6_2.in gd 0.79314f
C2505 vco_core_2_0.vco_delay_cell_2$6_6.out gd 1.31829f
C2506 a_41461_6360# gd 0.85716f
C2507 a_40101_6360# gd 0.75576f
C2508 a_38741_6360# gd 12.3432f
C2509 a_37381_6360# gd 0.95893f
C2510 a_36021_6360# gd 0.96544f
C2511 a_34661_6360# gd 1.5021f
C2512 VCO_MUX_0.VCO3_in gd 8.62498f
C2513 a_42005_7152# gd 1.27328f
C2514 a_40101_7152# gd 1.00536f
C2515 a_38741_7152# gd 0.74738f
C2516 a_37381_7152# gd 0.44992f
C2517 a_36021_7152# gd 0.13839f
C2518 a_29701_7737# gd 0.77896f
C2519 vco_core_2_0.vco_delay_cell_2$6_9.out gd 3.93283f
C2520 vco_core_2_0.vco_delay_cell_2$6_5.in gd 0.28413f
C2521 vco_core_2_0.nen5 gd 0.25363f
C2522 a_42005_8614# gd 0.01345f
C2523 a_38741_8614# gd 1.48045f
C2524 a_37381_8614# gd 0.39849f
C2525 a_36021_8614# gd 0.5742f
C2526 vco_passgate_0.OI gd 26.42585f
C2527 vco_passgate_1.OI gd 12.49804f
C2528 vco_core_0_0.vp gd 10.62138f
C2529 vco_passgate_3.OI gd 2.98384f
C2530 vco_passgate_4.OI gd 11.00551f
.ends
