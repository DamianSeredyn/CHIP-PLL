* Extracted by KLayout with SG13G2 LVS runset on : 18/03/2026 18:16

* cell inv_test
* pin GND
* pin OUT
* pin IN
* pin VP
.SUBCKT inv_test GND OUT IN VP
* device instance $1 r0 *1 2.545,-1.885 sg13_lv_nmos
M$1 GND IN OUT \$1 sg13_lv_nmos L=0.13u W=0.16u AS=0.1012p AD=0.1012p PS=1.34u
+ PD=1.34u
* device instance $2 r0 *1 2.545,-0.44 sg13_lv_pmos
M$2 VP IN OUT \$6 sg13_lv_pmos L=0.13u W=0.16u AS=0.1012p AD=0.1012p PS=1.34u
+ PD=1.34u
.ENDS inv_test
