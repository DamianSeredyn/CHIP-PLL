* Extracted by KLayout with SG13G2 LVS runset on : 19/03/2026 12:15

* cell INV_TEST
* pin GND
* pin OUT
* pin IN
* pin VP
.SUBCKT INV_TEST GND OUT IN VP
* device instance $1 r0 *1 -0.16,-1.88 sg13_lv_nmos
M$1 GND IN OUT \$1 sg13_lv_nmos L=0.13u W=0.15u AS=0.1005p AD=0.1005p PS=1.34u
+ PD=1.34u
* device instance $2 r0 *1 -0.16,-0.465 sg13_lv_pmos
M$2 VP IN OUT \$2 sg13_lv_pmos L=0.13u W=0.15u AS=0.1005p AD=0.1005p PS=1.34u
+ PD=1.34u
* device instance $3 r0 *1 -0.14,0.77 ntap1
R$3 \$2 VP ntap1 A=0.6084p P=3.12u
* device instance $4 r0 *1 -0.385,-2.76 ptap1
R$4 \$1 GND ptap1 A=0.6084p P=3.12u
.ENDS INV_TEST
