.lib /foss/pdks/ihp-sg13g2/libs.tech/ngspice/models/cornerMOSlv.lib mos_ff
.param vdd=1.2
.temp 27
.include /foss/designs/CHIP-PLL/simulations/pvt_tmp/vco_tb_clean.spice
.control
  tran 20p 20n
  wrdata /foss/designs/CHIP-PLL/simulations/pvt_results/ff_1.2V_27C.dat v(out_pb)
  exit
.endc
